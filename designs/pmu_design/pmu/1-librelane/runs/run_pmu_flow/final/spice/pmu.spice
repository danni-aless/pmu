* NGSPICE file created from pmu.ext - technology: sky130A

* Black-box entry subcircuit for sky130_fd_sc_hd__fill_2 abstract view
.subckt sky130_fd_sc_hd__fill_2 VGND VNB VPB VPWR
.ends

* Black-box entry subcircuit for sky130_fd_sc_hd__decap_3 abstract view
.subckt sky130_fd_sc_hd__decap_3 VGND VNB VPB VPWR
.ends

* Black-box entry subcircuit for sky130_fd_sc_hd__tapvpwrvgnd_1 abstract view
.subckt sky130_fd_sc_hd__tapvpwrvgnd_1 VGND VPWR
.ends

* Black-box entry subcircuit for sky130_fd_sc_hd__buf_1 abstract view
.subckt sky130_fd_sc_hd__buf_1 A VGND VNB VPB VPWR X
.ends

* Black-box entry subcircuit for sky130_fd_sc_hd__fill_1 abstract view
.subckt sky130_fd_sc_hd__fill_1 VGND VNB VPB VPWR
.ends

* Black-box entry subcircuit for sky130_fd_sc_hd__clkbuf_4 abstract view
.subckt sky130_fd_sc_hd__clkbuf_4 A VGND VNB VPB VPWR X
.ends

* Black-box entry subcircuit for sky130_fd_sc_hd__dfrtp_2 abstract view
.subckt sky130_fd_sc_hd__dfrtp_2 CLK D RESET_B VGND VNB VPB VPWR Q
.ends

* Black-box entry subcircuit for sky130_fd_sc_hd__clkbuf_16 abstract view
.subckt sky130_fd_sc_hd__clkbuf_16 A VGND VNB VPB VPWR X
.ends

* Black-box entry subcircuit for sky130_fd_sc_hd__buf_2 abstract view
.subckt sky130_fd_sc_hd__buf_2 A VGND VNB VPB VPWR X
.ends

* Black-box entry subcircuit for sky130_fd_sc_hd__inv_2 abstract view
.subckt sky130_fd_sc_hd__inv_2 A VGND VNB VPB VPWR Y
.ends

* Black-box entry subcircuit for sky130_fd_sc_hd__mux4_1 abstract view
.subckt sky130_fd_sc_hd__mux4_1 A0 A1 A2 A3 S0 S1 VGND VNB VPB VPWR X
.ends

* Black-box entry subcircuit for sky130_fd_sc_hd__o21a_2 abstract view
.subckt sky130_fd_sc_hd__o21a_2 A1 A2 B1 VGND VNB VPB VPWR X
.ends

* Black-box entry subcircuit for sky130_fd_sc_hd__a221o_2 abstract view
.subckt sky130_fd_sc_hd__a221o_2 A1 A2 B1 B2 C1 VGND VNB VPB VPWR X
.ends

* Black-box entry subcircuit for sky130_fd_sc_hd__mux2_1 abstract view
.subckt sky130_fd_sc_hd__mux2_1 A0 A1 S VGND VNB VPB VPWR X
.ends

* Black-box entry subcircuit for sky130_fd_sc_hd__o21ba_2 abstract view
.subckt sky130_fd_sc_hd__o21ba_2 A1 A2 B1_N VGND VNB VPB VPWR X
.ends

* Black-box entry subcircuit for sky130_fd_sc_hd__nand2b_2 abstract view
.subckt sky130_fd_sc_hd__nand2b_2 A_N B VGND VNB VPB VPWR Y
.ends

* Black-box entry subcircuit for sky130_fd_sc_hd__mux4_2 abstract view
.subckt sky130_fd_sc_hd__mux4_2 A0 A1 A2 A3 S0 S1 VGND VNB VPB VPWR X
.ends

* Black-box entry subcircuit for sky130_fd_sc_hd__xor2_2 abstract view
.subckt sky130_fd_sc_hd__xor2_2 A B VGND VNB VPB VPWR X
.ends

.subckt pmu VGND VPWR clk delay_sel[0] delay_sel[1] delay_sel[2] path[0] path[1] path[2]
+ path[3] path[4] path[5] path[6] path[7] path_sel[0] path_sel[1] path_sel[2] rst
+ se tdi tdo
XFILLER_3_34 VGND VGND VPWR VPWR sky130_fd_sc_hd__fill_2
XFILLER_7_7 VGND VGND VPWR VPWR sky130_fd_sc_hd__fill_2
XPHY_EDGE_ROW_0_Left_12 VGND VGND VPWR VPWR sky130_fd_sc_hd__decap_3
XTAP_TAPCELL_ROW_8_33 VGND VPWR sky130_fd_sc_hd__tapvpwrvgnd_1
Xdc_inst.x4.x10 dc_inst.x4.net10 VGND VGND VPWR VPWR dc_inst.x4.net1 sky130_fd_sc_hd__buf_1
XFILLER_0_57 VGND VGND VPWR VPWR sky130_fd_sc_hd__decap_3
Xdc_inst.x1.x13 dc_inst.x1.net12 VGND VGND VPWR VPWR dc_inst.x1.net13 sky130_fd_sc_hd__buf_1
Xdc_inst.x6.x8 dc_inst.x6.net8 VGND VGND VPWR VPWR dc_inst.x6.net9 sky130_fd_sc_hd__buf_1
Xdc_inst.x3.x9 dc_inst.x3.net9 VGND VGND VPWR VPWR dc_inst.x3.net10 sky130_fd_sc_hd__buf_1
XFILLER_3_57 VGND VGND VPWR VPWR sky130_fd_sc_hd__fill_2
XFILLER_3_68 VGND VGND VPWR VPWR sky130_fd_sc_hd__fill_2
Xdc_inst.x1.x14 dc_inst.x1.net13 VGND VGND VPWR VPWR dc_inst.x1.net14 sky130_fd_sc_hd__buf_1
Xdc_inst.x4.x11 dc_inst.x4.net1 VGND VGND VPWR VPWR dc_inst.x4.net11 sky130_fd_sc_hd__buf_1
XFILLER_0_69 VGND VGND VPWR VPWR sky130_fd_sc_hd__fill_1
XFILLER_9_23 VGND VGND VPWR VPWR sky130_fd_sc_hd__fill_1
Xdc_inst.x6.x9 dc_inst.x6.net9 VGND VGND VPWR VPWR dc_inst.x6.net10 sky130_fd_sc_hd__buf_1
XFILLER_6_35 VGND VGND VPWR VPWR sky130_fd_sc_hd__decap_3
XPHY_EDGE_ROW_6_Right_6 VGND VGND VPWR VPWR sky130_fd_sc_hd__decap_3
Xdc_inst.x7.x20 dc_inst.x7.net19 VGND VGND VPWR VPWR dc_inst.net7 sky130_fd_sc_hd__buf_1
Xdc_inst.x4.x12 dc_inst.x4.net11 VGND VGND VPWR VPWR dc_inst.x4.net12 sky130_fd_sc_hd__buf_1
Xdc_inst.x1.x15 dc_inst.x1.net14 VGND VGND VPWR VPWR dc_inst.x1.net15 sky130_fd_sc_hd__buf_1
Xdc_inst.x7.x10 dc_inst.x7.net10 VGND VGND VPWR VPWR dc_inst.x7.net1 sky130_fd_sc_hd__buf_1
XFILLER_3_48 VGND VGND VPWR VPWR sky130_fd_sc_hd__fill_2
Xdc_inst.x1.x16 dc_inst.x1.net15 VGND VGND VPWR VPWR dc_inst.x1.net16 sky130_fd_sc_hd__buf_1
Xdc_inst.x4.x13 dc_inst.x4.net12 VGND VGND VPWR VPWR dc_inst.x4.net13 sky130_fd_sc_hd__buf_1
XFILLER_9_69 VGND VGND VPWR VPWR sky130_fd_sc_hd__fill_1
XPHY_EDGE_ROW_4_Left_16 VGND VGND VPWR VPWR sky130_fd_sc_hd__decap_3
XFILLER_6_48 VGND VGND VPWR VPWR sky130_fd_sc_hd__fill_1
XTAP_TAPCELL_ROW_2_27 VGND VPWR sky130_fd_sc_hd__tapvpwrvgnd_1
XFILLER_11_3 VGND VGND VPWR VPWR sky130_fd_sc_hd__fill_2
Xdc_inst.x7.x11 dc_inst.x7.net1 VGND VGND VPWR VPWR dc_inst.x7.net11 sky130_fd_sc_hd__buf_1
Xdc_inst.x4.x14 dc_inst.x4.net13 VGND VGND VPWR VPWR dc_inst.x4.net14 sky130_fd_sc_hd__buf_1
XFILLER_9_48 VGND VGND VPWR VPWR sky130_fd_sc_hd__fill_2
Xdc_inst.x1.x1 dc_inst.in VGND VGND VPWR VPWR dc_inst.x1.net2 sky130_fd_sc_hd__buf_1
Xdc_inst.x1.x17 dc_inst.x1.net16 VGND VGND VPWR VPWR dc_inst.x1.net17 sky130_fd_sc_hd__buf_1
XFILLER_1_60 VGND VGND VPWR VPWR sky130_fd_sc_hd__fill_2
Xclkload0 clknet_1_1__leaf_clk VGND VGND VPWR VPWR clkload0/X sky130_fd_sc_hd__clkbuf_4
XFILLER_6_27 VGND VGND VPWR VPWR sky130_fd_sc_hd__fill_1
Xdc_inst.x7.x12 dc_inst.x7.net11 VGND VGND VPWR VPWR dc_inst.x7.net12 sky130_fd_sc_hd__buf_1
XFILLER_3_39 VGND VGND VPWR VPWR sky130_fd_sc_hd__fill_1
Xdc_inst.x1.x18 dc_inst.x1.net17 VGND VGND VPWR VPWR dc_inst.x1.net18 sky130_fd_sc_hd__buf_1
Xdc_inst.x4.x15 dc_inst.x4.net14 VGND VGND VPWR VPWR dc_inst.x4.net15 sky130_fd_sc_hd__buf_1
Xdc_inst.x4.x1 dc_inst.net3 VGND VGND VPWR VPWR dc_inst.x4.net2 sky130_fd_sc_hd__buf_1
XFILLER_1_3 VGND VGND VPWR VPWR sky130_fd_sc_hd__fill_2
Xdc_inst.x1.x2 dc_inst.x1.net2 VGND VGND VPWR VPWR dc_inst.x1.net3 sky130_fd_sc_hd__buf_1
Xdc_inst.x7.x1 dc_inst.net6 VGND VGND VPWR VPWR dc_inst.x7.net2 sky130_fd_sc_hd__buf_1
Xdc_inst.x7.x13 dc_inst.x7.net12 VGND VGND VPWR VPWR dc_inst.x7.net13 sky130_fd_sc_hd__buf_1
Xdc_inst.x4.x2 dc_inst.x4.net2 VGND VGND VPWR VPWR dc_inst.x4.net3 sky130_fd_sc_hd__buf_1
Xdc_inst.x4.x16 dc_inst.x4.net15 VGND VGND VPWR VPWR dc_inst.x4.net16 sky130_fd_sc_hd__buf_1
Xdc_inst.x1.x19 dc_inst.x1.net18 VGND VGND VPWR VPWR dc_inst.x1.net19 sky130_fd_sc_hd__buf_1
Xdc_inst.x1.x3 dc_inst.x1.net3 VGND VGND VPWR VPWR dc_inst.x1.net4 sky130_fd_sc_hd__buf_1
Xdc_inst.x7.x2 dc_inst.x7.net2 VGND VGND VPWR VPWR dc_inst.x7.net3 sky130_fd_sc_hd__buf_1
XPHY_EDGE_ROW_1_Right_1 VGND VGND VPWR VPWR sky130_fd_sc_hd__decap_3
Xdc_inst.x7.x14 dc_inst.x7.net13 VGND VGND VPWR VPWR dc_inst.x7.net14 sky130_fd_sc_hd__buf_1
Xdc_inst.x4.x3 dc_inst.x4.net3 VGND VGND VPWR VPWR dc_inst.x4.net4 sky130_fd_sc_hd__buf_1
Xdc_inst.x4.x17 dc_inst.x4.net16 VGND VGND VPWR VPWR dc_inst.x4.net17 sky130_fd_sc_hd__buf_1
Xdc_inst.x1.x4 dc_inst.x1.net4 VGND VGND VPWR VPWR dc_inst.x1.net5 sky130_fd_sc_hd__buf_1
XPHY_EDGE_ROW_11_Left_23 VGND VGND VPWR VPWR sky130_fd_sc_hd__decap_3
X_25_ clknet_1_0__leaf_clk _00_ _03_ VGND VGND VPWR VPWR tdo sky130_fd_sc_hd__dfrtp_2
Xdc_inst.x7.x3 dc_inst.x7.net3 VGND VGND VPWR VPWR dc_inst.x7.net4 sky130_fd_sc_hd__buf_1
Xclkbuf_0_clk clk VGND VGND VPWR VPWR clknet_0_clk sky130_fd_sc_hd__clkbuf_16
Xdc_inst.x7.x15 dc_inst.x7.net14 VGND VGND VPWR VPWR dc_inst.x7.net15 sky130_fd_sc_hd__buf_1
Xdc_inst.x4.x4 dc_inst.x4.net4 VGND VGND VPWR VPWR dc_inst.x4.net5 sky130_fd_sc_hd__buf_1
XFILLER_3_9 VGND VGND VPWR VPWR sky130_fd_sc_hd__fill_1
Xdc_inst.x1.x5 dc_inst.x1.net5 VGND VGND VPWR VPWR dc_inst.x1.net6 sky130_fd_sc_hd__buf_1
Xdc_inst.x4.x18 dc_inst.x4.net17 VGND VGND VPWR VPWR dc_inst.x4.net18 sky130_fd_sc_hd__buf_1
X_24_ clknet_1_1__leaf_clk capture_d _02_ VGND VGND VPWR VPWR capture_q sky130_fd_sc_hd__dfrtp_2
Xdc_inst.x7.x4 dc_inst.x7.net4 VGND VGND VPWR VPWR dc_inst.x7.net5 sky130_fd_sc_hd__buf_1
Xdc_inst.x7.x16 dc_inst.x7.net15 VGND VGND VPWR VPWR dc_inst.x7.net16 sky130_fd_sc_hd__buf_1
Xdc_inst.x4.x5 dc_inst.x4.net5 VGND VGND VPWR VPWR dc_inst.x4.net6 sky130_fd_sc_hd__buf_1
Xdc_inst.x4.x19 dc_inst.x4.net18 VGND VGND VPWR VPWR dc_inst.x4.net19 sky130_fd_sc_hd__buf_1
Xdc_inst.x1.x6 dc_inst.x1.net6 VGND VGND VPWR VPWR dc_inst.x1.net7 sky130_fd_sc_hd__buf_1
XTAP_TAPCELL_ROW_6_31 VGND VPWR sky130_fd_sc_hd__tapvpwrvgnd_1
X_23_ clknet_1_0__leaf_clk dc_inst.in _01_ VGND VGND VPWR VPWR shadow_q sky130_fd_sc_hd__dfrtp_2
Xdc_inst.x7.x5 dc_inst.x7.net5 VGND VGND VPWR VPWR dc_inst.x7.net6 sky130_fd_sc_hd__buf_1
XPHY_EDGE_ROW_5_Right_5 VGND VGND VPWR VPWR sky130_fd_sc_hd__decap_3
Xdc_inst.x7.x17 dc_inst.x7.net16 VGND VGND VPWR VPWR dc_inst.x7.net17 sky130_fd_sc_hd__buf_1
Xdc_inst.x4.x6 dc_inst.x4.net6 VGND VGND VPWR VPWR dc_inst.x4.net7 sky130_fd_sc_hd__buf_1
Xdc_inst.x1.x7 dc_inst.x1.net7 VGND VGND VPWR VPWR dc_inst.x1.net8 sky130_fd_sc_hd__buf_1
Xdc_inst.x3.x20 dc_inst.x3.net19 VGND VGND VPWR VPWR dc_inst.net3 sky130_fd_sc_hd__buf_2
XFILLER_1_11 VGND VGND VPWR VPWR sky130_fd_sc_hd__fill_2
X_22_ rst VGND VGND VPWR VPWR _03_ sky130_fd_sc_hd__inv_2
Xdc_inst.x7.x6 dc_inst.x7.net6 VGND VGND VPWR VPWR dc_inst.x7.net7 sky130_fd_sc_hd__buf_1
XPHY_EDGE_ROW_11_Right_11 VGND VGND VPWR VPWR sky130_fd_sc_hd__decap_3
Xdc_inst.x3.x10 dc_inst.x3.net10 VGND VGND VPWR VPWR dc_inst.x3.net1 sky130_fd_sc_hd__buf_1
Xdc_inst.x7.x18 dc_inst.x7.net17 VGND VGND VPWR VPWR dc_inst.x7.net18 sky130_fd_sc_hd__buf_1
Xdc_inst.x4.x7 dc_inst.x4.net7 VGND VGND VPWR VPWR dc_inst.x4.net8 sky130_fd_sc_hd__buf_1
Xdc_inst.x1.x8 dc_inst.x1.net8 VGND VGND VPWR VPWR dc_inst.x1.net9 sky130_fd_sc_hd__buf_1
Xdc_inst.x8 dc_inst.in dc_inst.net1 dc_inst.net2 dc_inst.net3 delay_sel[0] delay_sel[1]
+ VGND VGND VPWR VPWR dc_inst.net8 sky130_fd_sc_hd__mux4_1
XFILLER_1_34 VGND VGND VPWR VPWR sky130_fd_sc_hd__fill_1
XPHY_EDGE_ROW_3_Left_15 VGND VGND VPWR VPWR sky130_fd_sc_hd__decap_3
X_21_ rst VGND VGND VPWR VPWR _02_ sky130_fd_sc_hd__inv_2
Xdc_inst.x7.x7 dc_inst.x7.net7 VGND VGND VPWR VPWR dc_inst.x7.net8 sky130_fd_sc_hd__buf_1
XFILLER_7_55 VGND VGND VPWR VPWR sky130_fd_sc_hd__fill_1
Xdc_inst.x7.x19 dc_inst.x7.net18 VGND VGND VPWR VPWR dc_inst.x7.net19 sky130_fd_sc_hd__buf_1
Xdc_inst.x4.x8 dc_inst.x4.net8 VGND VGND VPWR VPWR dc_inst.x4.net9 sky130_fd_sc_hd__buf_1
Xdc_inst.x3.x11 dc_inst.x3.net1 VGND VGND VPWR VPWR dc_inst.x3.net11 sky130_fd_sc_hd__buf_1
XFILLER_8_3 VGND VGND VPWR VPWR sky130_fd_sc_hd__fill_1
XTAP_TAPCELL_ROW_0_24 VGND VPWR sky130_fd_sc_hd__tapvpwrvgnd_1
Xdc_inst.x1.x9 dc_inst.x1.net9 VGND VGND VPWR VPWR dc_inst.x1.net10 sky130_fd_sc_hd__buf_1
Xdc_inst.x9 dc_inst.net4 dc_inst.net5 dc_inst.net6 dc_inst.net7 delay_sel[0] delay_sel[1]
+ VGND VGND VPWR VPWR dc_inst.net9 sky130_fd_sc_hd__mux4_1
XFILLER_1_57 VGND VGND VPWR VPWR sky130_fd_sc_hd__decap_3
X_20_ _04_ _06_ _10_ VGND VGND VPWR VPWR dc_inst.in sky130_fd_sc_hd__o21a_2
Xdc_inst.x7.x8 dc_inst.x7.net8 VGND VGND VPWR VPWR dc_inst.x7.net9 sky130_fd_sc_hd__buf_1
XPHY_EDGE_ROW_9_Right_9 VGND VGND VPWR VPWR sky130_fd_sc_hd__decap_3
Xdc_inst.x3.x12 dc_inst.x3.net11 VGND VGND VPWR VPWR dc_inst.x3.net12 sky130_fd_sc_hd__buf_1
Xdc_inst.x6.x20 dc_inst.x6.net19 VGND VGND VPWR VPWR dc_inst.net6 sky130_fd_sc_hd__buf_2
Xdc_inst.x4.x9 dc_inst.x4.net9 VGND VGND VPWR VPWR dc_inst.x4.net10 sky130_fd_sc_hd__buf_1
XTAP_TAPCELL_ROW_0_25 VGND VPWR sky130_fd_sc_hd__tapvpwrvgnd_1
XTAP_TAPCELL_ROW_9_34 VGND VPWR sky130_fd_sc_hd__tapvpwrvgnd_1
Xdc_inst.x7.x9 dc_inst.x7.net9 VGND VGND VPWR VPWR dc_inst.x7.net10 sky130_fd_sc_hd__buf_1
Xdc_inst.x3.x13 dc_inst.x3.net12 VGND VGND VPWR VPWR dc_inst.x3.net13 sky130_fd_sc_hd__buf_1
Xdc_inst.x6.x10 dc_inst.x6.net10 VGND VGND VPWR VPWR dc_inst.x6.net1 sky130_fd_sc_hd__buf_1
XFILLER_4_69 VGND VGND VPWR VPWR sky130_fd_sc_hd__fill_1
XPHY_EDGE_ROW_7_Left_19 VGND VGND VPWR VPWR sky130_fd_sc_hd__decap_3
XTAP_TAPCELL_ROW_10_35 VGND VPWR sky130_fd_sc_hd__tapvpwrvgnd_1
XFILLER_7_69 VGND VGND VPWR VPWR sky130_fd_sc_hd__fill_1
XPHY_EDGE_ROW_0_Right_0 VGND VGND VPWR VPWR sky130_fd_sc_hd__decap_3
Xdc_inst.x6.x11 dc_inst.x6.net1 VGND VGND VPWR VPWR dc_inst.x6.net11 sky130_fd_sc_hd__buf_1
XFILLER_4_37 VGND VGND VPWR VPWR sky130_fd_sc_hd__fill_2
Xdc_inst.x3.x14 dc_inst.x3.net13 VGND VGND VPWR VPWR dc_inst.x3.net14 sky130_fd_sc_hd__buf_1
XFILLER_6_3 VGND VGND VPWR VPWR sky130_fd_sc_hd__fill_1
XFILLER_10_69 VGND VGND VPWR VPWR sky130_fd_sc_hd__fill_1
XPHY_EDGE_ROW_10_Left_22 VGND VGND VPWR VPWR sky130_fd_sc_hd__decap_3
Xdc_inst.x6.x12 dc_inst.x6.net11 VGND VGND VPWR VPWR dc_inst.x6.net12 sky130_fd_sc_hd__buf_1
Xdc_inst.x3.x15 dc_inst.x3.net14 VGND VGND VPWR VPWR dc_inst.x3.net15 sky130_fd_sc_hd__buf_1
Xdc_inst.x2.x1 dc_inst.net1 VGND VGND VPWR VPWR dc_inst.x2.net2 sky130_fd_sc_hd__buf_1
XTAP_TAPCELL_ROW_3_28 VGND VPWR sky130_fd_sc_hd__tapvpwrvgnd_1
Xdc_inst.x6.x13 dc_inst.x6.net12 VGND VGND VPWR VPWR dc_inst.x6.net13 sky130_fd_sc_hd__buf_1
Xdc_inst.x5.x1 dc_inst.net4 VGND VGND VPWR VPWR dc_inst.x5.net2 sky130_fd_sc_hd__buf_1
Xdc_inst.x3.x16 dc_inst.x3.net15 VGND VGND VPWR VPWR dc_inst.x3.net16 sky130_fd_sc_hd__buf_1
Xdc_inst.x2.x2 dc_inst.x2.net2 VGND VGND VPWR VPWR dc_inst.x2.net3 sky130_fd_sc_hd__buf_1
XPHY_EDGE_ROW_4_Right_4 VGND VGND VPWR VPWR sky130_fd_sc_hd__decap_3
Xdc_inst.x6.x14 dc_inst.x6.net13 VGND VGND VPWR VPWR dc_inst.x6.net14 sky130_fd_sc_hd__buf_1
Xdc_inst.x3.x17 dc_inst.x3.net16 VGND VGND VPWR VPWR dc_inst.x3.net17 sky130_fd_sc_hd__buf_1
XFILLER_4_18 VGND VGND VPWR VPWR sky130_fd_sc_hd__fill_1
XFILLER_4_29 VGND VGND VPWR VPWR sky130_fd_sc_hd__fill_1
Xdc_inst.x5.x2 dc_inst.x5.net2 VGND VGND VPWR VPWR dc_inst.x5.net3 sky130_fd_sc_hd__buf_1
XFILLER_4_3 VGND VGND VPWR VPWR sky130_fd_sc_hd__fill_1
Xdc_inst.x2.x3 dc_inst.x2.net3 VGND VGND VPWR VPWR dc_inst.x2.net4 sky130_fd_sc_hd__buf_1
Xdc_inst.x6.x15 dc_inst.x6.net14 VGND VGND VPWR VPWR dc_inst.x6.net15 sky130_fd_sc_hd__buf_1
Xdc_inst.x5.x3 dc_inst.x5.net3 VGND VGND VPWR VPWR dc_inst.x5.net4 sky130_fd_sc_hd__buf_1
Xdc_inst.x3.x18 dc_inst.x3.net17 VGND VGND VPWR VPWR dc_inst.x3.net18 sky130_fd_sc_hd__buf_1
Xdc_inst.x2.x4 dc_inst.x2.net4 VGND VGND VPWR VPWR dc_inst.x2.net5 sky130_fd_sc_hd__buf_1
XPHY_EDGE_ROW_2_Left_14 VGND VGND VPWR VPWR sky130_fd_sc_hd__decap_3
Xclkbuf_1_0__f_clk clknet_0_clk VGND VGND VPWR VPWR clknet_1_0__leaf_clk sky130_fd_sc_hd__clkbuf_16
Xdc_inst.x6.x16 dc_inst.x6.net15 VGND VGND VPWR VPWR dc_inst.x6.net16 sky130_fd_sc_hd__buf_1
Xdc_inst.x3.x19 dc_inst.x3.net18 VGND VGND VPWR VPWR dc_inst.x3.net19 sky130_fd_sc_hd__buf_1
Xdc_inst.x5.x4 dc_inst.x5.net4 VGND VGND VPWR VPWR dc_inst.x5.net5 sky130_fd_sc_hd__buf_1
Xdc_inst.x2.x5 dc_inst.x2.net5 VGND VGND VPWR VPWR dc_inst.x2.net6 sky130_fd_sc_hd__buf_1
XPHY_EDGE_ROW_10_Right_10 VGND VGND VPWR VPWR sky130_fd_sc_hd__decap_3
Xdc_inst.x6.x17 dc_inst.x6.net16 VGND VGND VPWR VPWR dc_inst.x6.net17 sky130_fd_sc_hd__buf_1
Xdc_inst.x2.x20 dc_inst.x2.net19 VGND VGND VPWR VPWR dc_inst.net2 sky130_fd_sc_hd__buf_2
Xdc_inst.x5.x5 dc_inst.x5.net5 VGND VGND VPWR VPWR dc_inst.x5.net6 sky130_fd_sc_hd__buf_1
XFILLER_5_31 VGND VGND VPWR VPWR sky130_fd_sc_hd__decap_3
XPHY_EDGE_ROW_8_Right_8 VGND VGND VPWR VPWR sky130_fd_sc_hd__decap_3
Xdc_inst.x2.x6 dc_inst.x2.net6 VGND VGND VPWR VPWR dc_inst.x2.net7 sky130_fd_sc_hd__buf_1
XFILLER_2_54 VGND VGND VPWR VPWR sky130_fd_sc_hd__fill_1
XFILLER_2_3 VGND VGND VPWR VPWR sky130_fd_sc_hd__fill_2
Xdc_inst.x6.x18 dc_inst.x6.net17 VGND VGND VPWR VPWR dc_inst.x6.net18 sky130_fd_sc_hd__buf_1
Xdc_inst.x2.x10 dc_inst.x2.net10 VGND VGND VPWR VPWR dc_inst.x2.net1 sky130_fd_sc_hd__buf_1
Xdc_inst.x5.x6 dc_inst.x5.net6 VGND VGND VPWR VPWR dc_inst.x5.net7 sky130_fd_sc_hd__buf_1
XFILLER_5_43 VGND VGND VPWR VPWR sky130_fd_sc_hd__fill_2
Xdc_inst.x2.x7 dc_inst.x2.net7 VGND VGND VPWR VPWR dc_inst.x2.net8 sky130_fd_sc_hd__buf_1
XFILLER_2_44 VGND VGND VPWR VPWR sky130_fd_sc_hd__fill_1
XFILLER_4_7 VGND VGND VPWR VPWR sky130_fd_sc_hd__fill_2
XPHY_EDGE_ROW_6_Left_18 VGND VGND VPWR VPWR sky130_fd_sc_hd__decap_3
XTAP_TAPCELL_ROW_7_32 VGND VPWR sky130_fd_sc_hd__tapvpwrvgnd_1
Xdc_inst.x6.x19 dc_inst.x6.net18 VGND VGND VPWR VPWR dc_inst.x6.net19 sky130_fd_sc_hd__buf_1
X_19_ _07_ _08_ _09_ path_sel[1] path_sel[2] VGND VGND VPWR VPWR _10_ sky130_fd_sc_hd__a221o_2
Xdc_inst.x2.x11 dc_inst.x2.net1 VGND VGND VPWR VPWR dc_inst.x2.net11 sky130_fd_sc_hd__buf_1
Xdc_inst.x5.x7 dc_inst.x5.net7 VGND VGND VPWR VPWR dc_inst.x5.net8 sky130_fd_sc_hd__buf_1
XFILLER_10_3 VGND VGND VPWR VPWR sky130_fd_sc_hd__fill_1
XPHY_EDGE_ROW_9_Left_21 VGND VGND VPWR VPWR sky130_fd_sc_hd__decap_3
Xdc_inst.x2.x8 dc_inst.x2.net8 VGND VGND VPWR VPWR dc_inst.x2.net9 sky130_fd_sc_hd__buf_1
Xdc_inst.x5.x20 dc_inst.x5.net19 VGND VGND VPWR VPWR dc_inst.net5 sky130_fd_sc_hd__buf_2
XFILLER_8_44 VGND VGND VPWR VPWR sky130_fd_sc_hd__fill_1
X_18_ path[2] path[3] path_sel[0] VGND VGND VPWR VPWR _09_ sky130_fd_sc_hd__mux2_1
Xdc_inst.x2.x12 dc_inst.x2.net11 VGND VGND VPWR VPWR dc_inst.x2.net12 sky130_fd_sc_hd__buf_1
Xdc_inst.x5.x8 dc_inst.x5.net8 VGND VGND VPWR VPWR dc_inst.x5.net9 sky130_fd_sc_hd__buf_1
Xdc_inst.x2.x9 dc_inst.x2.net9 VGND VGND VPWR VPWR dc_inst.x2.net10 sky130_fd_sc_hd__buf_1
XFILLER_2_13 VGND VGND VPWR VPWR sky130_fd_sc_hd__fill_2
XFILLER_2_24 VGND VGND VPWR VPWR sky130_fd_sc_hd__fill_1
X_17_ path[0] path_sel[0] path_sel[1] VGND VGND VPWR VPWR _08_ sky130_fd_sc_hd__o21ba_2
Xdc_inst.x2.x13 dc_inst.x2.net12 VGND VGND VPWR VPWR dc_inst.x2.net13 sky130_fd_sc_hd__buf_1
Xdc_inst.x5.x9 dc_inst.x5.net9 VGND VGND VPWR VPWR dc_inst.x5.net10 sky130_fd_sc_hd__buf_1
Xdc_inst.x5.x10 dc_inst.x5.net10 VGND VGND VPWR VPWR dc_inst.x5.net1 sky130_fd_sc_hd__buf_1
XFILLER_5_57 VGND VGND VPWR VPWR sky130_fd_sc_hd__fill_1
XFILLER_5_68 VGND VGND VPWR VPWR sky130_fd_sc_hd__fill_2
Xdc_inst.x5.x11 dc_inst.x5.net1 VGND VGND VPWR VPWR dc_inst.x5.net11 sky130_fd_sc_hd__buf_1
X_16_ path[1] path_sel[0] VGND VGND VPWR VPWR _07_ sky130_fd_sc_hd__nand2b_2
Xdc_inst.x2.x14 dc_inst.x2.net13 VGND VGND VPWR VPWR dc_inst.x2.net14 sky130_fd_sc_hd__buf_1
XFILLER_5_14 VGND VGND VPWR VPWR sky130_fd_sc_hd__fill_2
XPHY_EDGE_ROW_3_Right_3 VGND VGND VPWR VPWR sky130_fd_sc_hd__decap_3
XTAP_TAPCELL_ROW_1_26 VGND VPWR sky130_fd_sc_hd__tapvpwrvgnd_1
Xclkbuf_1_1__f_clk clknet_0_clk VGND VGND VPWR VPWR clknet_1_1__leaf_clk sky130_fd_sc_hd__clkbuf_16
XFILLER_2_8 VGND VGND VPWR VPWR sky130_fd_sc_hd__fill_2
XFILLER_8_69 VGND VGND VPWR VPWR sky130_fd_sc_hd__fill_1
X_15_ path[4] path[5] path[6] path[7] path_sel[0] path_sel[1] VGND VGND VPWR VPWR
+ _06_ sky130_fd_sc_hd__mux4_2
Xdc_inst.x2.x15 dc_inst.x2.net14 VGND VGND VPWR VPWR dc_inst.x2.net15 sky130_fd_sc_hd__buf_1
Xdc_inst.x5.x12 dc_inst.x5.net11 VGND VGND VPWR VPWR dc_inst.x5.net12 sky130_fd_sc_hd__buf_1
XFILLER_5_48 VGND VGND VPWR VPWR sky130_fd_sc_hd__fill_2
XFILLER_11_69 VGND VGND VPWR VPWR sky130_fd_sc_hd__fill_1
XPHY_EDGE_ROW_1_Left_13 VGND VGND VPWR VPWR sky130_fd_sc_hd__decap_3
XTAP_TAPCELL_ROW_11_36 VGND VPWR sky130_fd_sc_hd__tapvpwrvgnd_1
Xdc_inst.x5.x13 dc_inst.x5.net12 VGND VGND VPWR VPWR dc_inst.x5.net13 sky130_fd_sc_hd__buf_1
X_14_ _05_ tdi se VGND VGND VPWR VPWR _00_ sky130_fd_sc_hd__mux2_1
Xdc_inst.x2.x16 dc_inst.x2.net15 VGND VGND VPWR VPWR dc_inst.x2.net16 sky130_fd_sc_hd__buf_1
XFILLER_0_60 VGND VGND VPWR VPWR sky130_fd_sc_hd__fill_2
XTAP_TAPCELL_ROW_11_37 VGND VPWR sky130_fd_sc_hd__tapvpwrvgnd_1
Xdc_inst.x10 dc_inst.net8 dc_inst.net9 delay_sel[2] VGND VGND VPWR VPWR capture_d
+ sky130_fd_sc_hd__mux2_1
Xdc_inst.x3.x1 dc_inst.net2 VGND VGND VPWR VPWR dc_inst.x3.net2 sky130_fd_sc_hd__buf_1
Xdc_inst.x5.x14 dc_inst.x5.net13 VGND VGND VPWR VPWR dc_inst.x5.net14 sky130_fd_sc_hd__buf_1
X_13_ capture_q shadow_q VGND VGND VPWR VPWR _05_ sky130_fd_sc_hd__xor2_2
Xdc_inst.x2.x17 dc_inst.x2.net16 VGND VGND VPWR VPWR dc_inst.x2.net17 sky130_fd_sc_hd__buf_1
Xdc_inst.x6.x1 dc_inst.net5 VGND VGND VPWR VPWR dc_inst.x6.net2 sky130_fd_sc_hd__buf_1
XPHY_EDGE_ROW_7_Right_7 VGND VGND VPWR VPWR sky130_fd_sc_hd__decap_3
Xdc_inst.x3.x2 dc_inst.x3.net2 VGND VGND VPWR VPWR dc_inst.x3.net3 sky130_fd_sc_hd__buf_1
XTAP_TAPCELL_ROW_4_29 VGND VPWR sky130_fd_sc_hd__tapvpwrvgnd_1
X_12_ rst VGND VGND VPWR VPWR _01_ sky130_fd_sc_hd__inv_2
Xdc_inst.x2.x18 dc_inst.x2.net17 VGND VGND VPWR VPWR dc_inst.x2.net18 sky130_fd_sc_hd__buf_1
Xdc_inst.x5.x15 dc_inst.x5.net14 VGND VGND VPWR VPWR dc_inst.x5.net15 sky130_fd_sc_hd__buf_1
Xdc_inst.x6.x2 dc_inst.x6.net2 VGND VGND VPWR VPWR dc_inst.x6.net3 sky130_fd_sc_hd__buf_1
XFILLER_2_19 VGND VGND VPWR VPWR sky130_fd_sc_hd__fill_2
Xdc_inst.x3.x3 dc_inst.x3.net3 VGND VGND VPWR VPWR dc_inst.x3.net4 sky130_fd_sc_hd__buf_1
XPHY_EDGE_ROW_5_Left_17 VGND VGND VPWR VPWR sky130_fd_sc_hd__decap_3
Xdc_inst.x5.x16 dc_inst.x5.net15 VGND VGND VPWR VPWR dc_inst.x5.net16 sky130_fd_sc_hd__buf_1
X_11_ path_sel[2] VGND VGND VPWR VPWR _04_ sky130_fd_sc_hd__inv_2
Xdc_inst.x2.x19 dc_inst.x2.net18 VGND VGND VPWR VPWR dc_inst.x2.net19 sky130_fd_sc_hd__buf_1
XPHY_EDGE_ROW_8_Left_20 VGND VGND VPWR VPWR sky130_fd_sc_hd__decap_3
Xdc_inst.x6.x3 dc_inst.x6.net3 VGND VGND VPWR VPWR dc_inst.x6.net4 sky130_fd_sc_hd__buf_1
XFILLER_11_29 VGND VGND VPWR VPWR sky130_fd_sc_hd__fill_1
XFILLER_7_3 VGND VGND VPWR VPWR sky130_fd_sc_hd__fill_1
Xdc_inst.x3.x4 dc_inst.x3.net4 VGND VGND VPWR VPWR dc_inst.x3.net5 sky130_fd_sc_hd__buf_1
Xdc_inst.x1.x20 dc_inst.x1.net19 VGND VGND VPWR VPWR dc_inst.net1 sky130_fd_sc_hd__buf_2
Xdc_inst.x5.x17 dc_inst.x5.net16 VGND VGND VPWR VPWR dc_inst.x5.net17 sky130_fd_sc_hd__buf_1
XFILLER_0_53 VGND VGND VPWR VPWR sky130_fd_sc_hd__decap_3
XTAP_TAPCELL_ROW_5_30 VGND VPWR sky130_fd_sc_hd__tapvpwrvgnd_1
Xdc_inst.x6.x4 dc_inst.x6.net4 VGND VGND VPWR VPWR dc_inst.x6.net5 sky130_fd_sc_hd__buf_1
Xdc_inst.x3.x5 dc_inst.x3.net5 VGND VGND VPWR VPWR dc_inst.x3.net6 sky130_fd_sc_hd__buf_1
Xdc_inst.x5.x18 dc_inst.x5.net17 VGND VGND VPWR VPWR dc_inst.x5.net18 sky130_fd_sc_hd__buf_1
Xdc_inst.x1.x10 dc_inst.x1.net10 VGND VGND VPWR VPWR dc_inst.x1.net1 sky130_fd_sc_hd__buf_1
Xdc_inst.x6.x5 dc_inst.x6.net5 VGND VGND VPWR VPWR dc_inst.x6.net6 sky130_fd_sc_hd__buf_1
Xdc_inst.x3.x6 dc_inst.x3.net6 VGND VGND VPWR VPWR dc_inst.x3.net7 sky130_fd_sc_hd__buf_1
XFILLER_3_43 VGND VGND VPWR VPWR sky130_fd_sc_hd__fill_2
Xdc_inst.x1.x11 dc_inst.x1.net1 VGND VGND VPWR VPWR dc_inst.x1.net11 sky130_fd_sc_hd__buf_1
Xdc_inst.x5.x19 dc_inst.x5.net18 VGND VGND VPWR VPWR dc_inst.x5.net19 sky130_fd_sc_hd__buf_1
Xdc_inst.x6.x6 dc_inst.x6.net6 VGND VGND VPWR VPWR dc_inst.x6.net7 sky130_fd_sc_hd__buf_1
XFILLER_6_32 VGND VGND VPWR VPWR sky130_fd_sc_hd__decap_3
XPHY_EDGE_ROW_2_Right_2 VGND VGND VPWR VPWR sky130_fd_sc_hd__decap_3
Xdc_inst.x3.x7 dc_inst.x3.net7 VGND VGND VPWR VPWR dc_inst.x3.net8 sky130_fd_sc_hd__buf_1
XFILLER_5_3 VGND VGND VPWR VPWR sky130_fd_sc_hd__fill_2
Xdc_inst.x1.x12 dc_inst.x1.net11 VGND VGND VPWR VPWR dc_inst.x1.net12 sky130_fd_sc_hd__buf_1
Xdc_inst.x4.x20 dc_inst.x4.net19 VGND VGND VPWR VPWR dc_inst.net4 sky130_fd_sc_hd__buf_2
XFILLER_0_12 VGND VGND VPWR VPWR sky130_fd_sc_hd__fill_1
Xdc_inst.x6.x7 dc_inst.x6.net7 VGND VGND VPWR VPWR dc_inst.x6.net8 sky130_fd_sc_hd__buf_1
Xdc_inst.x3.x8 dc_inst.x3.net8 VGND VGND VPWR VPWR dc_inst.x3.net9 sky130_fd_sc_hd__buf_1
.ends
