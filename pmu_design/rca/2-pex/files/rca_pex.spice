* NGSPICE file created from rca.ext - technology: sky130A

.subckt sky130_fd_sc_hd__decap_3 VPWR VGND VPB VNB
X0 VPWR VGND VPWR VPB sky130_fd_pr__pfet_01v8_hvt ad=0.2262 pd=2.26 as=0.4524 ps=4.52 w=0.87 l=0.59
X1 VGND VPWR VGND VNB sky130_fd_pr__nfet_01v8 ad=0.143 pd=1.62 as=0.286 ps=3.24 w=0.55 l=0.59
C0 VGND VPWR 0.353f
C1 VPB VPWR 0.0625f
C2 VPB VGND 0.07966f
C3 VPWR VNB 0.46997f
C4 VGND VNB 0.42732f
C5 VPB VNB 0.33898f
.ends

.subckt sky130_fd_sc_hd__dfrtp_1 VGND VPWR VPB VNB CLK D RESET_B Q a_1462_47# a_543_47#
+ a_651_413# a_193_47# a_805_47# a_448_47# a_639_47# a_1283_21# a_761_289# a_1108_47#
+ a_1217_47# a_1270_413# a_27_47#
X0 a_805_47# a_761_289# a_639_47# VNB sky130_fd_pr__nfet_01v8 ad=0.0441 pd=0.63 as=0.1401 ps=1.1 w=0.42 l=0.15
X1 a_1217_47# a_27_47# a_1108_47# VNB sky130_fd_pr__special_nfet_01v8 ad=0.0669 pd=0.75 as=0.0711 ps=0.755 w=0.36 l=0.15
X2 a_1283_21# a_1108_47# a_1462_47# VNB sky130_fd_pr__nfet_01v8 ad=0.1092 pd=1.36 as=0.06405 ps=0.725 w=0.42 l=0.15
X3 a_651_413# a_27_47# a_543_47# VPB sky130_fd_pr__pfet_01v8_hvt ad=0.1155 pd=0.97 as=0.07245 ps=0.765 w=0.42 l=0.15
X4 a_1108_47# a_193_47# a_761_289# VNB sky130_fd_pr__special_nfet_01v8 ad=0.0711 pd=0.755 as=0.0999 ps=0.985 w=0.36 l=0.15
X5 VGND RESET_B a_805_47# VNB sky130_fd_pr__nfet_01v8 ad=0.1346 pd=1.15 as=0.0441 ps=0.63 w=0.42 l=0.15
X6 Q a_1283_21# VPWR VPB sky130_fd_pr__pfet_01v8_hvt ad=0.26 pd=2.52 as=0.3012 ps=2.66 w=1 l=0.15
X7 VPWR CLK a_27_47# VPB sky130_fd_pr__pfet_01v8_hvt ad=0.0864 pd=0.91 as=0.1664 ps=1.8 w=0.64 l=0.15
X8 a_448_47# D VPWR VPB sky130_fd_pr__pfet_01v8_hvt ad=0.0651 pd=0.73 as=0.1092 ps=1.36 w=0.42 l=0.15
X9 a_761_289# a_543_47# VGND VNB sky130_fd_pr__nfet_01v8 ad=0.0999 pd=0.985 as=0.1346 ps=1.15 w=0.64 l=0.15
X10 a_193_47# a_27_47# VGND VNB sky130_fd_pr__nfet_01v8 ad=0.1092 pd=1.36 as=0.0567 ps=0.69 w=0.42 l=0.15
X11 a_1108_47# a_27_47# a_761_289# VPB sky130_fd_pr__pfet_01v8_hvt ad=0.0588 pd=0.7 as=0.12915 ps=1.185 w=0.42 l=0.15
X12 a_1462_47# RESET_B VGND VNB sky130_fd_pr__nfet_01v8 ad=0.06405 pd=0.725 as=0.12495 ps=1.015 w=0.42 l=0.15
X13 a_543_47# a_27_47# a_448_47# VNB sky130_fd_pr__special_nfet_01v8 ad=0.0594 pd=0.69 as=0.066 ps=0.745 w=0.36 l=0.15
X14 a_543_47# a_193_47# a_448_47# VPB sky130_fd_pr__pfet_01v8_hvt ad=0.07245 pd=0.765 as=0.0651 ps=0.73 w=0.42 l=0.15
X15 a_448_47# D VGND VNB sky130_fd_pr__nfet_01v8 ad=0.066 pd=0.745 as=0.2205 ps=1.89 w=0.42 l=0.15
X16 VPWR a_1283_21# a_1270_413# VPB sky130_fd_pr__pfet_01v8_hvt ad=0.0819 pd=0.81 as=0.0567 ps=0.69 w=0.42 l=0.15
X17 VPWR a_1108_47# a_1283_21# VPB sky130_fd_pr__pfet_01v8_hvt ad=0.1134 pd=1.38 as=0.0567 ps=0.69 w=0.42 l=0.15
X18 a_1270_413# a_193_47# a_1108_47# VPB sky130_fd_pr__pfet_01v8_hvt ad=0.0567 pd=0.69 as=0.0588 ps=0.7 w=0.42 l=0.15
X19 a_193_47# a_27_47# VPWR VPB sky130_fd_pr__pfet_01v8_hvt ad=0.1664 pd=1.8 as=0.0864 ps=0.91 w=0.64 l=0.15
X20 a_1283_21# RESET_B VPWR VPB sky130_fd_pr__pfet_01v8_hvt ad=0.0567 pd=0.69 as=0.0819 ps=0.81 w=0.42 l=0.15
X21 VPWR a_761_289# a_651_413# VPB sky130_fd_pr__pfet_01v8_hvt ad=0.07035 pd=0.755 as=0.1155 ps=0.97 w=0.42 l=0.15
X22 Q a_1283_21# VGND VNB sky130_fd_pr__nfet_01v8 ad=0.169 pd=1.82 as=0.2087 ps=2.02 w=0.65 l=0.15
X23 a_639_47# a_193_47# a_543_47# VNB sky130_fd_pr__special_nfet_01v8 ad=0.1401 pd=1.1 as=0.0594 ps=0.69 w=0.36 l=0.15
X24 VGND a_1283_21# a_1217_47# VNB sky130_fd_pr__nfet_01v8 ad=0.12495 pd=1.015 as=0.0669 ps=0.75 w=0.42 l=0.15
X25 a_651_413# RESET_B VPWR VPB sky130_fd_pr__pfet_01v8_hvt ad=0.1092 pd=1.36 as=0.07035 ps=0.755 w=0.42 l=0.15
X26 VGND CLK a_27_47# VNB sky130_fd_pr__nfet_01v8 ad=0.0567 pd=0.69 as=0.1092 ps=1.36 w=0.42 l=0.15
X27 a_761_289# a_543_47# VPWR VPB sky130_fd_pr__pfet_01v8_hvt ad=0.12915 pd=1.185 as=0.2184 ps=2.2 w=0.84 l=0.15
C0 a_448_47# a_543_47# 0.04983f
C1 a_639_47# VGND 0.00863f
C2 a_1217_47# RESET_B 0
C3 a_805_47# a_543_47# 0.00171f
C4 a_805_47# a_761_289# 0
C5 a_651_413# a_193_47# 0.03462f
C6 a_651_413# a_27_47# 0
C7 RESET_B VPWR 0.06519f
C8 D VGND 0.05161f
C9 a_543_47# RESET_B 0.15327f
C10 a_761_289# RESET_B 0.16611f
C11 a_448_47# VGND 0.0661f
C12 a_805_47# VGND 0.00579f
C13 a_1462_47# RESET_B 0.00288f
C14 a_1217_47# a_761_289# 0
C15 a_1270_413# a_193_47# 0
C16 a_1108_47# RESET_B 0.2366f
C17 a_543_47# VPWR 0.10029f
C18 RESET_B VGND 0.28777f
C19 a_761_289# VPWR 0.10497f
C20 a_761_289# a_543_47# 0.20964f
C21 a_1108_47# a_1217_47# 0.00742f
C22 VPB D 0.13757f
C23 a_1217_47# VGND 0
C24 a_639_47# a_193_47# 0
C25 a_448_47# VPB 0.01414f
C26 a_1108_47# VPWR 0.17338f
C27 a_1108_47# a_543_47# 0
C28 a_639_47# a_27_47# 0.00188f
C29 a_1108_47# a_761_289# 0.05116f
C30 VPWR VGND 0.0502f
C31 a_543_47# VGND 0.12293f
C32 RESET_B Q 0
C33 a_761_289# VGND 0.07338f
C34 a_193_47# D 0.21795f
C35 a_27_47# D 0.13285f
C36 a_448_47# a_193_47# 0.06418f
C37 a_448_47# a_27_47# 0.09313f
C38 VPB RESET_B 0.13848f
C39 a_1462_47# VGND 0.00221f
C40 a_1108_47# VGND 0.148f
C41 VPWR Q 0.09969f
C42 a_193_47# RESET_B 0.0269f
C43 a_27_47# RESET_B 0.29634f
C44 a_1283_21# RESET_B 0.27814f
C45 CLK RESET_B 0
C46 VPB VPWR 0.21644f
C47 VPB a_543_47# 0.09579f
C48 VPB a_761_289# 0.09942f
C49 a_1217_47# a_193_47# 0
C50 a_1108_47# Q 0
C51 a_1217_47# a_27_47# 0
C52 VGND Q 0.06158f
C53 a_193_47# a_543_47# 0.2298f
C54 a_193_47# VPWR 0.39582f
C55 a_27_47# a_543_47# 0.11535f
C56 a_193_47# a_761_289# 0.18639f
C57 a_27_47# VPWR 0.1523f
C58 a_1108_47# VPB 0.11341f
C59 a_1283_21# VPWR 0.20891f
C60 a_27_47# a_761_289# 0.07009f
C61 VPB VGND 0.00999f
C62 CLK VPWR 0.01741f
C63 a_1283_21# a_1462_47# 0.0074f
C64 a_1108_47# a_193_47# 0.12532f
C65 a_1108_47# a_27_47# 0.10236f
C66 a_193_47# VGND 0.06306f
C67 a_1283_21# a_1108_47# 0.23366f
C68 a_27_47# VGND 0.25396f
C69 a_1283_21# VGND 0.23953f
C70 VPB Q 0.011f
C71 CLK VGND 0.01721f
C72 a_193_47# Q 0
C73 a_27_47# Q 0
C74 a_1283_21# Q 0.05978f
C75 a_651_413# RESET_B 0.0122f
C76 VPB a_193_47# 0.17092f
C77 VPB a_27_47# 0.26188f
C78 a_1283_21# VPB 0.13654f
C79 VPB CLK 0.06934f
C80 a_1270_413# RESET_B 0
C81 a_651_413# VPWR 0.12856f
C82 a_27_47# a_193_47# 0.90645f
C83 a_651_413# a_543_47# 0.05722f
C84 a_1283_21# a_193_47# 0.04242f
C85 a_651_413# a_761_289# 0.09774f
C86 a_448_47# a_639_47# 0
C87 CLK a_193_47# 0
C88 a_1283_21# a_27_47# 0.04357f
C89 CLK a_27_47# 0.2336f
C90 a_448_47# D 0.15563f
C91 a_639_47# RESET_B 0
C92 a_1270_413# VPWR 0
C93 a_1270_413# a_761_289# 0
C94 D RESET_B 0
C95 a_448_47# RESET_B 0
C96 a_1108_47# a_1270_413# 0.00645f
C97 a_805_47# RESET_B 0.00316f
C98 a_639_47# a_543_47# 0.01379f
C99 a_639_47# a_761_289# 0
C100 D VPWR 0.08119f
C101 a_543_47# D 0
C102 a_651_413# VPB 0.01354f
C103 a_448_47# VPWR 0.06814f
C104 Q VNB 0.08987f
C105 VGND VNB 1.02171f
C106 VPWR VNB 0.83084f
C107 RESET_B VNB 0.26386f
C108 D VNB 0.15989f
C109 CLK VNB 0.19525f
C110 VPB VNB 1.84511f
C111 a_651_413# VNB 0.00469f
C112 a_448_47# VNB 0.0139f
C113 a_1108_47# VNB 0.13854f
C114 a_1283_21# VNB 0.29898f
C115 a_543_47# VNB 0.15787f
C116 a_761_289# VNB 0.12085f
C117 a_193_47# VNB 0.27357f
C118 a_27_47# VNB 0.49578f
.ends

.subckt sky130_fd_sc_hd__and2_1 VPWR VGND X B A VPB VNB a_145_75# a_59_75#
X0 VPWR B a_59_75# VPB sky130_fd_pr__pfet_01v8_hvt ad=0.16655 pd=1.39 as=0.0567 ps=0.69 w=0.42 l=0.15
X1 X a_59_75# VPWR VPB sky130_fd_pr__pfet_01v8_hvt ad=0.475 pd=2.95 as=0.16655 ps=1.39 w=1 l=0.15
X2 VGND B a_145_75# VNB sky130_fd_pr__nfet_01v8 ad=0.1118 pd=1.04 as=0.0567 ps=0.69 w=0.42 l=0.15
X3 a_59_75# A VPWR VPB sky130_fd_pr__pfet_01v8_hvt ad=0.0567 pd=0.69 as=0.1176 ps=1.4 w=0.42 l=0.15
X4 X a_59_75# VGND VNB sky130_fd_pr__nfet_01v8 ad=0.182 pd=1.86 as=0.1118 ps=1.04 w=0.65 l=0.15
X5 a_145_75# A a_59_75# VNB sky130_fd_pr__nfet_01v8 ad=0.0567 pd=0.69 as=0.1176 ps=1.4 w=0.42 l=0.15
C0 VGND B 0.01146f
C1 VPB VPWR 0.07293f
C2 VGND a_59_75# 0.11564f
C3 VPB A 0.08057f
C4 X VGND 0.09933f
C5 VGND a_145_75# 0.00468f
C6 VPWR A 0.03623f
C7 VPB B 0.06287f
C8 a_59_75# VPB 0.05631f
C9 VPWR B 0.01175f
C10 X VPB 0.01265f
C11 a_59_75# VPWR 0.15028f
C12 A B 0.09709f
C13 X VPWR 0.11122f
C14 a_145_75# VPWR 0
C15 a_59_75# A 0.08088f
C16 X A 0
C17 a_59_75# B 0.14331f
C18 X B 0.00276f
C19 X a_59_75# 0.10872f
C20 a_59_75# a_145_75# 0.00658f
C21 VGND VPB 0.008f
C22 X a_145_75# 0
C23 VGND VPWR 0.04608f
C24 VGND A 0.01472f
C25 VGND VNB 0.3114f
C26 X VNB 0.10018f
C27 B VNB 0.11287f
C28 A VNB 0.17379f
C29 VPWR VNB 0.27345f
C30 VPB VNB 0.51617f
C31 a_59_75# VNB 0.17706f
.ends

.subckt sky130_fd_sc_hd__or2_1 VPB VNB VGND VPWR X A B a_150_297# a_68_297#
X0 VGND A a_68_297# VNB sky130_fd_pr__nfet_01v8 ad=0.10025 pd=0.985 as=0.0567 ps=0.69 w=0.42 l=0.15
X1 a_68_297# B VGND VNB sky130_fd_pr__nfet_01v8 ad=0.0567 pd=0.69 as=0.1092 ps=1.36 w=0.42 l=0.15
X2 X a_68_297# VGND VNB sky130_fd_pr__nfet_01v8 ad=0.169 pd=1.82 as=0.10025 ps=0.985 w=0.65 l=0.15
X3 VPWR A a_150_297# VPB sky130_fd_pr__pfet_01v8_hvt ad=0.14575 pd=1.335 as=0.0441 ps=0.63 w=0.42 l=0.15
X4 X a_68_297# VPWR VPB sky130_fd_pr__pfet_01v8_hvt ad=0.34 pd=2.68 as=0.14575 ps=1.335 w=1 l=0.15
X5 a_150_297# B a_68_297# VPB sky130_fd_pr__pfet_01v8_hvt ad=0.0441 pd=0.63 as=0.1092 ps=1.36 w=0.42 l=0.15
C0 B VGND 0.04365f
C1 A VPWR 0.00846f
C2 a_68_297# VPB 0.06114f
C3 X VPWR 0.12857f
C4 a_68_297# VPWR 0.08898f
C5 B A 0.07509f
C6 B X 0
C7 a_150_297# VPWR 0.00193f
C8 B a_68_297# 0.09843f
C9 A VGND 0.03465f
C10 VPB VPWR 0.08053f
C11 VGND X 0.11395f
C12 VGND a_68_297# 0.11796f
C13 B VPB 0.0462f
C14 A X 0.01305f
C15 VGND a_150_297# 0
C16 B VPWR 0.00855f
C17 A a_68_297# 0.15786f
C18 X a_68_297# 0.10534f
C19 VGND VPB 0.0112f
C20 X a_150_297# 0
C21 a_68_297# a_150_297# 0.00477f
C22 VGND VPWR 0.04645f
C23 A VPB 0.03097f
C24 X VPB 0.0209f
C25 VGND VNB 0.32043f
C26 X VNB 0.10095f
C27 A VNB 0.11072f
C28 B VNB 0.18272f
C29 VPWR VNB 0.26856f
C30 VPB VNB 0.51617f
C31 a_68_297# VNB 0.15387f
.ends

.subckt sky130_fd_sc_hd__buf_2 VPWR VGND X A VPB VNB a_27_47#
X0 VPWR a_27_47# X VPB sky130_fd_pr__pfet_01v8_hvt ad=0.265 pd=2.53 as=0.135 ps=1.27 w=1 l=0.15
X1 X a_27_47# VPWR VPB sky130_fd_pr__pfet_01v8_hvt ad=0.135 pd=1.27 as=0.149 ps=1.325 w=1 l=0.15
X2 VPWR A a_27_47# VPB sky130_fd_pr__pfet_01v8_hvt ad=0.149 pd=1.325 as=0.1664 ps=1.8 w=0.64 l=0.15
X3 X a_27_47# VGND VNB sky130_fd_pr__nfet_01v8 ad=0.08775 pd=0.92 as=0.097 ps=0.975 w=0.65 l=0.15
X4 VGND a_27_47# X VNB sky130_fd_pr__nfet_01v8 ad=0.17225 pd=1.83 as=0.08775 ps=0.92 w=0.65 l=0.15
X5 VGND A a_27_47# VNB sky130_fd_pr__nfet_01v8 ad=0.097 pd=0.975 as=0.1092 ps=1.36 w=0.42 l=0.15
C0 A VGND 0.01989f
C1 VPWR VPB 0.05279f
C2 X VPB 0.00443f
C3 A VPWR 0.02211f
C4 A X 0.00306f
C5 a_27_47# VPB 0.07497f
C6 VPWR VGND 0.05175f
C7 VGND X 0.11126f
C8 A a_27_47# 0.15787f
C9 VPWR X 0.16899f
C10 A VPB 0.06973f
C11 VGND a_27_47# 0.12719f
C12 VPWR a_27_47# 0.1533f
C13 X a_27_47# 0.14879f
C14 VGND VPB 0.00642f
C15 VGND VNB 0.28418f
C16 X VNB 0.0215f
C17 VPWR VNB 0.24963f
C18 A VNB 0.18747f
C19 VPB VNB 0.42757f
C20 a_27_47# VNB 0.28447f
.ends

.subckt sky130_fd_sc_hd__a21bo_1 VNB VPB VGND VPWR X A2 A1 B1_N a_215_297# a_27_413#
+ a_298_297# a_382_47#
X0 a_298_297# a_27_413# a_215_297# VPB sky130_fd_pr__pfet_01v8_hvt ad=0.135 pd=1.27 as=0.265 ps=2.53 w=1 l=0.15
X1 a_215_297# a_27_413# VGND VNB sky130_fd_pr__nfet_01v8 ad=0.08775 pd=0.92 as=0.1359 ps=1.1 w=0.65 l=0.15
X2 a_298_297# A2 VPWR VPB sky130_fd_pr__pfet_01v8_hvt ad=0.265 pd=2.53 as=0.14 ps=1.28 w=1 l=0.15
X3 X a_215_297# VGND VNB sky130_fd_pr__nfet_01v8 ad=0.169 pd=1.82 as=0.25837 ps=1.445 w=0.65 l=0.15
X4 VPWR B1_N a_27_413# VPB sky130_fd_pr__pfet_01v8_hvt ad=0.1092 pd=1.36 as=0.1092 ps=1.36 w=0.42 l=0.15
X5 X a_215_297# VPWR VPB sky130_fd_pr__pfet_01v8_hvt ad=0.26 pd=2.52 as=0.26 ps=2.52 w=1 l=0.15
X6 a_382_47# A1 a_215_297# VNB sky130_fd_pr__nfet_01v8 ad=0.091 pd=0.93 as=0.08775 ps=0.92 w=0.65 l=0.15
X7 VGND B1_N a_27_413# VNB sky130_fd_pr__nfet_01v8 ad=0.1359 pd=1.1 as=0.1113 ps=1.37 w=0.42 l=0.15
X8 VPWR A1 a_298_297# VPB sky130_fd_pr__pfet_01v8_hvt ad=0.14 pd=1.28 as=0.135 ps=1.27 w=1 l=0.15
X9 VGND A2 a_382_47# VNB sky130_fd_pr__nfet_01v8 ad=0.25837 pd=1.445 as=0.091 ps=0.93 w=0.65 l=0.15
C0 VPB A2 0.04174f
C1 B1_N VGND 0.04923f
C2 A1 a_215_297# 0.09298f
C3 VPB a_298_297# 0.00345f
C4 A2 A1 0.11177f
C5 VGND X 0.05729f
C6 A1 a_298_297# 0.04941f
C7 a_382_47# X 0
C8 VPWR a_27_413# 0.10723f
C9 VPB VGND 0.01171f
C10 a_27_413# a_215_297# 0.14121f
C11 A2 a_27_413# 0
C12 VPWR a_215_297# 0.12987f
C13 VGND A1 0.01436f
C14 VPWR A2 0.0307f
C15 a_382_47# A1 0
C16 a_27_413# a_298_297# 0.00498f
C17 VPWR a_298_297# 0.19626f
C18 A2 a_215_297# 0.09491f
C19 B1_N X 0
C20 a_215_297# a_298_297# 0.07178f
C21 A2 a_298_297# 0.0357f
C22 B1_N VPB 0.10324f
C23 VGND a_27_413# 0.09815f
C24 VPWR VGND 0.07888f
C25 a_382_47# VPWR 0
C26 B1_N A1 0
C27 VGND a_215_297# 0.27179f
C28 a_382_47# a_215_297# 0.01048f
C29 A2 VGND 0.01967f
C30 VPB X 0.01173f
C31 VGND a_298_297# 0.00393f
C32 a_382_47# a_298_297# 0
C33 A1 X 0
C34 VPB A1 0.02766f
C35 B1_N a_27_413# 0.23707f
C36 B1_N VPWR 0.01897f
C37 a_382_47# VGND 0.0053f
C38 B1_N a_215_297# 0.00479f
C39 B1_N A2 0
C40 X a_27_413# 0
C41 VPWR X 0.11491f
C42 VPB a_27_413# 0.0987f
C43 B1_N a_298_297# 0
C44 VPB VPWR 0.09762f
C45 X a_215_297# 0.08024f
C46 A2 X 0.00569f
C47 A1 a_27_413# 0.05727f
C48 VPB a_215_297# 0.05456f
C49 VPWR A1 0.02152f
C50 VGND VNB 0.43958f
C51 X VNB 0.089f
C52 VPWR VNB 0.36562f
C53 A2 VNB 0.10755f
C54 A1 VNB 0.08928f
C55 B1_N VNB 0.29046f
C56 VPB VNB 0.78196f
C57 a_298_297# VNB 0.0039f
C58 a_215_297# VNB 0.15284f
C59 a_27_413# VNB 0.17158f
.ends

.subckt sky130_fd_sc_hd__xnor2_1 VGND VPWR B Y A VPB VNB a_129_47# a_47_47# a_285_47#
+ a_377_297#
X0 a_377_297# A VPWR VPB sky130_fd_pr__pfet_01v8_hvt ad=0.105 pd=1.21 as=0.365 ps=1.73 w=1 l=0.15
X1 a_47_47# B VPWR VPB sky130_fd_pr__pfet_01v8_hvt ad=0.135 pd=1.27 as=0.3 ps=2.6 w=1 l=0.15
X2 a_129_47# B a_47_47# VNB sky130_fd_pr__nfet_01v8 ad=0.06825 pd=0.86 as=0.169 ps=1.82 w=0.65 l=0.15
X3 a_285_47# B VGND VNB sky130_fd_pr__nfet_01v8 ad=0.08775 pd=0.92 as=0.169 ps=1.82 w=0.65 l=0.15
X4 Y a_47_47# a_285_47# VNB sky130_fd_pr__nfet_01v8 ad=0.195 pd=1.9 as=0.08775 ps=0.92 w=0.65 l=0.15
X5 VGND A a_129_47# VNB sky130_fd_pr__nfet_01v8 ad=0.08775 pd=0.92 as=0.06825 ps=0.86 w=0.65 l=0.15
X6 VPWR A a_47_47# VPB sky130_fd_pr__pfet_01v8_hvt ad=0.365 pd=1.73 as=0.135 ps=1.27 w=1 l=0.15
X7 VPWR a_47_47# Y VPB sky130_fd_pr__pfet_01v8_hvt ad=0.36 pd=2.72 as=0.165 ps=1.33 w=1 l=0.15
X8 Y B a_377_297# VPB sky130_fd_pr__pfet_01v8_hvt ad=0.165 pd=1.33 as=0.105 ps=1.21 w=1 l=0.15
X9 a_285_47# A VGND VNB sky130_fd_pr__nfet_01v8 ad=0.169 pd=1.82 as=0.08775 ps=0.92 w=0.65 l=0.15
C0 a_47_47# a_285_47# 0.01755f
C1 a_377_297# B 0.00254f
C2 a_285_47# Y 0.04387f
C3 a_285_47# VGND 0.21054f
C4 B VPB 0.06433f
C5 A VPB 0.0822f
C6 VPWR B 0.04082f
C7 A VPWR 0.03489f
C8 a_47_47# B 0.35554f
C9 A a_47_47# 0.0307f
C10 B Y 0.00334f
C11 A Y 0.00181f
C12 B a_129_47# 0.00236f
C13 B VGND 0.03892f
C14 A VGND 0.06347f
C15 VPWR a_377_297# 0.00559f
C16 a_377_297# a_47_47# 0.00899f
C17 a_377_297# Y 0.00188f
C18 VPWR VPB 0.07177f
C19 a_285_47# B 0.06696f
C20 A a_285_47# 0.03532f
C21 a_377_297# VGND 0.00125f
C22 a_47_47# VPB 0.04439f
C23 VPWR a_47_47# 0.27294f
C24 VPB Y 0.00878f
C25 VPWR Y 0.10728f
C26 VPWR a_129_47# 0
C27 a_47_47# Y 0.14268f
C28 a_47_47# a_129_47# 0.00369f
C29 VPB VGND 0.00568f
C30 VPWR VGND 0.06652f
C31 a_47_47# VGND 0.10353f
C32 A B 0.23582f
C33 Y VGND 0.03811f
C34 a_129_47# VGND 0.00547f
C35 a_285_47# VPB 0
C36 VPWR a_285_47# 0.00255f
C37 VGND VNB 0.39981f
C38 Y VNB 0.07833f
C39 VPWR VNB 0.35194f
C40 A VNB 0.21658f
C41 B VNB 0.21233f
C42 VPB VNB 0.69336f
C43 a_285_47# VNB 0.01742f
C44 a_47_47# VNB 0.19928f
.ends

.subckt sky130_fd_sc_hd__nand2_1 VPB VNB VGND VPWR A Y B a_113_47#
X0 VPWR A Y VPB sky130_fd_pr__pfet_01v8_hvt ad=0.26 pd=2.52 as=0.135 ps=1.27 w=1 l=0.15
X1 Y A a_113_47# VNB sky130_fd_pr__nfet_01v8 ad=0.169 pd=1.82 as=0.08775 ps=0.92 w=0.65 l=0.15
X2 a_113_47# B VGND VNB sky130_fd_pr__nfet_01v8 ad=0.08775 pd=0.92 as=0.169 ps=1.82 w=0.65 l=0.15
X3 Y B VPWR VPB sky130_fd_pr__pfet_01v8_hvt ad=0.135 pd=1.27 as=0.26 ps=2.52 w=1 l=0.15
C0 a_113_47# Y 0.00937f
C1 VGND VPWR 0.03219f
C2 VGND Y 0.1389f
C3 A VPB 0.03788f
C4 B A 0.05096f
C5 VPB VPWR 0.05086f
C6 B VPWR 0.04784f
C7 a_113_47# VGND 0.0019f
C8 VPB Y 0.00618f
C9 B Y 0.04807f
C10 VGND VPB 0.0044f
C11 B VGND 0.0544f
C12 A VPWR 0.04444f
C13 A Y 0.08548f
C14 B VPB 0.03907f
C15 VPWR Y 0.21141f
C16 a_113_47# VPWR 0
C17 A VGND 0.00949f
C18 VGND VNB 0.23167f
C19 Y VNB 0.05566f
C20 VPWR VNB 0.24511f
C21 A VNB 0.14338f
C22 B VNB 0.14583f
C23 VPB VNB 0.33898f
.ends

.subckt sky130_fd_sc_hd__bufinv_16 VNB VPB VGND VPWR A Y a_361_47# a_27_47#
X0 a_361_47# a_27_47# VGND VNB sky130_fd_pr__nfet_01v8 ad=0.08775 pd=0.92 as=0.08775 ps=0.92 w=0.65 l=0.15
X1 VPWR a_361_47# Y VPB sky130_fd_pr__pfet_01v8_hvt ad=0.135 pd=1.27 as=0.135 ps=1.27 w=1 l=0.15
X2 a_361_47# a_27_47# VGND VNB sky130_fd_pr__nfet_01v8 ad=0.08775 pd=0.92 as=0.08775 ps=0.92 w=0.65 l=0.15
X3 Y a_361_47# VGND VNB sky130_fd_pr__nfet_01v8 ad=0.08775 pd=0.92 as=0.08775 ps=0.92 w=0.65 l=0.15
X4 VPWR a_361_47# Y VPB sky130_fd_pr__pfet_01v8_hvt ad=0.135 pd=1.27 as=0.135 ps=1.27 w=1 l=0.15
X5 Y a_361_47# VGND VNB sky130_fd_pr__nfet_01v8 ad=0.08775 pd=0.92 as=0.08775 ps=0.92 w=0.65 l=0.15
X6 Y a_361_47# VPWR VPB sky130_fd_pr__pfet_01v8_hvt ad=0.135 pd=1.27 as=0.135 ps=1.27 w=1 l=0.15
X7 VPWR a_27_47# a_361_47# VPB sky130_fd_pr__pfet_01v8_hvt ad=0.135 pd=1.27 as=0.135 ps=1.27 w=1 l=0.15
X8 VPWR a_361_47# Y VPB sky130_fd_pr__pfet_01v8_hvt ad=0.26 pd=2.52 as=0.135 ps=1.27 w=1 l=0.15
X9 VPWR a_361_47# Y VPB sky130_fd_pr__pfet_01v8_hvt ad=0.135 pd=1.27 as=0.135 ps=1.27 w=1 l=0.15
X10 VGND a_361_47# Y VNB sky130_fd_pr__nfet_01v8 ad=0.169 pd=1.82 as=0.08775 ps=0.92 w=0.65 l=0.15
X11 a_361_47# a_27_47# VPWR VPB sky130_fd_pr__pfet_01v8_hvt ad=0.135 pd=1.27 as=0.135 ps=1.27 w=1 l=0.15
X12 VGND a_361_47# Y VNB sky130_fd_pr__nfet_01v8 ad=0.08775 pd=0.92 as=0.08775 ps=0.92 w=0.65 l=0.15
X13 VGND a_361_47# Y VNB sky130_fd_pr__nfet_01v8 ad=0.08775 pd=0.92 as=0.08775 ps=0.92 w=0.65 l=0.15
X14 VGND a_361_47# Y VNB sky130_fd_pr__nfet_01v8 ad=0.08775 pd=0.92 as=0.08775 ps=0.92 w=0.65 l=0.15
X15 VGND a_361_47# Y VNB sky130_fd_pr__nfet_01v8 ad=0.08775 pd=0.92 as=0.08775 ps=0.92 w=0.65 l=0.15
X16 VPWR A a_27_47# VPB sky130_fd_pr__pfet_01v8_hvt ad=0.135 pd=1.27 as=0.135 ps=1.27 w=1 l=0.15
X17 Y a_361_47# VPWR VPB sky130_fd_pr__pfet_01v8_hvt ad=0.135 pd=1.27 as=0.135 ps=1.27 w=1 l=0.15
X18 VGND a_361_47# Y VNB sky130_fd_pr__nfet_01v8 ad=0.08775 pd=0.92 as=0.08775 ps=0.92 w=0.65 l=0.15
X19 VPWR a_361_47# Y VPB sky130_fd_pr__pfet_01v8_hvt ad=0.135 pd=1.27 as=0.135 ps=1.27 w=1 l=0.15
X20 a_27_47# A VPWR VPB sky130_fd_pr__pfet_01v8_hvt ad=0.135 pd=1.27 as=0.135 ps=1.27 w=1 l=0.15
X21 Y a_361_47# VPWR VPB sky130_fd_pr__pfet_01v8_hvt ad=0.135 pd=1.27 as=0.135 ps=1.27 w=1 l=0.15
X22 a_27_47# A VGND VNB sky130_fd_pr__nfet_01v8 ad=0.08775 pd=0.92 as=0.08775 ps=0.92 w=0.65 l=0.15
X23 a_361_47# a_27_47# VGND VNB sky130_fd_pr__nfet_01v8 ad=0.08775 pd=0.92 as=0.08775 ps=0.92 w=0.65 l=0.15
X24 Y a_361_47# VPWR VPB sky130_fd_pr__pfet_01v8_hvt ad=0.135 pd=1.27 as=0.135 ps=1.27 w=1 l=0.15
X25 Y a_361_47# VGND VNB sky130_fd_pr__nfet_01v8 ad=0.08775 pd=0.92 as=0.08775 ps=0.92 w=0.65 l=0.15
X26 VPWR a_27_47# a_361_47# VPB sky130_fd_pr__pfet_01v8_hvt ad=0.135 pd=1.27 as=0.135 ps=1.27 w=1 l=0.15
X27 Y a_361_47# VGND VNB sky130_fd_pr__nfet_01v8 ad=0.08775 pd=0.92 as=0.08775 ps=0.92 w=0.65 l=0.15
X28 Y a_361_47# VPWR VPB sky130_fd_pr__pfet_01v8_hvt ad=0.135 pd=1.27 as=0.135 ps=1.27 w=1 l=0.15
X29 Y a_361_47# VGND VNB sky130_fd_pr__nfet_01v8 ad=0.08775 pd=0.92 as=0.08775 ps=0.92 w=0.65 l=0.15
X30 a_361_47# a_27_47# VPWR VPB sky130_fd_pr__pfet_01v8_hvt ad=0.135 pd=1.27 as=0.135 ps=1.27 w=1 l=0.15
X31 VPWR a_361_47# Y VPB sky130_fd_pr__pfet_01v8_hvt ad=0.135 pd=1.27 as=0.135 ps=1.27 w=1 l=0.15
X32 Y a_361_47# VGND VNB sky130_fd_pr__nfet_01v8 ad=0.08775 pd=0.92 as=0.08775 ps=0.92 w=0.65 l=0.15
X33 VGND A a_27_47# VNB sky130_fd_pr__nfet_01v8 ad=0.08775 pd=0.92 as=0.08775 ps=0.92 w=0.65 l=0.15
X34 VGND a_27_47# a_361_47# VNB sky130_fd_pr__nfet_01v8 ad=0.08775 pd=0.92 as=0.08775 ps=0.92 w=0.65 l=0.15
X35 VPWR a_27_47# a_361_47# VPB sky130_fd_pr__pfet_01v8_hvt ad=0.135 pd=1.27 as=0.135 ps=1.27 w=1 l=0.15
X36 Y a_361_47# VPWR VPB sky130_fd_pr__pfet_01v8_hvt ad=0.135 pd=1.27 as=0.135 ps=1.27 w=1 l=0.15
X37 VGND a_27_47# a_361_47# VNB sky130_fd_pr__nfet_01v8 ad=0.08775 pd=0.92 as=0.08775 ps=0.92 w=0.65 l=0.15
X38 VGND a_27_47# a_361_47# VNB sky130_fd_pr__nfet_01v8 ad=0.08775 pd=0.92 as=0.08775 ps=0.92 w=0.65 l=0.15
X39 a_361_47# a_27_47# VPWR VPB sky130_fd_pr__pfet_01v8_hvt ad=0.135 pd=1.27 as=0.135 ps=1.27 w=1 l=0.15
X40 VPWR a_361_47# Y VPB sky130_fd_pr__pfet_01v8_hvt ad=0.135 pd=1.27 as=0.135 ps=1.27 w=1 l=0.15
X41 VPWR a_361_47# Y VPB sky130_fd_pr__pfet_01v8_hvt ad=0.135 pd=1.27 as=0.135 ps=1.27 w=1 l=0.15
X42 VGND a_361_47# Y VNB sky130_fd_pr__nfet_01v8 ad=0.08775 pd=0.92 as=0.08775 ps=0.92 w=0.65 l=0.15
X43 VGND a_361_47# Y VNB sky130_fd_pr__nfet_01v8 ad=0.08775 pd=0.92 as=0.08775 ps=0.92 w=0.65 l=0.15
X44 VPWR A a_27_47# VPB sky130_fd_pr__pfet_01v8_hvt ad=0.135 pd=1.27 as=0.26 ps=2.52 w=1 l=0.15
X45 Y a_361_47# VPWR VPB sky130_fd_pr__pfet_01v8_hvt ad=0.135 pd=1.27 as=0.135 ps=1.27 w=1 l=0.15
X46 Y a_361_47# VGND VNB sky130_fd_pr__nfet_01v8 ad=0.08775 pd=0.92 as=0.08775 ps=0.92 w=0.65 l=0.15
X47 Y a_361_47# VPWR VPB sky130_fd_pr__pfet_01v8_hvt ad=0.135 pd=1.27 as=0.135 ps=1.27 w=1 l=0.15
X48 VGND A a_27_47# VNB sky130_fd_pr__nfet_01v8 ad=0.08775 pd=0.92 as=0.169 ps=1.82 w=0.65 l=0.15
X49 Y a_361_47# VGND VNB sky130_fd_pr__nfet_01v8 ad=0.08775 pd=0.92 as=0.08775 ps=0.92 w=0.65 l=0.15
C0 VPWR a_361_47# 0.7941f
C1 a_361_47# VGND 0.62299f
C2 a_361_47# A 0.00148f
C3 a_361_47# a_27_47# 0.66114f
C4 Y VPB 0.03485f
C5 Y VPWR 1.45006f
C6 Y VGND 1.053f
C7 Y a_27_47# 0.0017f
C8 VPWR VPB 0.20834f
C9 VGND VPB 0.01272f
C10 VPWR VGND 0.2259f
C11 A VPB 0.08817f
C12 a_27_47# VPB 0.1979f
C13 VPWR A 0.0498f
C14 VPWR a_27_47# 0.40289f
C15 VGND A 0.04463f
C16 VGND a_27_47# 0.31033f
C17 Y a_361_47# 1.68993f
C18 a_27_47# A 0.3805f
C19 a_361_47# VPB 0.51914f
C20 VGND VNB 1.19187f
C21 Y VNB 0.07747f
C22 VPWR VNB 1.01898f
C23 A VNB 0.29967f
C24 VPB VNB 2.19949f
C25 a_361_47# VNB 1.5068f
C26 a_27_47# VNB 0.62134f
.ends

.subckt sky130_fd_sc_hd__inv_2 A Y VPB VNB VPWR VGND
X0 Y A VPWR VPB sky130_fd_pr__pfet_01v8_hvt ad=0.135 pd=1.27 as=0.26 ps=2.52 w=1 l=0.15
X1 VGND A Y VNB sky130_fd_pr__nfet_01v8 ad=0.169 pd=1.82 as=0.08775 ps=0.92 w=0.65 l=0.15
X2 Y A VGND VNB sky130_fd_pr__nfet_01v8 ad=0.08775 pd=0.92 as=0.169 ps=1.82 w=0.65 l=0.15
X3 VPWR A Y VPB sky130_fd_pr__pfet_01v8_hvt ad=0.26 pd=2.52 as=0.135 ps=1.27 w=1 l=0.15
C0 VPWR A 0.06305f
C1 VGND Y 0.1546f
C2 VPB Y 0.0061f
C3 VGND A 0.06375f
C4 VPB A 0.07418f
C5 VPWR VGND 0.04227f
C6 VPB VPWR 0.05206f
C7 Y A 0.08939f
C8 VPB VGND 0.00649f
C9 VPWR Y 0.2091f
C10 VGND VNB 0.26619f
C11 Y VNB 0.03316f
C12 VPWR VNB 0.24604f
C13 A VNB 0.26281f
C14 VPB VNB 0.33898f
.ends

.subckt sky130_fd_sc_hd__clkinvlp_4 VNB VPB VPWR VGND A Y a_110_47# a_268_47#
X0 Y A VPWR VPB sky130_fd_pr__pfet_01v8_hvt ad=0.14 pd=1.28 as=0.265 ps=2.53 w=1 l=0.25
X1 VGND A a_268_47# VNB sky130_fd_pr__nfet_01v8 ad=0.14575 pd=1.63 as=0.05775 ps=0.76 w=0.55 l=0.15
X2 Y A VPWR VPB sky130_fd_pr__pfet_01v8_hvt ad=0.14 pd=1.28 as=0.14 ps=1.28 w=1 l=0.25
X3 Y A a_110_47# VNB sky130_fd_pr__nfet_01v8 ad=0.077 pd=0.83 as=0.05775 ps=0.76 w=0.55 l=0.15
X4 VPWR A Y VPB sky130_fd_pr__pfet_01v8_hvt ad=0.14 pd=1.28 as=0.14 ps=1.28 w=1 l=0.25
X5 a_110_47# A VGND VNB sky130_fd_pr__nfet_01v8 ad=0.05775 pd=0.76 as=0.14575 ps=1.63 w=0.55 l=0.15
X6 a_268_47# A Y VNB sky130_fd_pr__nfet_01v8 ad=0.05775 pd=0.76 as=0.077 ps=0.83 w=0.55 l=0.15
X7 VPWR A Y VPB sky130_fd_pr__pfet_01v8_hvt ad=0.265 pd=2.53 as=0.14 ps=1.28 w=1 l=0.25
C0 VGND VPWR 0.0682f
C1 a_268_47# VGND 0.008f
C2 VPWR A 0.16526f
C3 Y VPWR 0.43851f
C4 a_268_47# Y 0.00587f
C5 VPWR a_110_47# 0
C6 VGND A 0.10133f
C7 Y VGND 0.17274f
C8 VPB VPWR 0.07716f
C9 VGND a_110_47# 0.00176f
C10 Y A 0.2454f
C11 A a_110_47# 0
C12 Y a_110_47# 0.00568f
C13 VGND VPB 0.00662f
C14 a_268_47# VPWR 0
C15 VPB A 0.15965f
C16 Y VPB 0.01065f
C17 VGND VNB 0.39983f
C18 Y VNB 0.04051f
C19 VPWR VNB 0.36781f
C20 A VNB 0.57753f
C21 VPB VNB 0.60476f
.ends

.subckt sky130_fd_sc_hd__buf_4 VPWR VGND X A VPB VNB a_27_47#
X0 VPWR a_27_47# X VPB sky130_fd_pr__pfet_01v8_hvt ad=0.26 pd=2.52 as=0.135 ps=1.27 w=1 l=0.15
X1 X a_27_47# VPWR VPB sky130_fd_pr__pfet_01v8_hvt ad=0.135 pd=1.27 as=0.135 ps=1.27 w=1 l=0.15
X2 VPWR a_27_47# X VPB sky130_fd_pr__pfet_01v8_hvt ad=0.135 pd=1.27 as=0.135 ps=1.27 w=1 l=0.15
X3 X a_27_47# VPWR VPB sky130_fd_pr__pfet_01v8_hvt ad=0.135 pd=1.27 as=0.135 ps=1.27 w=1 l=0.15
X4 X a_27_47# VGND VNB sky130_fd_pr__nfet_01v8 ad=0.08775 pd=0.92 as=0.08775 ps=0.92 w=0.65 l=0.15
X5 X a_27_47# VGND VNB sky130_fd_pr__nfet_01v8 ad=0.08775 pd=0.92 as=0.08775 ps=0.92 w=0.65 l=0.15
X6 VGND a_27_47# X VNB sky130_fd_pr__nfet_01v8 ad=0.08775 pd=0.92 as=0.08775 ps=0.92 w=0.65 l=0.15
X7 VGND a_27_47# X VNB sky130_fd_pr__nfet_01v8 ad=0.169 pd=1.82 as=0.08775 ps=0.92 w=0.65 l=0.15
X8 VPWR A a_27_47# VPB sky130_fd_pr__pfet_01v8_hvt ad=0.135 pd=1.27 as=0.26 ps=2.52 w=1 l=0.15
X9 VGND A a_27_47# VNB sky130_fd_pr__nfet_01v8 ad=0.08775 pd=0.92 as=0.169 ps=1.82 w=0.65 l=0.15
C0 VGND A 0.01937f
C1 A X 0
C2 A VPB 0.03609f
C3 a_27_47# VPWR 0.21812f
C4 a_27_47# VGND 0.16264f
C5 a_27_47# X 0.20651f
C6 a_27_47# VPB 0.13215f
C7 VGND VPWR 0.07203f
C8 X VPWR 0.33254f
C9 VPB VPWR 0.07107f
C10 VGND X 0.22989f
C11 VGND VPB 0.00796f
C12 a_27_47# A 0.17018f
C13 VPB X 0.00899f
C14 A VPWR 0.01601f
C15 VGND VNB 0.37777f
C16 X VNB 0.03903f
C17 VPWR VNB 0.32508f
C18 A VNB 0.13997f
C19 VPB VNB 0.60476f
C20 a_27_47# VNB 0.46146f
.ends

.subckt sky130_fd_sc_hd__clkbuf_4 VGND VPWR A X VPB VNB a_27_47#
X0 VPWR A a_27_47# VPB sky130_fd_pr__pfet_01v8_hvt ad=0.165 pd=1.33 as=0.265 ps=2.53 w=1 l=0.15
X1 VGND a_27_47# X VNB sky130_fd_pr__nfet_01v8 ad=0.1218 pd=1.42 as=0.0588 ps=0.7 w=0.42 l=0.15
X2 VGND a_27_47# X VNB sky130_fd_pr__nfet_01v8 ad=0.0588 pd=0.7 as=0.0588 ps=0.7 w=0.42 l=0.15
X3 X a_27_47# VPWR VPB sky130_fd_pr__pfet_01v8_hvt ad=0.14 pd=1.28 as=0.14 ps=1.28 w=1 l=0.15
X4 X a_27_47# VGND VNB sky130_fd_pr__nfet_01v8 ad=0.0588 pd=0.7 as=0.0588 ps=0.7 w=0.42 l=0.15
X5 VGND A a_27_47# VNB sky130_fd_pr__nfet_01v8 ad=0.07035 pd=0.755 as=0.1113 ps=1.37 w=0.42 l=0.15
X6 VPWR a_27_47# X VPB sky130_fd_pr__pfet_01v8_hvt ad=0.3 pd=2.6 as=0.14 ps=1.28 w=1 l=0.15
X7 X a_27_47# VGND VNB sky130_fd_pr__nfet_01v8 ad=0.0588 pd=0.7 as=0.07035 ps=0.755 w=0.42 l=0.15
X8 X a_27_47# VPWR VPB sky130_fd_pr__pfet_01v8_hvt ad=0.14 pd=1.28 as=0.165 ps=1.33 w=1 l=0.15
X9 VPWR a_27_47# X VPB sky130_fd_pr__pfet_01v8_hvt ad=0.14 pd=1.28 as=0.14 ps=1.28 w=1 l=0.15
C0 VGND A 0.04309f
C1 A X 0.01395f
C2 A VPB 0.03214f
C3 a_27_47# VPWR 0.21924f
C4 a_27_47# VGND 0.14848f
C5 a_27_47# X 0.3277f
C6 a_27_47# VPB 0.13876f
C7 VGND VPWR 0.05704f
C8 X VPWR 0.31697f
C9 VPB VPWR 0.06317f
C10 VGND X 0.21559f
C11 VGND VPB 0.00583f
C12 a_27_47# A 0.19501f
C13 VPB X 0.01216f
C14 A VPWR 0.02195f
C15 VGND VNB 0.35771f
C16 X VNB 0.06701f
C17 VPWR VNB 0.30765f
C18 A VNB 0.14764f
C19 VPB VNB 0.60476f
C20 a_27_47# VNB 0.54298f
.ends

.subckt sky130_fd_sc_hd__clkbuf_16 VNB VPB VGND VPWR A X a_110_47#
X0 VPWR A a_110_47# VPB sky130_fd_pr__pfet_01v8_hvt ad=0.14 pd=1.28 as=0.14 ps=1.28 w=1 l=0.15
X1 VPWR a_110_47# X VPB sky130_fd_pr__pfet_01v8_hvt ad=0.14 pd=1.28 as=0.14 ps=1.28 w=1 l=0.15
X2 X a_110_47# VPWR VPB sky130_fd_pr__pfet_01v8_hvt ad=0.14 pd=1.28 as=0.14 ps=1.28 w=1 l=0.15
X3 X a_110_47# VPWR VPB sky130_fd_pr__pfet_01v8_hvt ad=0.14 pd=1.28 as=0.14 ps=1.28 w=1 l=0.15
X4 VPWR a_110_47# X VPB sky130_fd_pr__pfet_01v8_hvt ad=0.14 pd=1.28 as=0.14 ps=1.28 w=1 l=0.15
X5 VPWR a_110_47# X VPB sky130_fd_pr__pfet_01v8_hvt ad=0.265 pd=2.53 as=0.14 ps=1.28 w=1 l=0.15
X6 a_110_47# A VPWR VPB sky130_fd_pr__pfet_01v8_hvt ad=0.14 pd=1.28 as=0.265 ps=2.53 w=1 l=0.15
X7 a_110_47# A VGND VNB sky130_fd_pr__nfet_01v8 ad=0.0588 pd=0.7 as=0.0588 ps=0.7 w=0.42 l=0.15
X8 VGND a_110_47# X VNB sky130_fd_pr__nfet_01v8 ad=0.0588 pd=0.7 as=0.0588 ps=0.7 w=0.42 l=0.15
X9 X a_110_47# VGND VNB sky130_fd_pr__nfet_01v8 ad=0.0588 pd=0.7 as=0.0588 ps=0.7 w=0.42 l=0.15
X10 VGND a_110_47# X VNB sky130_fd_pr__nfet_01v8 ad=0.0588 pd=0.7 as=0.0588 ps=0.7 w=0.42 l=0.15
X11 a_110_47# A VPWR VPB sky130_fd_pr__pfet_01v8_hvt ad=0.14 pd=1.28 as=0.14 ps=1.28 w=1 l=0.15
X12 VGND A a_110_47# VNB sky130_fd_pr__nfet_01v8 ad=0.0588 pd=0.7 as=0.0588 ps=0.7 w=0.42 l=0.15
X13 VGND a_110_47# X VNB sky130_fd_pr__nfet_01v8 ad=0.05775 pd=0.695 as=0.0588 ps=0.7 w=0.42 l=0.15
X14 VPWR a_110_47# X VPB sky130_fd_pr__pfet_01v8_hvt ad=0.14 pd=1.28 as=0.14 ps=1.28 w=1 l=0.15
X15 X a_110_47# VPWR VPB sky130_fd_pr__pfet_01v8_hvt ad=0.14 pd=1.28 as=0.14 ps=1.28 w=1 l=0.15
X16 VGND A a_110_47# VNB sky130_fd_pr__nfet_01v8 ad=0.0588 pd=0.7 as=0.0588 ps=0.7 w=0.42 l=0.15
X17 VGND a_110_47# X VNB sky130_fd_pr__nfet_01v8 ad=0.1113 pd=1.37 as=0.0588 ps=0.7 w=0.42 l=0.15
X18 VPWR a_110_47# X VPB sky130_fd_pr__pfet_01v8_hvt ad=0.1375 pd=1.275 as=0.14 ps=1.28 w=1 l=0.15
X19 VGND a_110_47# X VNB sky130_fd_pr__nfet_01v8 ad=0.0588 pd=0.7 as=0.0588 ps=0.7 w=0.42 l=0.15
X20 X a_110_47# VPWR VPB sky130_fd_pr__pfet_01v8_hvt ad=0.14 pd=1.28 as=0.1375 ps=1.275 w=1 l=0.15
X21 a_110_47# A VGND VNB sky130_fd_pr__nfet_01v8 ad=0.0588 pd=0.7 as=0.1113 ps=1.37 w=0.42 l=0.15
X22 VPWR A a_110_47# VPB sky130_fd_pr__pfet_01v8_hvt ad=0.14 pd=1.28 as=0.14 ps=1.28 w=1 l=0.15
X23 VPWR a_110_47# X VPB sky130_fd_pr__pfet_01v8_hvt ad=0.14 pd=1.28 as=0.14 ps=1.28 w=1 l=0.15
X24 VPWR a_110_47# X VPB sky130_fd_pr__pfet_01v8_hvt ad=0.14 pd=1.28 as=0.14 ps=1.28 w=1 l=0.15
X25 VGND a_110_47# X VNB sky130_fd_pr__nfet_01v8 ad=0.0588 pd=0.7 as=0.0588 ps=0.7 w=0.42 l=0.15
X26 X a_110_47# VPWR VPB sky130_fd_pr__pfet_01v8_hvt ad=0.14 pd=1.28 as=0.14 ps=1.28 w=1 l=0.15
X27 VGND a_110_47# X VNB sky130_fd_pr__nfet_01v8 ad=0.0588 pd=0.7 as=0.0588 ps=0.7 w=0.42 l=0.15
X28 VGND a_110_47# X VNB sky130_fd_pr__nfet_01v8 ad=0.0588 pd=0.7 as=0.0588 ps=0.7 w=0.42 l=0.15
X29 X a_110_47# VGND VNB sky130_fd_pr__nfet_01v8 ad=0.0588 pd=0.7 as=0.0588 ps=0.7 w=0.42 l=0.15
X30 X a_110_47# VPWR VPB sky130_fd_pr__pfet_01v8_hvt ad=0.14 pd=1.28 as=0.14 ps=1.28 w=1 l=0.15
X31 X a_110_47# VPWR VPB sky130_fd_pr__pfet_01v8_hvt ad=0.14 pd=1.28 as=0.14 ps=1.28 w=1 l=0.15
X32 X a_110_47# VGND VNB sky130_fd_pr__nfet_01v8 ad=0.0588 pd=0.7 as=0.0588 ps=0.7 w=0.42 l=0.15
X33 VPWR a_110_47# X VPB sky130_fd_pr__pfet_01v8_hvt ad=0.14 pd=1.28 as=0.14 ps=1.28 w=1 l=0.15
X34 X a_110_47# VPWR VPB sky130_fd_pr__pfet_01v8_hvt ad=0.14 pd=1.28 as=0.14 ps=1.28 w=1 l=0.15
X35 X a_110_47# VGND VNB sky130_fd_pr__nfet_01v8 ad=0.0588 pd=0.7 as=0.0588 ps=0.7 w=0.42 l=0.15
X36 X a_110_47# VGND VNB sky130_fd_pr__nfet_01v8 ad=0.0588 pd=0.7 as=0.0588 ps=0.7 w=0.42 l=0.15
X37 X a_110_47# VGND VNB sky130_fd_pr__nfet_01v8 ad=0.0588 pd=0.7 as=0.0588 ps=0.7 w=0.42 l=0.15
X38 X a_110_47# VGND VNB sky130_fd_pr__nfet_01v8 ad=0.0588 pd=0.7 as=0.0588 ps=0.7 w=0.42 l=0.15
X39 X a_110_47# VGND VNB sky130_fd_pr__nfet_01v8 ad=0.0588 pd=0.7 as=0.05775 ps=0.695 w=0.42 l=0.15
C0 VGND A 0.11535f
C1 A X 0.00292f
C2 A VPB 0.1334f
C3 a_110_47# VPWR 0.66998f
C4 a_110_47# VGND 0.51239f
C5 a_110_47# X 1.62234f
C6 a_110_47# VPB 0.52756f
C7 VGND VPWR 0.18736f
C8 X VPWR 1.36494f
C9 VPB VPWR 0.18386f
C10 VGND X 0.97688f
C11 VGND VPB 0.01139f
C12 a_110_47# A 0.30658f
C13 VPB X 0.03148f
C14 A VPWR 0.11164f
C15 VGND VNB 1.01442f
C16 X VNB 0.11058f
C17 VPWR VNB 0.83479f
C18 A VNB 0.49473f
C19 VPB VNB 1.84511f
C20 a_110_47# VNB 1.73295f
.ends

.subckt sky130_fd_sc_hd__clkbuf_8 X A VPB VNB VGND VPWR a_110_47#
X0 VPWR A a_110_47# VPB sky130_fd_pr__pfet_01v8_hvt ad=0.14 pd=1.28 as=0.14 ps=1.28 w=1 l=0.15
X1 VPWR a_110_47# X VPB sky130_fd_pr__pfet_01v8_hvt ad=0.14 pd=1.28 as=0.14 ps=1.28 w=1 l=0.15
X2 X a_110_47# VPWR VPB sky130_fd_pr__pfet_01v8_hvt ad=0.14 pd=1.28 as=0.14 ps=1.28 w=1 l=0.15
X3 a_110_47# A VPWR VPB sky130_fd_pr__pfet_01v8_hvt ad=0.14 pd=1.28 as=0.265 ps=2.53 w=1 l=0.15
X4 X a_110_47# VGND VNB sky130_fd_pr__nfet_01v8 ad=0.0588 pd=0.7 as=0.0588 ps=0.7 w=0.42 l=0.15
X5 X a_110_47# VPWR VPB sky130_fd_pr__pfet_01v8_hvt ad=0.14 pd=1.28 as=0.14 ps=1.28 w=1 l=0.15
X6 VGND a_110_47# X VNB sky130_fd_pr__nfet_01v8 ad=0.0588 pd=0.7 as=0.0588 ps=0.7 w=0.42 l=0.15
X7 VPWR a_110_47# X VPB sky130_fd_pr__pfet_01v8_hvt ad=0.14 pd=1.28 as=0.14 ps=1.28 w=1 l=0.15
X8 VGND A a_110_47# VNB sky130_fd_pr__nfet_01v8 ad=0.0588 pd=0.7 as=0.0588 ps=0.7 w=0.42 l=0.15
X9 VGND a_110_47# X VNB sky130_fd_pr__nfet_01v8 ad=0.1134 pd=1.38 as=0.0588 ps=0.7 w=0.42 l=0.15
X10 a_110_47# A VGND VNB sky130_fd_pr__nfet_01v8 ad=0.0588 pd=0.7 as=0.1113 ps=1.37 w=0.42 l=0.15
X11 VPWR a_110_47# X VPB sky130_fd_pr__pfet_01v8_hvt ad=0.14 pd=1.28 as=0.14 ps=1.28 w=1 l=0.15
X12 X a_110_47# VPWR VPB sky130_fd_pr__pfet_01v8_hvt ad=0.14 pd=1.28 as=0.14 ps=1.28 w=1 l=0.15
X13 VGND a_110_47# X VNB sky130_fd_pr__nfet_01v8 ad=0.0588 pd=0.7 as=0.0588 ps=0.7 w=0.42 l=0.15
X14 VGND a_110_47# X VNB sky130_fd_pr__nfet_01v8 ad=0.0588 pd=0.7 as=0.0588 ps=0.7 w=0.42 l=0.15
X15 X a_110_47# VPWR VPB sky130_fd_pr__pfet_01v8_hvt ad=0.14 pd=1.28 as=0.14 ps=1.28 w=1 l=0.15
X16 X a_110_47# VGND VNB sky130_fd_pr__nfet_01v8 ad=0.0588 pd=0.7 as=0.0588 ps=0.7 w=0.42 l=0.15
X17 VPWR a_110_47# X VPB sky130_fd_pr__pfet_01v8_hvt ad=0.265 pd=2.53 as=0.14 ps=1.28 w=1 l=0.15
X18 X a_110_47# VGND VNB sky130_fd_pr__nfet_01v8 ad=0.0588 pd=0.7 as=0.0588 ps=0.7 w=0.42 l=0.15
X19 X a_110_47# VGND VNB sky130_fd_pr__nfet_01v8 ad=0.0588 pd=0.7 as=0.0588 ps=0.7 w=0.42 l=0.15
C0 VGND A 0.06948f
C1 A X 0.00168f
C2 A VPB 0.07074f
C3 a_110_47# VPWR 0.36905f
C4 a_110_47# VGND 0.24321f
C5 a_110_47# X 0.74245f
C6 a_110_47# VPB 0.26091f
C7 VGND VPWR 0.10623f
C8 X VPWR 0.71159f
C9 VPB VPWR 0.11643f
C10 VGND X 0.49209f
C11 VGND VPB 0.00944f
C12 a_110_47# A 0.19308f
C13 VPB X 0.02232f
C14 A VPWR 0.08111f
C15 VGND VNB 0.60793f
C16 X VNB 0.08125f
C17 VPWR VNB 0.52675f
C18 A VNB 0.28981f
C19 VPB VNB 1.04774f
C20 a_110_47# VNB 0.87741f
.ends

.subckt sky130_fd_sc_hd__clkbuf_1 VGND VPWR X A VPB VNB a_75_212#
X0 VPWR a_75_212# X VPB sky130_fd_pr__pfet_01v8_hvt ad=0.11455 pd=1.08 as=0.2054 ps=2.1 w=0.79 l=0.15
X1 a_75_212# A VGND VNB sky130_fd_pr__nfet_01v8 ad=0.1352 pd=1.56 as=0.0754 ps=0.81 w=0.52 l=0.15
X2 a_75_212# A VPWR VPB sky130_fd_pr__pfet_01v8_hvt ad=0.2054 pd=2.1 as=0.11455 ps=1.08 w=0.79 l=0.15
X3 VGND a_75_212# X VNB sky130_fd_pr__nfet_01v8 ad=0.0754 pd=0.81 as=0.1352 ps=1.56 w=0.52 l=0.15
C0 VGND A 0.01842f
C1 A VPWR 0.02174f
C2 A VPB 0.05249f
C3 a_75_212# X 0.10651f
C4 a_75_212# VGND 0.10497f
C5 a_75_212# VPWR 0.13404f
C6 a_75_212# VPB 0.0571f
C7 VGND X 0.05448f
C8 VPWR X 0.0896f
C9 VPB X 0.01279f
C10 VGND VPWR 0.02887f
C11 VGND VPB 0.00507f
C12 a_75_212# A 0.1779f
C13 VPB VPWR 0.03552f
C14 A X 0
C15 VGND VNB 0.20733f
C16 VPWR VNB 0.17553f
C17 X VNB 0.09416f
C18 A VNB 0.1642f
C19 VPB VNB 0.33898f
C20 a_75_212# VNB 0.21026f
.ends

.subckt sky130_fd_sc_hd__buf_1 VGND VPWR X A VPB VNB a_27_47#
X0 VPWR A a_27_47# VPB sky130_fd_pr__pfet_01v8_hvt ad=0.11455 pd=1.08 as=0.2054 ps=2.1 w=0.79 l=0.15
X1 X a_27_47# VGND VNB sky130_fd_pr__nfet_01v8 ad=0.1352 pd=1.56 as=0.0754 ps=0.81 w=0.52 l=0.15
X2 X a_27_47# VPWR VPB sky130_fd_pr__pfet_01v8_hvt ad=0.2054 pd=2.1 as=0.11455 ps=1.08 w=0.79 l=0.15
X3 VGND A a_27_47# VNB sky130_fd_pr__nfet_01v8 ad=0.0754 pd=0.81 as=0.1352 ps=1.56 w=0.52 l=0.15
C0 VGND A 0.01842f
C1 A X 0
C2 A VPB 0.05239f
C3 a_27_47# VPWR 0.1351f
C4 a_27_47# VGND 0.10476f
C5 a_27_47# X 0.10745f
C6 a_27_47# VPB 0.05917f
C7 VGND VPWR 0.02897f
C8 X VPWR 0.08968f
C9 VPB VPWR 0.03549f
C10 VGND X 0.05463f
C11 VGND VPB 0.00505f
C12 a_27_47# A 0.18145f
C13 VPB X 0.01276f
C14 A VPWR 0.02154f
C15 VGND VNB 0.20732f
C16 X VNB 0.09411f
C17 VPWR VNB 0.1754f
C18 A VNB 0.16405f
C19 VPB VNB 0.33898f
C20 a_27_47# VNB 0.20778f
.ends

.subckt sky130_fd_sc_hd__dlygate4sd3_1 X A VPB VNB VGND VPWR a_49_47# a_285_47# a_391_47#
X0 VPWR A a_49_47# VPB sky130_fd_pr__pfet_01v8_hvt ad=0.0567 pd=0.69 as=0.1092 ps=1.36 w=0.42 l=0.15
X1 VGND a_285_47# a_391_47# VNB sky130_fd_pr__nfet_01v8 ad=0.097 pd=0.975 as=0.1092 ps=1.36 w=0.42 l=0.5
X2 X a_391_47# VPWR VPB sky130_fd_pr__pfet_01v8_hvt ad=0.26 pd=2.52 as=0.14075 ps=1.325 w=1 l=0.15
X3 VGND A a_49_47# VNB sky130_fd_pr__nfet_01v8 ad=0.0567 pd=0.69 as=0.1092 ps=1.36 w=0.42 l=0.15
X4 VPWR a_285_47# a_391_47# VPB sky130_fd_pr__pfet_01v8_hvt ad=0.14075 pd=1.325 as=0.1092 ps=1.36 w=0.42 l=0.5
X5 a_285_47# a_49_47# VGND VNB sky130_fd_pr__nfet_01v8 ad=0.1092 pd=1.36 as=0.0567 ps=0.69 w=0.42 l=0.5
X6 a_285_47# a_49_47# VPWR VPB sky130_fd_pr__pfet_01v8_hvt ad=0.1092 pd=1.36 as=0.0567 ps=0.69 w=0.42 l=0.5
X7 X a_391_47# VGND VNB sky130_fd_pr__nfet_01v8 ad=0.169 pd=1.82 as=0.097 ps=0.975 w=0.65 l=0.15
C0 a_391_47# X 0.12894f
C1 VGND VPB 0.00717f
C2 VPWR VGND 0.07151f
C3 VGND a_285_47# 0.12094f
C4 VGND A 0.02139f
C5 VGND a_391_47# 0.13024f
C6 VGND X 0.07961f
C7 a_49_47# VPB 0.12541f
C8 a_49_47# VPWR 0.14427f
C9 a_49_47# a_285_47# 0.22264f
C10 a_49_47# A 0.27998f
C11 a_49_47# a_391_47# 0.00188f
C12 VPWR VPB 0.0787f
C13 a_285_47# VPB 0.15643f
C14 VPWR a_285_47# 0.11983f
C15 A VPB 0.08284f
C16 a_391_47# VPB 0.04413f
C17 VPWR A 0.02064f
C18 VPWR a_391_47# 0.13477f
C19 a_285_47# A 0.00107f
C20 a_285_47# a_391_47# 0.41909f
C21 X VPB 0.0155f
C22 VPWR X 0.08023f
C23 a_49_47# VGND 0.14355f
C24 a_285_47# X 0.0072f
C25 VGND VNB 0.43965f
C26 X VNB 0.09545f
C27 VPWR VNB 0.36735f
C28 A VNB 0.17865f
C29 VPB VNB 0.78196f
C30 a_391_47# VNB 0.1277f
C31 a_285_47# VNB 0.29867f
C32 a_49_47# VNB 0.3069f
.ends

.subckt sky130_fd_sc_hd__clkbuf_2 VGND VPWR A X VPB VNB a_27_47#
X0 VPWR A a_27_47# VPB sky130_fd_pr__pfet_01v8_hvt ad=0.1625 pd=1.325 as=0.265 ps=2.53 w=1 l=0.15
X1 VPWR a_27_47# X VPB sky130_fd_pr__pfet_01v8_hvt ad=0.26 pd=2.52 as=0.135 ps=1.27 w=1 l=0.15
X2 VGND A a_27_47# VNB sky130_fd_pr__nfet_01v8 ad=0.06825 pd=0.745 as=0.1113 ps=1.37 w=0.42 l=0.15
X3 X a_27_47# VPWR VPB sky130_fd_pr__pfet_01v8_hvt ad=0.135 pd=1.27 as=0.1625 ps=1.325 w=1 l=0.15
X4 X a_27_47# VGND VNB sky130_fd_pr__nfet_01v8 ad=0.0567 pd=0.69 as=0.06825 ps=0.745 w=0.42 l=0.15
X5 VGND a_27_47# X VNB sky130_fd_pr__nfet_01v8 ad=0.1092 pd=1.36 as=0.0567 ps=0.69 w=0.42 l=0.15
C0 X A 0.01226f
C1 a_27_47# X 0.16497f
C2 VGND VPB 0.00461f
C3 VPWR VGND 0.03808f
C4 VGND A 0.04529f
C5 VGND a_27_47# 0.10472f
C6 VGND X 0.11464f
C7 VPWR VPB 0.04378f
C8 A VPB 0.03346f
C9 a_27_47# VPB 0.06864f
C10 VPWR A 0.02197f
C11 VPWR a_27_47# 0.16726f
C12 a_27_47# A 0.20858f
C13 X VPB 0.00837f
C14 VPWR X 0.13913f
C15 VGND VNB 0.26297f
C16 X VNB 0.07314f
C17 VPWR VNB 0.22061f
C18 A VNB 0.1476f
C19 VPB VNB 0.42757f
C20 a_27_47# VNB 0.32014f
.ends

.subckt ZR_sky130_fd_sc_hd__decap_3 VPWR VGND VPB VNB
X0 VPWR VGND VPWR VPB sky130_fd_pr__pfet_01v8_hvt ad=0.2262 pd=2.26 as=0.4524 ps=4.52 w=0.87 l=0.59
X1 VGND VPWR VGND VNB sky130_fd_pr__nfet_01v8 ad=0.143 pd=1.62 as=0.286 ps=3.24 w=0.55 l=0.59
C0 VPB VPWR 0.0625f
C1 VPWR VGND 0.353f
C2 VPB VGND 0.07966f
C3 VPWR VNB 0.46997f
C4 VGND VNB 0.42732f
C5 VPB VNB 0.33898f
.ends

.subckt ZR_sky130_fd_sc_hd__buf_1 VGND VPWR X A VPB VNB a_27_47#
X0 VPWR A a_27_47# VPB sky130_fd_pr__pfet_01v8_hvt ad=0.11455 pd=1.08 as=0.2054 ps=2.1 w=0.79 l=0.15
X1 X a_27_47# VGND VNB sky130_fd_pr__nfet_01v8 ad=0.1352 pd=1.56 as=0.0754 ps=0.81 w=0.52 l=0.15
X2 X a_27_47# VPWR VPB sky130_fd_pr__pfet_01v8_hvt ad=0.2054 pd=2.1 as=0.11455 ps=1.08 w=0.79 l=0.15
X3 VGND A a_27_47# VNB sky130_fd_pr__nfet_01v8 ad=0.0754 pd=0.81 as=0.1352 ps=1.56 w=0.52 l=0.15
C0 X A 0
C1 a_27_47# X 0.10745f
C2 VGND VPB 0.00505f
C3 VPWR VGND 0.02897f
C4 VGND A 0.01842f
C5 VGND a_27_47# 0.10476f
C6 VGND X 0.05463f
C7 VPWR VPB 0.03549f
C8 A VPB 0.05239f
C9 a_27_47# VPB 0.05917f
C10 VPWR A 0.02154f
C11 VPWR a_27_47# 0.1351f
C12 a_27_47# A 0.18145f
C13 X VPB 0.01276f
C14 VPWR X 0.08968f
C15 VGND VNB 0.20732f
C16 X VNB 0.09411f
C17 VPWR VNB 0.1754f
C18 A VNB 0.16405f
C19 VPB VNB 0.33898f
C20 a_27_47# VNB 0.20778f
.ends

.subckt ZR_sky130_fd_sc_hd__clkbuf_4 VGND VPWR A X VPB VNB a_27_47#
X0 VPWR A a_27_47# VPB sky130_fd_pr__pfet_01v8_hvt ad=0.165 pd=1.33 as=0.265 ps=2.53 w=1 l=0.15
X1 VGND a_27_47# X VNB sky130_fd_pr__nfet_01v8 ad=0.1218 pd=1.42 as=0.0588 ps=0.7 w=0.42 l=0.15
X2 VGND a_27_47# X VNB sky130_fd_pr__nfet_01v8 ad=0.0588 pd=0.7 as=0.0588 ps=0.7 w=0.42 l=0.15
X3 X a_27_47# VPWR VPB sky130_fd_pr__pfet_01v8_hvt ad=0.14 pd=1.28 as=0.14 ps=1.28 w=1 l=0.15
X4 X a_27_47# VGND VNB sky130_fd_pr__nfet_01v8 ad=0.0588 pd=0.7 as=0.0588 ps=0.7 w=0.42 l=0.15
X5 VGND A a_27_47# VNB sky130_fd_pr__nfet_01v8 ad=0.07035 pd=0.755 as=0.1113 ps=1.37 w=0.42 l=0.15
X6 VPWR a_27_47# X VPB sky130_fd_pr__pfet_01v8_hvt ad=0.3 pd=2.6 as=0.14 ps=1.28 w=1 l=0.15
X7 X a_27_47# VGND VNB sky130_fd_pr__nfet_01v8 ad=0.0588 pd=0.7 as=0.07035 ps=0.755 w=0.42 l=0.15
X8 X a_27_47# VPWR VPB sky130_fd_pr__pfet_01v8_hvt ad=0.14 pd=1.28 as=0.165 ps=1.33 w=1 l=0.15
X9 VPWR a_27_47# X VPB sky130_fd_pr__pfet_01v8_hvt ad=0.14 pd=1.28 as=0.14 ps=1.28 w=1 l=0.15
C0 X A 0.01395f
C1 a_27_47# X 0.3277f
C2 VGND VPB 0.00583f
C3 VPWR VGND 0.05704f
C4 VGND A 0.04309f
C5 VGND a_27_47# 0.14848f
C6 VGND X 0.21559f
C7 VPWR VPB 0.06317f
C8 A VPB 0.03214f
C9 a_27_47# VPB 0.13876f
C10 VPWR A 0.02195f
C11 VPWR a_27_47# 0.21924f
C12 a_27_47# A 0.19501f
C13 X VPB 0.01216f
C14 VPWR X 0.31697f
C15 VGND VNB 0.35771f
C16 X VNB 0.06701f
C17 VPWR VNB 0.30765f
C18 A VNB 0.14764f
C19 VPB VNB 0.60476f
C20 a_27_47# VNB 0.54298f
.ends

.subckt ZR_sky130_fd_sc_hd__dfrtp_2 VGND VPWR VPB VNB CLK D RESET_B Q a_1462_47# a_543_47#
+ a_651_413# a_193_47# a_805_47# a_448_47# a_639_47# a_1283_21# a_761_289# a_1108_47#
+ a_1217_47# a_1270_413# a_27_47#
X0 a_805_47# a_761_289# a_639_47# VNB sky130_fd_pr__nfet_01v8 ad=0.0441 pd=0.63 as=0.1401 ps=1.1 w=0.42 l=0.15
X1 a_1217_47# a_27_47# a_1108_47# VNB sky130_fd_pr__special_nfet_01v8 ad=0.0669 pd=0.75 as=0.0711 ps=0.755 w=0.36 l=0.15
X2 VGND a_1283_21# Q VNB sky130_fd_pr__nfet_01v8 ad=0.169 pd=1.82 as=0.08775 ps=0.92 w=0.65 l=0.15
X3 a_1283_21# a_1108_47# a_1462_47# VNB sky130_fd_pr__nfet_01v8 ad=0.1092 pd=1.36 as=0.06405 ps=0.725 w=0.42 l=0.15
X4 a_651_413# a_27_47# a_543_47# VPB sky130_fd_pr__pfet_01v8_hvt ad=0.1155 pd=0.97 as=0.07245 ps=0.765 w=0.42 l=0.15
X5 VPWR a_1283_21# Q VPB sky130_fd_pr__pfet_01v8_hvt ad=0.26 pd=2.52 as=0.135 ps=1.27 w=1 l=0.15
X6 a_1108_47# a_193_47# a_761_289# VNB sky130_fd_pr__special_nfet_01v8 ad=0.0711 pd=0.755 as=0.0999 ps=0.985 w=0.36 l=0.15
X7 VGND RESET_B a_805_47# VNB sky130_fd_pr__nfet_01v8 ad=0.1346 pd=1.15 as=0.0441 ps=0.63 w=0.42 l=0.15
X8 Q a_1283_21# VPWR VPB sky130_fd_pr__pfet_01v8_hvt ad=0.135 pd=1.27 as=0.3012 ps=2.66 w=1 l=0.15
X9 VPWR CLK a_27_47# VPB sky130_fd_pr__pfet_01v8_hvt ad=0.0864 pd=0.91 as=0.1664 ps=1.8 w=0.64 l=0.15
X10 a_448_47# D VPWR VPB sky130_fd_pr__pfet_01v8_hvt ad=0.0651 pd=0.73 as=0.1092 ps=1.36 w=0.42 l=0.15
X11 a_761_289# a_543_47# VGND VNB sky130_fd_pr__nfet_01v8 ad=0.0999 pd=0.985 as=0.1346 ps=1.15 w=0.64 l=0.15
X12 a_193_47# a_27_47# VGND VNB sky130_fd_pr__nfet_01v8 ad=0.1092 pd=1.36 as=0.0567 ps=0.69 w=0.42 l=0.15
X13 a_1108_47# a_27_47# a_761_289# VPB sky130_fd_pr__pfet_01v8_hvt ad=0.0588 pd=0.7 as=0.12915 ps=1.185 w=0.42 l=0.15
X14 a_1462_47# RESET_B VGND VNB sky130_fd_pr__nfet_01v8 ad=0.06405 pd=0.725 as=0.12495 ps=1.015 w=0.42 l=0.15
X15 a_543_47# a_27_47# a_448_47# VNB sky130_fd_pr__special_nfet_01v8 ad=0.0594 pd=0.69 as=0.066 ps=0.745 w=0.36 l=0.15
X16 a_543_47# a_193_47# a_448_47# VPB sky130_fd_pr__pfet_01v8_hvt ad=0.07245 pd=0.765 as=0.0651 ps=0.73 w=0.42 l=0.15
X17 a_448_47# D VGND VNB sky130_fd_pr__nfet_01v8 ad=0.066 pd=0.745 as=0.2205 ps=1.89 w=0.42 l=0.15
X18 VPWR a_1283_21# a_1270_413# VPB sky130_fd_pr__pfet_01v8_hvt ad=0.0819 pd=0.81 as=0.0567 ps=0.69 w=0.42 l=0.15
X19 VPWR a_1108_47# a_1283_21# VPB sky130_fd_pr__pfet_01v8_hvt ad=0.1134 pd=1.38 as=0.0567 ps=0.69 w=0.42 l=0.15
X20 a_1270_413# a_193_47# a_1108_47# VPB sky130_fd_pr__pfet_01v8_hvt ad=0.0567 pd=0.69 as=0.0588 ps=0.7 w=0.42 l=0.15
X21 a_193_47# a_27_47# VPWR VPB sky130_fd_pr__pfet_01v8_hvt ad=0.1664 pd=1.8 as=0.0864 ps=0.91 w=0.64 l=0.15
X22 a_1283_21# RESET_B VPWR VPB sky130_fd_pr__pfet_01v8_hvt ad=0.0567 pd=0.69 as=0.0819 ps=0.81 w=0.42 l=0.15
X23 VPWR a_761_289# a_651_413# VPB sky130_fd_pr__pfet_01v8_hvt ad=0.07035 pd=0.755 as=0.1155 ps=0.97 w=0.42 l=0.15
X24 Q a_1283_21# VGND VNB sky130_fd_pr__nfet_01v8 ad=0.08775 pd=0.92 as=0.2087 ps=2.02 w=0.65 l=0.15
X25 a_639_47# a_193_47# a_543_47# VNB sky130_fd_pr__special_nfet_01v8 ad=0.1401 pd=1.1 as=0.0594 ps=0.69 w=0.36 l=0.15
X26 VGND a_1283_21# a_1217_47# VNB sky130_fd_pr__nfet_01v8 ad=0.12495 pd=1.015 as=0.0669 ps=0.75 w=0.42 l=0.15
X27 a_651_413# RESET_B VPWR VPB sky130_fd_pr__pfet_01v8_hvt ad=0.1092 pd=1.36 as=0.07035 ps=0.755 w=0.42 l=0.15
X28 VGND CLK a_27_47# VNB sky130_fd_pr__nfet_01v8 ad=0.0567 pd=0.69 as=0.1092 ps=1.36 w=0.42 l=0.15
X29 a_761_289# a_543_47# VPWR VPB sky130_fd_pr__pfet_01v8_hvt ad=0.12915 pd=1.185 as=0.2184 ps=2.2 w=0.84 l=0.15
C0 a_1283_21# a_193_47# 0.04251f
C1 a_1217_47# VGND 0
C2 VPB D 0.13757f
C3 a_1108_47# a_543_47# 0
C4 a_27_47# a_1108_47# 0.10236f
C5 a_1283_21# a_1462_47# 0.0074f
C6 CLK VGND 0.01721f
C7 VPB Q 0.00555f
C8 D VPWR 0.08119f
C9 a_448_47# VPB 0.01414f
C10 VPWR Q 0.16936f
C11 a_448_47# VPWR 0.06814f
C12 a_193_47# a_543_47# 0.2298f
C13 RESET_B a_1108_47# 0.2366f
C14 a_1283_21# Q 0.0963f
C15 a_193_47# a_639_47# 0
C16 a_193_47# a_27_47# 0.90645f
C17 a_651_413# VPB 0.01354f
C18 D a_543_47# 0
C19 a_651_413# VPWR 0.12856f
C20 a_1270_413# RESET_B 0
C21 a_651_413# a_761_289# 0.09774f
C22 a_193_47# RESET_B 0.0269f
C23 D a_27_47# 0.13285f
C24 VPB CLK 0.06934f
C25 a_805_47# VGND 0.00579f
C26 a_1462_47# RESET_B 0.00288f
C27 a_1217_47# a_761_289# 0
C28 a_448_47# a_543_47# 0.04983f
C29 Q a_27_47# 0
C30 a_448_47# a_639_47# 0
C31 a_1270_413# a_1108_47# 0.00645f
C32 a_448_47# a_27_47# 0.09313f
C33 a_193_47# a_1108_47# 0.12532f
C34 CLK VPWR 0.01741f
C35 VPB VGND 0.01215f
C36 D RESET_B 0
C37 VPWR VGND 0.07191f
C38 RESET_B Q 0
C39 VGND a_761_289# 0.07338f
C40 a_448_47# RESET_B 0
C41 a_651_413# a_543_47# 0.05722f
C42 a_193_47# a_1270_413# 0
C43 a_1283_21# VGND 0.25943f
C44 a_651_413# a_27_47# 0
C45 Q a_1108_47# 0
C46 a_1217_47# a_27_47# 0
C47 a_651_413# RESET_B 0.0122f
C48 a_193_47# D 0.21795f
C49 CLK a_27_47# 0.2336f
C50 VGND a_543_47# 0.12293f
C51 a_805_47# a_761_289# 0
C52 a_1217_47# RESET_B 0
C53 a_639_47# VGND 0.00863f
C54 a_193_47# Q 0
C55 VGND a_27_47# 0.25397f
C56 a_193_47# a_448_47# 0.06418f
C57 VPB VPWR 0.2337f
C58 CLK RESET_B 0
C59 VPB a_761_289# 0.09942f
C60 a_1217_47# a_1108_47# 0.00742f
C61 a_1283_21# VPB 0.16811f
C62 RESET_B VGND 0.28803f
C63 VPWR a_761_289# 0.10497f
C64 a_448_47# D 0.15563f
C65 a_1283_21# VPWR 0.22975f
C66 a_193_47# a_651_413# 0.03462f
C67 a_805_47# a_543_47# 0.00171f
C68 VGND a_1108_47# 0.14813f
C69 a_193_47# a_1217_47# 0
C70 VPB a_543_47# 0.09579f
C71 a_193_47# CLK 0
C72 VPB a_27_47# 0.26188f
C73 a_543_47# a_761_289# 0.20964f
C74 VPWR a_543_47# 0.10029f
C75 a_805_47# RESET_B 0.00316f
C76 a_639_47# a_761_289# 0
C77 a_193_47# VGND 0.06306f
C78 VPWR a_27_47# 0.1523f
C79 a_27_47# a_761_289# 0.07009f
C80 a_1283_21# a_27_47# 0.04359f
C81 VPB RESET_B 0.13848f
C82 a_1462_47# VGND 0.00221f
C83 RESET_B VPWR 0.06519f
C84 D VGND 0.05161f
C85 RESET_B a_761_289# 0.16611f
C86 VPB a_1108_47# 0.11463f
C87 a_1283_21# RESET_B 0.27892f
C88 VGND Q 0.10966f
C89 a_639_47# a_543_47# 0.01379f
C90 a_448_47# VGND 0.0661f
C91 VPWR a_1108_47# 0.17379f
C92 a_27_47# a_543_47# 0.11535f
C93 a_1108_47# a_761_289# 0.05116f
C94 a_639_47# a_27_47# 0.00188f
C95 a_1283_21# a_1108_47# 0.23366f
C96 a_193_47# VPB 0.17091f
C97 RESET_B a_543_47# 0.15327f
C98 a_1270_413# VPWR 0
C99 a_639_47# RESET_B 0
C100 a_1270_413# a_761_289# 0
C101 a_193_47# VPWR 0.39596f
C102 a_193_47# a_761_289# 0.18639f
C103 RESET_B a_27_47# 0.29634f
C104 Q VNB 0.02956f
C105 VGND VNB 1.09584f
C106 VPWR VNB 0.90228f
C107 RESET_B VNB 0.26285f
C108 D VNB 0.15989f
C109 CLK VNB 0.19525f
C110 VPB VNB 1.9337f
C111 a_651_413# VNB 0.00469f
C112 a_448_47# VNB 0.0139f
C113 a_1108_47# VNB 0.13732f
C114 a_1283_21# VNB 0.38926f
C115 a_543_47# VNB 0.15787f
C116 a_761_289# VNB 0.12085f
C117 a_193_47# VNB 0.27321f
C118 a_27_47# VNB 0.49575f
.ends

.subckt ZR_sky130_fd_sc_hd__clkbuf_16 VNB VPB VGND VPWR A X a_110_47#
X0 VPWR A a_110_47# VPB sky130_fd_pr__pfet_01v8_hvt ad=0.14 pd=1.28 as=0.14 ps=1.28 w=1 l=0.15
X1 VPWR a_110_47# X VPB sky130_fd_pr__pfet_01v8_hvt ad=0.14 pd=1.28 as=0.14 ps=1.28 w=1 l=0.15
X2 X a_110_47# VPWR VPB sky130_fd_pr__pfet_01v8_hvt ad=0.14 pd=1.28 as=0.14 ps=1.28 w=1 l=0.15
X3 X a_110_47# VPWR VPB sky130_fd_pr__pfet_01v8_hvt ad=0.14 pd=1.28 as=0.14 ps=1.28 w=1 l=0.15
X4 VPWR a_110_47# X VPB sky130_fd_pr__pfet_01v8_hvt ad=0.14 pd=1.28 as=0.14 ps=1.28 w=1 l=0.15
X5 VPWR a_110_47# X VPB sky130_fd_pr__pfet_01v8_hvt ad=0.265 pd=2.53 as=0.14 ps=1.28 w=1 l=0.15
X6 a_110_47# A VPWR VPB sky130_fd_pr__pfet_01v8_hvt ad=0.14 pd=1.28 as=0.265 ps=2.53 w=1 l=0.15
X7 a_110_47# A VGND VNB sky130_fd_pr__nfet_01v8 ad=0.0588 pd=0.7 as=0.0588 ps=0.7 w=0.42 l=0.15
X8 VGND a_110_47# X VNB sky130_fd_pr__nfet_01v8 ad=0.0588 pd=0.7 as=0.0588 ps=0.7 w=0.42 l=0.15
X9 X a_110_47# VGND VNB sky130_fd_pr__nfet_01v8 ad=0.0588 pd=0.7 as=0.0588 ps=0.7 w=0.42 l=0.15
X10 VGND a_110_47# X VNB sky130_fd_pr__nfet_01v8 ad=0.0588 pd=0.7 as=0.0588 ps=0.7 w=0.42 l=0.15
X11 a_110_47# A VPWR VPB sky130_fd_pr__pfet_01v8_hvt ad=0.14 pd=1.28 as=0.14 ps=1.28 w=1 l=0.15
X12 VGND A a_110_47# VNB sky130_fd_pr__nfet_01v8 ad=0.0588 pd=0.7 as=0.0588 ps=0.7 w=0.42 l=0.15
X13 VGND a_110_47# X VNB sky130_fd_pr__nfet_01v8 ad=0.05775 pd=0.695 as=0.0588 ps=0.7 w=0.42 l=0.15
X14 VPWR a_110_47# X VPB sky130_fd_pr__pfet_01v8_hvt ad=0.14 pd=1.28 as=0.14 ps=1.28 w=1 l=0.15
X15 X a_110_47# VPWR VPB sky130_fd_pr__pfet_01v8_hvt ad=0.14 pd=1.28 as=0.14 ps=1.28 w=1 l=0.15
X16 VGND A a_110_47# VNB sky130_fd_pr__nfet_01v8 ad=0.0588 pd=0.7 as=0.0588 ps=0.7 w=0.42 l=0.15
X17 VGND a_110_47# X VNB sky130_fd_pr__nfet_01v8 ad=0.1113 pd=1.37 as=0.0588 ps=0.7 w=0.42 l=0.15
X18 VPWR a_110_47# X VPB sky130_fd_pr__pfet_01v8_hvt ad=0.1375 pd=1.275 as=0.14 ps=1.28 w=1 l=0.15
X19 VGND a_110_47# X VNB sky130_fd_pr__nfet_01v8 ad=0.0588 pd=0.7 as=0.0588 ps=0.7 w=0.42 l=0.15
X20 X a_110_47# VPWR VPB sky130_fd_pr__pfet_01v8_hvt ad=0.14 pd=1.28 as=0.1375 ps=1.275 w=1 l=0.15
X21 a_110_47# A VGND VNB sky130_fd_pr__nfet_01v8 ad=0.0588 pd=0.7 as=0.1113 ps=1.37 w=0.42 l=0.15
X22 VPWR A a_110_47# VPB sky130_fd_pr__pfet_01v8_hvt ad=0.14 pd=1.28 as=0.14 ps=1.28 w=1 l=0.15
X23 VPWR a_110_47# X VPB sky130_fd_pr__pfet_01v8_hvt ad=0.14 pd=1.28 as=0.14 ps=1.28 w=1 l=0.15
X24 VPWR a_110_47# X VPB sky130_fd_pr__pfet_01v8_hvt ad=0.14 pd=1.28 as=0.14 ps=1.28 w=1 l=0.15
X25 VGND a_110_47# X VNB sky130_fd_pr__nfet_01v8 ad=0.0588 pd=0.7 as=0.0588 ps=0.7 w=0.42 l=0.15
X26 X a_110_47# VPWR VPB sky130_fd_pr__pfet_01v8_hvt ad=0.14 pd=1.28 as=0.14 ps=1.28 w=1 l=0.15
X27 VGND a_110_47# X VNB sky130_fd_pr__nfet_01v8 ad=0.0588 pd=0.7 as=0.0588 ps=0.7 w=0.42 l=0.15
X28 VGND a_110_47# X VNB sky130_fd_pr__nfet_01v8 ad=0.0588 pd=0.7 as=0.0588 ps=0.7 w=0.42 l=0.15
X29 X a_110_47# VGND VNB sky130_fd_pr__nfet_01v8 ad=0.0588 pd=0.7 as=0.0588 ps=0.7 w=0.42 l=0.15
X30 X a_110_47# VPWR VPB sky130_fd_pr__pfet_01v8_hvt ad=0.14 pd=1.28 as=0.14 ps=1.28 w=1 l=0.15
X31 X a_110_47# VPWR VPB sky130_fd_pr__pfet_01v8_hvt ad=0.14 pd=1.28 as=0.14 ps=1.28 w=1 l=0.15
X32 X a_110_47# VGND VNB sky130_fd_pr__nfet_01v8 ad=0.0588 pd=0.7 as=0.0588 ps=0.7 w=0.42 l=0.15
X33 VPWR a_110_47# X VPB sky130_fd_pr__pfet_01v8_hvt ad=0.14 pd=1.28 as=0.14 ps=1.28 w=1 l=0.15
X34 X a_110_47# VPWR VPB sky130_fd_pr__pfet_01v8_hvt ad=0.14 pd=1.28 as=0.14 ps=1.28 w=1 l=0.15
X35 X a_110_47# VGND VNB sky130_fd_pr__nfet_01v8 ad=0.0588 pd=0.7 as=0.0588 ps=0.7 w=0.42 l=0.15
X36 X a_110_47# VGND VNB sky130_fd_pr__nfet_01v8 ad=0.0588 pd=0.7 as=0.0588 ps=0.7 w=0.42 l=0.15
X37 X a_110_47# VGND VNB sky130_fd_pr__nfet_01v8 ad=0.0588 pd=0.7 as=0.0588 ps=0.7 w=0.42 l=0.15
X38 X a_110_47# VGND VNB sky130_fd_pr__nfet_01v8 ad=0.0588 pd=0.7 as=0.0588 ps=0.7 w=0.42 l=0.15
X39 X a_110_47# VGND VNB sky130_fd_pr__nfet_01v8 ad=0.0588 pd=0.7 as=0.05775 ps=0.695 w=0.42 l=0.15
C0 a_110_47# VPB 0.52756f
C1 a_110_47# VGND 0.51239f
C2 VPB VPWR 0.18386f
C3 VPWR VGND 0.18736f
C4 a_110_47# X 1.62234f
C5 VPB A 0.1334f
C6 A VGND 0.11535f
C7 VPWR X 1.36494f
C8 a_110_47# VPWR 0.66998f
C9 A X 0.00292f
C10 VPB VGND 0.01139f
C11 a_110_47# A 0.30658f
C12 VPB X 0.03148f
C13 A VPWR 0.11164f
C14 X VGND 0.97688f
C15 VGND VNB 1.01442f
C16 X VNB 0.11058f
C17 VPWR VNB 0.83479f
C18 A VNB 0.49473f
C19 VPB VNB 1.84511f
C20 a_110_47# VNB 1.73295f
.ends

.subckt ZR_sky130_fd_sc_hd__buf_2 VPWR VGND X A VPB VNB a_27_47#
X0 VPWR a_27_47# X VPB sky130_fd_pr__pfet_01v8_hvt ad=0.265 pd=2.53 as=0.135 ps=1.27 w=1 l=0.15
X1 X a_27_47# VPWR VPB sky130_fd_pr__pfet_01v8_hvt ad=0.135 pd=1.27 as=0.149 ps=1.325 w=1 l=0.15
X2 VPWR A a_27_47# VPB sky130_fd_pr__pfet_01v8_hvt ad=0.149 pd=1.325 as=0.1664 ps=1.8 w=0.64 l=0.15
X3 X a_27_47# VGND VNB sky130_fd_pr__nfet_01v8 ad=0.08775 pd=0.92 as=0.097 ps=0.975 w=0.65 l=0.15
X4 VGND a_27_47# X VNB sky130_fd_pr__nfet_01v8 ad=0.17225 pd=1.83 as=0.08775 ps=0.92 w=0.65 l=0.15
X5 VGND A a_27_47# VNB sky130_fd_pr__nfet_01v8 ad=0.097 pd=0.975 as=0.1092 ps=1.36 w=0.42 l=0.15
C0 a_27_47# VPB 0.07497f
C1 VPB VPWR 0.05279f
C2 a_27_47# VGND 0.12719f
C3 VPWR VGND 0.05175f
C4 VPB A 0.06973f
C5 a_27_47# X 0.14879f
C6 VPWR X 0.16899f
C7 A VGND 0.01989f
C8 a_27_47# VPWR 0.1533f
C9 VPB VGND 0.00642f
C10 A X 0.00306f
C11 a_27_47# A 0.15787f
C12 A VPWR 0.02211f
C13 VPB X 0.00443f
C14 X VGND 0.11126f
C15 VGND VNB 0.28418f
C16 X VNB 0.0215f
C17 VPWR VNB 0.24963f
C18 A VNB 0.18747f
C19 VPB VNB 0.42757f
C20 a_27_47# VNB 0.28447f
.ends

.subckt ZR_sky130_fd_sc_hd__inv_2 A Y VPB VNB VPWR VGND
X0 Y A VPWR VPB sky130_fd_pr__pfet_01v8_hvt ad=0.135 pd=1.27 as=0.26 ps=2.52 w=1 l=0.15
X1 VGND A Y VNB sky130_fd_pr__nfet_01v8 ad=0.169 pd=1.82 as=0.08775 ps=0.92 w=0.65 l=0.15
X2 Y A VGND VNB sky130_fd_pr__nfet_01v8 ad=0.08775 pd=0.92 as=0.169 ps=1.82 w=0.65 l=0.15
X3 VPWR A Y VPB sky130_fd_pr__pfet_01v8_hvt ad=0.26 pd=2.52 as=0.135 ps=1.27 w=1 l=0.15
C0 A Y 0.08939f
C1 VPB VGND 0.00649f
C2 VPB Y 0.0061f
C3 A VPWR 0.06305f
C4 Y VGND 0.1546f
C5 VPB VPWR 0.05206f
C6 VPWR VGND 0.04227f
C7 VPB A 0.07418f
C8 VPWR Y 0.2091f
C9 A VGND 0.06375f
C10 VGND VNB 0.26619f
C11 Y VNB 0.03316f
C12 VPWR VNB 0.24604f
C13 A VNB 0.26281f
C14 VPB VNB 0.33898f
.ends

.subckt ZR_sky130_fd_sc_hd__mux4_1 VNB VPB VGND VPWR A1 A0 S0 A3 A2 S1 X a_1290_413#
+ a_757_363# a_1478_413# a_277_47# a_750_97# a_27_413# a_923_363# a_193_47# a_834_97#
+ a_247_21# a_668_97# a_193_413# a_27_47#
X0 a_277_47# a_247_21# a_27_413# VPB sky130_fd_pr__pfet_01v8_hvt ad=0.0567 pd=0.69 as=0.1092 ps=1.36 w=0.42 l=0.15
X1 VGND S0 a_247_21# VNB sky130_fd_pr__nfet_01v8 ad=0.1092 pd=1.36 as=0.1092 ps=1.36 w=0.42 l=0.15
X2 a_834_97# a_247_21# a_750_97# VNB sky130_fd_pr__nfet_01v8 ad=0.10795 pd=1.36 as=0.0567 ps=0.69 w=0.42 l=0.15
X3 VGND A3 a_668_97# VNB sky130_fd_pr__nfet_01v8 ad=0.0567 pd=0.69 as=0.1079 ps=1.36 w=0.42 l=0.15
X4 a_1290_413# S1 VPWR VPB sky130_fd_pr__pfet_01v8_hvt ad=0.1092 pd=1.36 as=0.1092 ps=1.36 w=0.42 l=0.15
X5 a_834_97# A2 VGND VNB sky130_fd_pr__nfet_01v8 ad=0.1092 pd=1.36 as=0.0567 ps=0.69 w=0.42 l=0.15
X6 a_750_97# S0 a_757_363# VPB sky130_fd_pr__pfet_01v8_hvt ad=0.0567 pd=0.69 as=0.1079 ps=1.36 w=0.42 l=0.15
X7 a_27_47# S0 a_277_47# VNB sky130_fd_pr__nfet_01v8 ad=0.1092 pd=1.36 as=0.08523 ps=0.925 w=0.42 l=0.15
X8 X a_1478_413# VGND VNB sky130_fd_pr__nfet_01v8 ad=0.169 pd=1.82 as=0.169 ps=1.82 w=0.65 l=0.15
X9 VPWR A1 a_27_413# VPB sky130_fd_pr__pfet_01v8_hvt ad=0.0567 pd=0.69 as=0.1092 ps=1.36 w=0.42 l=0.15
X10 VPWR S0 a_247_21# VPB sky130_fd_pr__pfet_01v8_hvt ad=0.1079 pd=1.36 as=0.1083 ps=1.36 w=0.42 l=0.15
X11 X a_1478_413# VPWR VPB sky130_fd_pr__pfet_01v8_hvt ad=0.26 pd=2.52 as=0.26 ps=2.52 w=1 l=0.15
X12 a_193_47# A0 VGND VNB sky130_fd_pr__nfet_01v8 ad=0.0567 pd=0.69 as=0.0567 ps=0.69 w=0.42 l=0.15
X13 a_750_97# a_1290_413# a_1478_413# VPB sky130_fd_pr__pfet_01v8_hvt ad=0.2688 pd=2.12 as=0.09207 ps=0.99 w=0.42 l=0.15
X14 a_1478_413# S1 a_277_47# VPB sky130_fd_pr__pfet_01v8_hvt ad=0.09207 pd=0.99 as=0.1092 ps=1.36 w=0.42 l=0.15
X15 a_1290_413# S1 VGND VNB sky130_fd_pr__nfet_01v8 ad=0.1092 pd=1.36 as=0.1092 ps=1.36 w=0.42 l=0.15
X16 a_277_47# a_247_21# a_193_47# VNB sky130_fd_pr__nfet_01v8 ad=0.08523 pd=0.925 as=0.0567 ps=0.69 w=0.42 l=0.15
X17 a_750_97# S0 a_668_97# VNB sky130_fd_pr__nfet_01v8 ad=0.0567 pd=0.69 as=0.1092 ps=1.36 w=0.42 l=0.15
X18 a_923_363# a_247_21# a_750_97# VPB sky130_fd_pr__pfet_01v8_hvt ad=0.09013 pd=0.995 as=0.0567 ps=0.69 w=0.42 l=0.15
X19 a_757_363# A2 VPWR VPB sky130_fd_pr__pfet_01v8_hvt ad=0.1092 pd=1.36 as=0.0567 ps=0.69 w=0.42 l=0.15
X20 VPWR A3 a_923_363# VPB sky130_fd_pr__pfet_01v8_hvt ad=0.0567 pd=0.69 as=0.09013 ps=0.995 w=0.42 l=0.15
X21 a_277_47# a_1290_413# a_1478_413# VNB sky130_fd_pr__nfet_01v8 ad=0.1092 pd=1.36 as=0.15102 ps=1.285 w=0.42 l=0.15
X22 a_193_413# A0 VPWR VPB sky130_fd_pr__pfet_01v8_hvt ad=0.1092 pd=1.36 as=0.0567 ps=0.69 w=0.42 l=0.15
X23 a_193_413# S0 a_277_47# VPB sky130_fd_pr__pfet_01v8_hvt ad=0.1079 pd=1.36 as=0.0567 ps=0.69 w=0.42 l=0.15
X24 VGND A1 a_27_47# VNB sky130_fd_pr__nfet_01v8 ad=0.0567 pd=0.69 as=0.1092 ps=1.36 w=0.42 l=0.15
X25 a_1478_413# S1 a_750_97# VNB sky130_fd_pr__nfet_01v8 ad=0.15102 pd=1.285 as=0.1092 ps=1.36 w=0.42 l=0.15
C0 a_27_47# A0 0.04574f
C1 a_27_413# a_247_21# 0.00549f
C2 a_247_21# X 0
C3 a_27_47# VGND 0.22952f
C4 a_27_413# a_750_97# 0
C5 a_750_97# X 0
C6 VPB a_27_413# 0.02285f
C7 VPB X 0.01181f
C8 VPWR a_27_413# 0.08385f
C9 A0 a_247_21# 0.07359f
C10 A3 a_277_47# 0.0121f
C11 S0 a_193_413# 0.01772f
C12 S1 X 0
C13 a_834_97# a_247_21# 0.02707f
C14 VPWR X 0.05937f
C15 a_923_363# a_750_97# 0.00222f
C16 a_247_21# VGND 0.09412f
C17 a_834_97# A2 0.04394f
C18 S0 a_757_363# 0.03305f
C19 A0 a_750_97# 0
C20 A1 a_277_47# 0.00101f
C21 VPWR a_923_363# 0.00225f
C22 VPWR a_193_47# 0
C23 a_834_97# a_750_97# 0.0296f
C24 A2 VGND 0.0122f
C25 VPB A0 0.08019f
C26 a_834_97# VPB 0.00426f
C27 a_750_97# VGND 0.05676f
C28 a_834_97# S1 0.00189f
C29 A0 VPWR 0.01747f
C30 a_834_97# VPWR 0
C31 VPB VGND 0.01387f
C32 a_1290_413# X 0.00208f
C33 S1 VGND 0.04087f
C34 VPWR VGND 0.05896f
C35 a_247_21# a_668_97# 0.01881f
C36 a_1290_413# a_923_363# 0
C37 a_27_47# a_277_47# 0.08551f
C38 a_247_21# a_1478_413# 0
C39 a_750_97# a_668_97# 0.04662f
C40 a_27_47# A3 0
C41 a_834_97# a_1290_413# 0.01242f
C42 a_27_413# a_193_413# 0.05551f
C43 VPB a_668_97# 0.00146f
C44 a_750_97# a_1478_413# 0.1456f
C45 a_1290_413# VGND 0.06373f
C46 VPWR a_668_97# 0.00181f
C47 VPB a_1478_413# 0.07712f
C48 a_27_47# A1 0.03909f
C49 S1 a_1478_413# 0.00517f
C50 VPWR a_1478_413# 0.21151f
C51 a_247_21# a_277_47# 0.35203f
C52 A2 a_277_47# 0.01375f
C53 A3 a_247_21# 0.07395f
C54 A0 a_193_413# 0.00145f
C55 S0 a_27_413# 0
C56 a_923_363# a_757_363# 0.00988f
C57 a_277_47# a_750_97# 0.26678f
C58 a_193_413# VGND 0
C59 VPB a_277_47# 0.03677f
C60 A2 A3 0.15492f
C61 a_1290_413# a_668_97# 0
C62 a_277_47# S1 0.06116f
C63 A3 a_750_97# 0.03406f
C64 VPWR a_277_47# 0.05706f
C65 A1 a_247_21# 0
C66 a_834_97# a_757_363# 0.01352f
C67 a_1290_413# a_1478_413# 0.10432f
C68 VPB A3 0.07252f
C69 A3 S1 0
C70 A0 S0 0.00186f
C71 A3 VPWR 0.012f
C72 a_834_97# S0 0
C73 A1 a_750_97# 0
C74 S0 VGND 0.06675f
C75 VPB A1 0.0741f
C76 VPWR A1 0.01712f
C77 a_1290_413# a_277_47# 0.33858f
C78 a_27_47# a_247_21# 0.0457f
C79 a_1290_413# A3 0
C80 S0 a_668_97# 0.03f
C81 a_27_47# VPB 0.00324f
C82 a_27_47# VPWR 0.0018f
C83 a_193_413# a_277_47# 0.0594f
C84 A0 a_27_413# 0.04892f
C85 A2 a_247_21# 0.00145f
C86 a_277_47# a_757_363# 0
C87 a_247_21# a_750_97# 0.12371f
C88 a_27_413# VGND 0.00189f
C89 X VGND 0.05939f
C90 VPB a_247_21# 0.22297f
C91 a_247_21# S1 0
C92 S0 a_277_47# 0.03381f
C93 A2 a_750_97# 0.01619f
C94 VPWR a_247_21# 0.15063f
C95 A3 a_757_363# 0.03224f
C96 A1 a_193_413# 0
C97 A0 a_193_47# 0
C98 a_834_97# a_923_363# 0
C99 VPB A2 0.07872f
C100 VGND a_193_47# 0.00175f
C101 A2 S1 0.06853f
C102 VPB a_750_97# 0.05933f
C103 A3 S0 0.00317f
C104 A2 VPWR 0.0129f
C105 a_750_97# S1 0.06323f
C106 VPWR a_750_97# 0.22609f
C107 A0 VGND 0.01709f
C108 VPB S1 0.21534f
C109 a_834_97# VGND 0.09477f
C110 VPB VPWR 0.22689f
C111 VPWR S1 0.0409f
C112 a_1290_413# a_247_21# 0.00705f
C113 X a_1478_413# 0.12698f
C114 a_1290_413# A2 0.00165f
C115 a_1290_413# a_750_97# 0.17579f
C116 VPB a_1290_413# 0.14223f
C117 a_834_97# a_668_97# 0.05583f
C118 a_1290_413# S1 0.15612f
C119 a_1290_413# VPWR 0.0823f
C120 a_27_47# S0 0.01792f
C121 VGND a_668_97# 0.22352f
C122 a_193_413# a_247_21# 0.09132f
C123 a_27_413# a_277_47# 0.05408f
C124 a_277_47# X 0
C125 VGND a_1478_413# 0.18885f
C126 a_247_21# a_757_363# 0.02645f
C127 a_193_413# a_750_97# 0
C128 a_277_47# a_193_47# 0
C129 VPB a_193_413# 0.01733f
C130 A0 a_277_47# 0.05427f
C131 A2 a_757_363# 0.03541f
C132 A1 a_27_413# 0.0413f
C133 VPWR a_193_413# 0.18442f
C134 S0 a_247_21# 0.39319f
C135 A3 a_923_363# 0
C136 a_834_97# a_277_47# 0.04391f
C137 a_757_363# a_750_97# 0.13413f
C138 a_277_47# VGND 0.41112f
C139 VPB a_757_363# 0.0237f
C140 a_834_97# A3 0.03609f
C141 a_757_363# S1 0.00151f
C142 VPWR a_757_363# 0.24812f
C143 S0 a_750_97# 0.09449f
C144 A3 VGND 0.01161f
C145 VPB S0 0.31074f
C146 A0 A1 0.14123f
C147 S0 VPWR 0.0687f
C148 a_27_47# a_27_413# 0.00987f
C149 A1 VGND 0.01705f
C150 a_277_47# a_668_97# 0.02235f
C151 a_1290_413# a_757_363# 0.0098f
C152 a_27_47# a_193_47# 0.00648f
C153 a_277_47# a_1478_413# 0.09435f
C154 A3 a_668_97# 0.0033f
C155 VGND VNB 1.07507f
C156 X VNB 0.09236f
C157 S1 VNB 0.32062f
C158 A2 VNB 0.11249f
C159 A3 VNB 0.11926f
C160 S0 VNB 0.46486f
C161 VPWR VNB 0.86887f
C162 A0 VNB 0.10257f
C163 A1 VNB 0.17585f
C164 VPB VNB 1.9337f
C165 a_834_97# VNB 0.02499f
C166 a_668_97# VNB 0.02039f
C167 a_27_47# VNB 0.04207f
C168 a_1478_413# VNB 0.16413f
C169 a_1290_413# VNB 0.2199f
C170 a_750_97# VNB 0.04192f
C171 a_757_363# VNB 0.00666f
C172 a_277_47# VNB 0.07984f
C173 a_247_21# VNB 0.34344f
C174 a_193_413# VNB 0.00373f
C175 a_27_413# VNB 0.02865f
.ends

.subckt ZR_sky130_fd_sc_hd__o21a_2 VNB VPB VGND VPWR X B1 A2 A1 a_384_47# a_470_297#
+ a_79_21#
X0 VPWR A1 a_470_297# VPB sky130_fd_pr__pfet_01v8_hvt ad=0.265 pd=2.53 as=0.16 ps=1.32 w=1 l=0.15
X1 a_79_21# B1 VPWR VPB sky130_fd_pr__pfet_01v8_hvt ad=0.14 pd=1.28 as=0.4 ps=1.8 w=1 l=0.15
X2 VGND a_79_21# X VNB sky130_fd_pr__nfet_01v8 ad=0.17225 pd=1.83 as=0.08937 ps=0.925 w=0.65 l=0.15
X3 VGND A2 a_384_47# VNB sky130_fd_pr__nfet_01v8 ad=0.104 pd=0.97 as=0.091 ps=0.93 w=0.65 l=0.15
X4 a_470_297# A2 a_79_21# VPB sky130_fd_pr__pfet_01v8_hvt ad=0.16 pd=1.32 as=0.14 ps=1.28 w=1 l=0.15
X5 VPWR a_79_21# X VPB sky130_fd_pr__pfet_01v8_hvt ad=0.4 pd=1.8 as=0.1375 ps=1.275 w=1 l=0.15
X6 a_384_47# B1 a_79_21# VNB sky130_fd_pr__nfet_01v8 ad=0.091 pd=0.93 as=0.17225 ps=1.83 w=0.65 l=0.15
X7 a_384_47# A1 VGND VNB sky130_fd_pr__nfet_01v8 ad=0.17225 pd=1.83 as=0.104 ps=0.97 w=0.65 l=0.15
X8 X a_79_21# VPWR VPB sky130_fd_pr__pfet_01v8_hvt ad=0.1375 pd=1.275 as=0.26 ps=2.52 w=1 l=0.15
X9 X a_79_21# VGND VNB sky130_fd_pr__nfet_01v8 ad=0.08937 pd=0.925 as=0.169 ps=1.82 w=0.65 l=0.15
C0 VPWR A1 0.04887f
C1 VPWR A2 0.05921f
C2 VPB B1 0.03944f
C3 a_79_21# B1 0.17323f
C4 VPWR VGND 0.07997f
C5 VPB X 0.00507f
C6 a_79_21# X 0.16252f
C7 A1 VPB 0.04016f
C8 A1 a_79_21# 0.0024f
C9 VPB A2 0.03377f
C10 a_79_21# A2 0.04273f
C11 VPWR a_384_47# 0.00722f
C12 VPB VGND 0.00643f
C13 a_79_21# VGND 0.15845f
C14 a_470_297# B1 0
C15 a_384_47# VPB 0
C16 a_384_47# a_79_21# 0.03435f
C17 a_470_297# A2 0.01159f
C18 a_470_297# VGND 0.00158f
C19 VPWR VPB 0.079f
C20 VPWR a_79_21# 0.2223f
C21 B1 X 0
C22 A1 B1 0
C23 B1 A2 0.09948f
C24 a_384_47# a_470_297# 0
C25 A1 A2 0.09025f
C26 a_79_21# VPB 0.07954f
C27 B1 VGND 0.01952f
C28 VGND X 0.10592f
C29 A1 VGND 0.01757f
C30 VPWR a_470_297# 0.01177f
C31 A2 VGND 0.01957f
C32 a_384_47# B1 0.00268f
C33 a_384_47# A1 0.03864f
C34 a_384_47# A2 0.05585f
C35 a_470_297# a_79_21# 0.00478f
C36 VPWR B1 0.02419f
C37 VPWR X 0.13299f
C38 a_384_47# VGND 0.09661f
C39 VGND VNB 0.43148f
C40 X VNB 0.02758f
C41 VPWR VNB 0.38347f
C42 A1 VNB 0.15077f
C43 A2 VNB 0.10192f
C44 B1 VNB 0.1061f
C45 VPB VNB 0.69336f
C46 a_384_47# VNB 0.01898f
C47 a_79_21# VNB 0.24775f
.ends

.subckt ZR_sky130_fd_sc_hd__a221o_2 VPWR VGND VPB VNB C1 B2 B1 A1 A2 X a_193_297#
+ a_465_47# a_205_47# a_109_297# a_27_47#
X0 VPWR a_27_47# X VPB sky130_fd_pr__pfet_01v8_hvt ad=0.285 pd=2.57 as=0.135 ps=1.27 w=1 l=0.15
X1 a_465_47# A1 a_27_47# VNB sky130_fd_pr__nfet_01v8 ad=0.10725 pd=0.98 as=0.169 ps=1.82 w=0.65 l=0.15
X2 X a_27_47# VPWR VPB sky130_fd_pr__pfet_01v8_hvt ad=0.135 pd=1.27 as=0.1575 ps=1.315 w=1 l=0.15
X3 a_109_297# B1 a_193_297# VPB sky130_fd_pr__pfet_01v8_hvt ad=0.26 pd=2.52 as=0.135 ps=1.27 w=1 l=0.15
X4 a_193_297# B2 a_109_297# VPB sky130_fd_pr__pfet_01v8_hvt ad=0.135 pd=1.27 as=0.135 ps=1.27 w=1 l=0.15
X5 X a_27_47# VGND VNB sky130_fd_pr__nfet_01v8 ad=0.08775 pd=0.92 as=0.10238 ps=0.965 w=0.65 l=0.15
X6 a_205_47# B2 VGND VNB sky130_fd_pr__nfet_01v8 ad=0.06825 pd=0.86 as=0.10725 ps=0.98 w=0.65 l=0.15
X7 VPWR A2 a_193_297# VPB sky130_fd_pr__pfet_01v8_hvt ad=0.1575 pd=1.315 as=0.165 ps=1.33 w=1 l=0.15
X8 a_193_297# A1 VPWR VPB sky130_fd_pr__pfet_01v8_hvt ad=0.165 pd=1.33 as=0.26 ps=2.52 w=1 l=0.15
X9 a_27_47# B1 a_205_47# VNB sky130_fd_pr__nfet_01v8 ad=0.169 pd=1.82 as=0.06825 ps=0.86 w=0.65 l=0.15
X10 VGND a_27_47# X VNB sky130_fd_pr__nfet_01v8 ad=0.18525 pd=1.87 as=0.08775 ps=0.92 w=0.65 l=0.15
X11 a_109_297# C1 a_27_47# VPB sky130_fd_pr__pfet_01v8_hvt ad=0.135 pd=1.27 as=0.26 ps=2.52 w=1 l=0.15
X12 VGND C1 a_27_47# VNB sky130_fd_pr__nfet_01v8 ad=0.10725 pd=0.98 as=0.169 ps=1.82 w=0.65 l=0.15
X13 VGND A2 a_465_47# VNB sky130_fd_pr__nfet_01v8 ad=0.10238 pd=0.965 as=0.10725 ps=0.98 w=0.65 l=0.15
C0 a_27_47# B2 0.09593f
C1 a_205_47# a_27_47# 0.00762f
C2 VPB a_193_297# 0.00774f
C3 B1 C1 0
C4 A2 X 0.00157f
C5 A1 VGND 0.01257f
C6 X C1 0
C7 C1 a_109_297# 0.00739f
C8 a_27_47# a_193_297# 0.14375f
C9 VPWR a_465_47# 0
C10 B2 C1 0.07257f
C11 VPB VPWR 0.09413f
C12 A2 a_193_297# 0.00683f
C13 a_27_47# VPWR 0.11848f
C14 B1 A1 0.06093f
C15 a_27_47# a_465_47# 0.01301f
C16 a_27_47# VPB 0.08209f
C17 B1 VGND 0.01327f
C18 A2 VPWR 0.02093f
C19 A1 X 0
C20 A1 a_109_297# 0
C21 X VGND 0.12187f
C22 VPWR C1 0.01404f
C23 VGND a_109_297# 0.00284f
C24 B2 VGND 0.01744f
C25 VPB A2 0.02696f
C26 a_205_47# VGND 0.00156f
C27 VPB C1 0.0368f
C28 A1 a_193_297# 0.01087f
C29 a_27_47# A2 0.15296f
C30 VGND a_193_297# 0.00438f
C31 a_27_47# C1 0.07922f
C32 B1 a_109_297# 0.00736f
C33 A1 VPWR 0.01613f
C34 B1 X 0
C35 B2 B1 0.07843f
C36 A2 C1 0
C37 X a_109_297# 0
C38 VPWR VGND 0.09384f
C39 A1 a_465_47# 0
C40 B2 X 0
C41 VPB A1 0.0343f
C42 B2 a_109_297# 0.01335f
C43 VGND a_465_47# 0.00257f
C44 VPB VGND 0.01028f
C45 B1 a_193_297# 0.00869f
C46 a_27_47# A1 0.09838f
C47 X a_193_297# 0.00367f
C48 a_193_297# a_109_297# 0.09272f
C49 a_27_47# VGND 0.41486f
C50 B2 a_193_297# 0.00126f
C51 B1 VPWR 0.00982f
C52 A1 A2 0.06924f
C53 A2 VGND 0.01675f
C54 A1 C1 0
C55 VPWR X 0.17541f
C56 VPWR a_109_297# 0.15013f
C57 VPB B1 0.03208f
C58 B2 VPWR 0.00842f
C59 a_205_47# VPWR 0
C60 VGND C1 0.01975f
C61 X a_465_47# 0
C62 VPB X 0.00423f
C63 VPB a_109_297# 0.00421f
C64 B2 VPB 0.02556f
C65 a_27_47# B1 0.11237f
C66 VPWR a_193_297# 0.16924f
C67 a_27_47# X 0.12862f
C68 a_27_47# a_109_297# 0.09613f
C69 VGND VNB 0.51852f
C70 X VNB 0.02003f
C71 VPWR VNB 0.44375f
C72 A2 VNB 0.08957f
C73 A1 VNB 0.10591f
C74 B1 VNB 0.10847f
C75 B2 VNB 0.08869f
C76 C1 VNB 0.13936f
C77 VPB VNB 0.87055f
C78 a_193_297# VNB 0.0011f
C79 a_109_297# VNB 0
C80 a_27_47# VNB 0.30506f
.ends

.subckt ZR_sky130_fd_sc_hd__mux2_1 VGND VPWR VPB VNB X A1 S A0 a_505_21# a_535_374#
+ a_439_47# a_218_47# a_76_199# a_218_374#
X0 VPWR a_505_21# a_535_374# VPB sky130_fd_pr__pfet_01v8_hvt ad=0.0693 pd=0.75 as=0.0441 ps=0.63 w=0.42 l=0.15
X1 a_505_21# S VPWR VPB sky130_fd_pr__pfet_01v8_hvt ad=0.1176 pd=1.4 as=0.0693 ps=0.75 w=0.42 l=0.15
X2 a_218_374# S VPWR VPB sky130_fd_pr__pfet_01v8_hvt ad=0.07665 pd=0.785 as=0.15835 ps=1.395 w=0.42 l=0.15
X3 VGND a_505_21# a_439_47# VNB sky130_fd_pr__nfet_01v8 ad=0.1449 pd=1.11 as=0.0693 ps=0.75 w=0.42 l=0.15
X4 a_76_199# A0 a_218_374# VPB sky130_fd_pr__pfet_01v8_hvt ad=0.1932 pd=1.34 as=0.07665 ps=0.785 w=0.42 l=0.15
X5 a_505_21# S VGND VNB sky130_fd_pr__nfet_01v8 ad=0.1092 pd=1.36 as=0.1449 ps=1.11 w=0.42 l=0.15
X6 a_439_47# A0 a_76_199# VNB sky130_fd_pr__nfet_01v8 ad=0.0693 pd=0.75 as=0.09975 ps=0.895 w=0.42 l=0.15
X7 a_535_374# A1 a_76_199# VPB sky130_fd_pr__pfet_01v8_hvt ad=0.0441 pd=0.63 as=0.1932 ps=1.34 w=0.42 l=0.15
X8 a_76_199# A1 a_218_47# VNB sky130_fd_pr__nfet_01v8 ad=0.09975 pd=0.895 as=0.0693 ps=0.75 w=0.42 l=0.15
X9 a_218_47# S VGND VNB sky130_fd_pr__nfet_01v8 ad=0.0693 pd=0.75 as=0.11285 ps=1.045 w=0.42 l=0.15
X10 VPWR a_76_199# X VPB sky130_fd_pr__pfet_01v8_hvt ad=0.15835 pd=1.395 as=0.26 ps=2.52 w=1 l=0.15
X11 VGND a_76_199# X VNB sky130_fd_pr__nfet_01v8 ad=0.11285 pd=1.045 as=0.169 ps=1.82 w=0.65 l=0.15
C0 X a_76_199# 0.07764f
C1 A1 S 0.08722f
C2 a_505_21# VPB 0.07806f
C3 a_535_374# VPWR 0
C4 VGND a_505_21# 0.12387f
C5 a_76_199# a_535_374# 0
C6 VPB VPWR 0.10994f
C7 VGND a_439_47# 0.00354f
C8 VGND VPWR 0.08036f
C9 X S 0.00823f
C10 a_76_199# VPB 0.04809f
C11 A0 VPB 0.1066f
C12 VGND a_76_199# 0.16013f
C13 A0 VGND 0.04323f
C14 a_535_374# S 0.00526f
C15 X a_218_47# 0
C16 VPB S 0.16849f
C17 VGND S 0.03296f
C18 a_218_374# VPWR 0.00177f
C19 a_76_199# a_218_374# 0.00557f
C20 VGND a_218_47# 0.00328f
C21 VPB A1 0.07208f
C22 VGND A1 0.07521f
C23 a_218_374# S 0.00688f
C24 X VPB 0.01205f
C25 X VGND 0.05864f
C26 a_505_21# VPWR 0.08183f
C27 A0 a_505_21# 0.03829f
C28 a_439_47# VPWR 0
C29 VGND a_535_374# 0
C30 a_76_199# VPWR 0.05421f
C31 A0 a_439_47# 0.00369f
C32 A0 VPWR 0.00732f
C33 VGND VPB 0.01345f
C34 A0 a_76_199# 0.05444f
C35 a_505_21# S 0.19751f
C36 S VPWR 0.39244f
C37 a_76_199# S 0.31816f
C38 A0 S 0.03411f
C39 a_218_47# VPWR 0
C40 VGND a_218_374# 0
C41 a_505_21# A1 0.09927f
C42 a_76_199# a_218_47# 0.00783f
C43 a_439_47# A1 0.00498f
C44 A1 VPWR 0.01137f
C45 a_76_199# A1 0.18667f
C46 A0 A1 0.2668f
C47 X VPWR 0.12783f
C48 VGND VNB 0.49866f
C49 A1 VNB 0.14042f
C50 A0 VNB 0.13429f
C51 S VNB 0.26814f
C52 VPWR VNB 0.41925f
C53 X VNB 0.09236f
C54 VPB VNB 0.87055f
C55 a_505_21# VNB 0.24676f
C56 a_76_199# VNB 0.13947f
.ends

.subckt ZR_sky130_fd_sc_hd__o21ba_2 VNB VPB VGND VPWR A2 A1 B1_N X a_478_47# a_27_93#
+ a_574_297# a_174_21#
X0 VGND B1_N a_27_93# VNB sky130_fd_pr__nfet_01v8 ad=0.097 pd=0.975 as=0.1092 ps=1.36 w=0.42 l=0.15
X1 VGND A2 a_478_47# VNB sky130_fd_pr__nfet_01v8 ad=0.08775 pd=0.92 as=0.10563 ps=0.975 w=0.65 l=0.15
X2 a_478_47# a_27_93# a_174_21# VNB sky130_fd_pr__nfet_01v8 ad=0.10563 pd=0.975 as=0.169 ps=1.82 w=0.65 l=0.15
X3 a_478_47# A1 VGND VNB sky130_fd_pr__nfet_01v8 ad=0.169 pd=1.82 as=0.08775 ps=0.92 w=0.65 l=0.15
X4 X a_174_21# VGND VNB sky130_fd_pr__nfet_01v8 ad=0.08775 pd=0.92 as=0.097 ps=0.975 w=0.65 l=0.15
X5 VPWR a_174_21# X VPB sky130_fd_pr__pfet_01v8_hvt ad=0.395 pd=1.79 as=0.135 ps=1.27 w=1 l=0.15
X6 X a_174_21# VPWR VPB sky130_fd_pr__pfet_01v8_hvt ad=0.135 pd=1.27 as=0.14575 ps=1.335 w=1 l=0.15
X7 VPWR A1 a_574_297# VPB sky130_fd_pr__pfet_01v8_hvt ad=0.28 pd=2.56 as=0.105 ps=1.21 w=1 l=0.15
X8 VGND a_174_21# X VNB sky130_fd_pr__nfet_01v8 ad=0.169 pd=1.82 as=0.08775 ps=0.92 w=0.65 l=0.15
X9 VPWR B1_N a_27_93# VPB sky130_fd_pr__pfet_01v8_hvt ad=0.14575 pd=1.335 as=0.1092 ps=1.36 w=0.42 l=0.15
X10 a_574_297# A2 a_174_21# VPB sky130_fd_pr__pfet_01v8_hvt ad=0.105 pd=1.21 as=0.165 ps=1.33 w=1 l=0.15
X11 a_174_21# a_27_93# VPWR VPB sky130_fd_pr__pfet_01v8_hvt ad=0.165 pd=1.33 as=0.395 ps=1.79 w=1 l=0.15
C0 a_174_21# VPWR 0.16766f
C1 a_478_47# a_174_21# 0.04688f
C2 B1_N VGND 0.03497f
C3 A2 a_574_297# 0.0012f
C4 VGND a_27_93# 0.07422f
C5 VPB B1_N 0.03863f
C6 VPWR VGND 0.07638f
C7 a_478_47# VGND 0.14787f
C8 A1 a_27_93# 0
C9 VPB a_27_93# 0.06917f
C10 a_174_21# a_574_297# 0.00594f
C11 VPWR A1 0.05355f
C12 a_478_47# A1 0.05742f
C13 VPB VPWR 0.08928f
C14 a_478_47# VPB 0
C15 VGND a_574_297# 0.00166f
C16 A1 a_574_297# 0
C17 B1_N X 0.05903f
C18 a_174_21# A2 0.05477f
C19 X a_27_93# 0.06273f
C20 VPWR X 0.01453f
C21 A2 VGND 0.0152f
C22 A2 A1 0.08184f
C23 VPB A2 0.02572f
C24 a_174_21# VGND 0.15593f
C25 a_174_21# A1 0.01787f
C26 a_174_21# VPB 0.07057f
C27 B1_N a_27_93# 0.0956f
C28 VPWR B1_N 0.01005f
C29 a_478_47# B1_N 0
C30 VGND A1 0.01629f
C31 VPB VGND 0.00775f
C32 VPWR a_27_93# 0.17642f
C33 a_478_47# a_27_93# 0.00383f
C34 VPB A1 0.03906f
C35 a_478_47# VPWR 0.00511f
C36 a_174_21# X 0.10302f
C37 VPWR a_574_297# 0.00809f
C38 a_478_47# a_574_297# 0.00203f
C39 X VGND 0.1117f
C40 VPB X 0.00312f
C41 A2 a_27_93# 0.05337f
C42 VPWR A2 0.0222f
C43 a_478_47# A2 0.05445f
C44 a_174_21# B1_N 0.04164f
C45 a_174_21# a_27_93# 0.24554f
C46 VGND VNB 0.45343f
C47 X VNB 0.00534f
C48 B1_N VNB 0.12157f
C49 VPWR VNB 0.39541f
C50 A1 VNB 0.14585f
C51 A2 VNB 0.0899f
C52 VPB VNB 0.78196f
C53 a_478_47# VNB 0.0324f
C54 a_27_93# VNB 0.20594f
C55 a_174_21# VNB 0.21227f
.ends

.subckt ZR_sky130_fd_sc_hd__nand2b_2 VNB VPB VGND VPWR A_N Y B a_229_47# a_27_93#
X0 Y B VPWR VPB sky130_fd_pr__pfet_01v8_hvt ad=0.135 pd=1.27 as=0.335 ps=1.67 w=1 l=0.15
X1 VGND A_N a_27_93# VNB sky130_fd_pr__nfet_01v8 ad=0.194 pd=1.95 as=0.1092 ps=1.36 w=0.42 l=0.15
X2 VGND B a_229_47# VNB sky130_fd_pr__nfet_01v8 ad=0.08775 pd=0.92 as=0.08775 ps=0.92 w=0.65 l=0.15
X3 Y a_27_93# a_229_47# VNB sky130_fd_pr__nfet_01v8 ad=0.08775 pd=0.92 as=0.169 ps=1.82 w=0.65 l=0.15
X4 a_229_47# a_27_93# Y VNB sky130_fd_pr__nfet_01v8 ad=0.08775 pd=0.92 as=0.08775 ps=0.92 w=0.65 l=0.15
X5 Y a_27_93# VPWR VPB sky130_fd_pr__pfet_01v8_hvt ad=0.165 pd=1.33 as=0.1468 ps=1.34 w=1 l=0.15
X6 VPWR a_27_93# Y VPB sky130_fd_pr__pfet_01v8_hvt ad=0.335 pd=1.67 as=0.165 ps=1.33 w=1 l=0.15
X7 VPWR B Y VPB sky130_fd_pr__pfet_01v8_hvt ad=0.275 pd=2.55 as=0.135 ps=1.27 w=1 l=0.15
X8 a_229_47# B VGND VNB sky130_fd_pr__nfet_01v8 ad=0.169 pd=1.82 as=0.08775 ps=0.92 w=0.65 l=0.15
X9 VPWR A_N a_27_93# VPB sky130_fd_pr__pfet_01v8_hvt ad=0.1468 pd=1.34 as=0.1092 ps=1.36 w=0.42 l=0.15
C0 VGND a_27_93# 0.07927f
C1 a_229_47# VPB 0
C2 a_229_47# Y 0.0848f
C3 VPB VPWR 0.09247f
C4 a_27_93# VPB 0.10054f
C5 VPWR Y 0.36778f
C6 a_27_93# Y 0.15215f
C7 VGND B 0.03115f
C8 a_229_47# A_N 0.00146f
C9 VPB B 0.08297f
C10 B Y 0.13629f
C11 VPWR A_N 0.00854f
C12 a_27_93# A_N 0.12924f
C13 VGND VPB 0.00778f
C14 VGND Y 0.01185f
C15 a_229_47# VPWR 0.0046f
C16 a_27_93# a_229_47# 0.05476f
C17 VPB Y 0.00632f
C18 a_27_93# VPWR 0.09512f
C19 VGND A_N 0.04234f
C20 a_229_47# B 0.12787f
C21 VPB A_N 0.0377f
C22 B VPWR 0.07134f
C23 a_27_93# B 0.04811f
C24 A_N Y 0.00387f
C25 VGND a_229_47# 0.30599f
C26 VGND VPWR 0.06699f
C27 VGND VNB 0.41132f
C28 Y VNB 0.0094f
C29 A_N VNB 0.12449f
C30 VPWR VNB 0.37543f
C31 B VNB 0.24538f
C32 VPB VNB 0.69336f
C33 a_229_47# VNB 0.0409f
C34 a_27_93# VNB 0.28968f
.ends

.subckt ZR_sky130_fd_sc_hd__mux4_2 VNB VPB VGND VPWR S0 A2 A3 S1 A1 A0 X a_193_369#
+ a_372_413# a_1281_47# a_193_47# a_1064_47# a_1060_369# a_288_47# a_397_47# a_872_316#
+ a_1279_413# a_788_316# a_600_345# a_27_47#
X0 a_600_345# S1 VPWR VPB sky130_fd_pr__pfet_01v8_hvt ad=0.1664 pd=1.8 as=0.0864 ps=0.91 w=0.64 l=0.15
X1 a_788_316# S1 a_288_47# VNB sky130_fd_pr__nfet_01v8 ad=0.05775 pd=0.695 as=0.1092 ps=1.36 w=0.42 l=0.15
X2 VPWR A3 a_372_413# VPB sky130_fd_pr__pfet_01v8_hvt ad=0.0864 pd=0.91 as=0.1645 ps=1.33 w=0.64 l=0.15
X3 a_872_316# a_600_345# a_788_316# VNB sky130_fd_pr__nfet_01v8 ad=0.1092 pd=1.36 as=0.05775 ps=0.695 w=0.42 l=0.15
X4 VPWR S0 a_27_47# VPB sky130_fd_pr__pfet_01v8_hvt ad=0.0864 pd=0.91 as=0.1664 ps=1.8 w=0.64 l=0.15
X5 a_1279_413# S0 a_872_316# VPB sky130_fd_pr__pfet_01v8_hvt ad=0.10535 pd=0.995 as=0.0567 ps=0.69 w=0.42 l=0.15
X6 VGND a_788_316# X VNB sky130_fd_pr__nfet_01v8 ad=0.221 pd=1.98 as=0.08775 ps=0.92 w=0.65 l=0.15
X7 a_1060_369# A1 VPWR VPB sky130_fd_pr__pfet_01v8_hvt ad=0.13775 pd=1.165 as=0.1664 ps=1.8 w=0.64 l=0.15
X8 a_872_316# a_27_47# a_1060_369# VPB sky130_fd_pr__pfet_01v8_hvt ad=0.0567 pd=0.69 as=0.13775 ps=1.165 w=0.42 l=0.15
X9 a_193_47# A2 VGND VNB sky130_fd_pr__nfet_01v8 ad=0.066 pd=0.745 as=0.0567 ps=0.69 w=0.42 l=0.15
X10 a_1064_47# A1 VGND VNB sky130_fd_pr__nfet_01v8 ad=0.0786 pd=0.805 as=0.1092 ps=1.36 w=0.42 l=0.15
X11 a_1281_47# a_27_47# a_872_316# VNB sky130_fd_pr__special_nfet_01v8 ad=0.066 pd=0.745 as=0.072 ps=0.76 w=0.36 l=0.15
X12 a_872_316# S1 a_788_316# VPB sky130_fd_pr__pfet_01v8_hvt ad=0.1404 pd=1.6 as=0.0729 ps=0.81 w=0.54 l=0.15
X13 a_872_316# S0 a_1064_47# VNB sky130_fd_pr__special_nfet_01v8 ad=0.072 pd=0.76 as=0.0786 ps=0.805 w=0.36 l=0.15
X14 X a_788_316# VGND VNB sky130_fd_pr__nfet_01v8 ad=0.08775 pd=0.92 as=0.10675 ps=1.005 w=0.65 l=0.15
X15 a_788_316# a_600_345# a_288_47# VPB sky130_fd_pr__pfet_01v8_hvt ad=0.0729 pd=0.81 as=0.1404 ps=1.6 w=0.54 l=0.15
X16 a_372_413# a_27_47# a_288_47# VPB sky130_fd_pr__pfet_01v8_hvt ad=0.1645 pd=1.33 as=0.0567 ps=0.69 w=0.42 l=0.15
X17 VGND A3 a_397_47# VNB sky130_fd_pr__nfet_01v8 ad=0.0819 pd=0.81 as=0.06705 ps=0.75 w=0.42 l=0.15
X18 a_600_345# S1 VGND VNB sky130_fd_pr__nfet_01v8 ad=0.1134 pd=1.38 as=0.0819 ps=0.81 w=0.42 l=0.15
X19 a_193_369# A2 VPWR VPB sky130_fd_pr__pfet_01v8_hvt ad=0.09575 pd=0.965 as=0.0864 ps=0.91 w=0.64 l=0.15
X20 VPWR a_788_316# X VPB sky130_fd_pr__pfet_01v8_hvt ad=0.34 pd=2.68 as=0.135 ps=1.27 w=1 l=0.15
X21 a_288_47# S0 a_193_369# VPB sky130_fd_pr__pfet_01v8_hvt ad=0.0567 pd=0.69 as=0.09575 ps=0.965 w=0.42 l=0.15
X22 VGND A0 a_1281_47# VNB sky130_fd_pr__nfet_01v8 ad=0.10675 pd=1.005 as=0.066 ps=0.745 w=0.42 l=0.15
X23 a_397_47# S0 a_288_47# VNB sky130_fd_pr__special_nfet_01v8 ad=0.06705 pd=0.75 as=0.0711 ps=0.755 w=0.36 l=0.15
X24 X a_788_316# VPWR VPB sky130_fd_pr__pfet_01v8_hvt ad=0.135 pd=1.27 as=0.154 ps=1.335 w=1 l=0.15
X25 a_288_47# a_27_47# a_193_47# VNB sky130_fd_pr__special_nfet_01v8 ad=0.0711 pd=0.755 as=0.066 ps=0.745 w=0.36 l=0.15
X26 VGND S0 a_27_47# VNB sky130_fd_pr__nfet_01v8 ad=0.0567 pd=0.69 as=0.1092 ps=1.36 w=0.42 l=0.15
X27 VPWR A0 a_1279_413# VPB sky130_fd_pr__pfet_01v8_hvt ad=0.154 pd=1.335 as=0.10535 ps=0.995 w=0.64 l=0.15
C0 a_27_47# A3 0.0128f
C1 A3 S0 0.06363f
C2 a_27_47# a_1060_369# 0.00149f
C3 a_372_413# a_27_47# 0.00271f
C4 a_372_413# S0 0
C5 a_1279_413# VGND 0
C6 a_788_316# a_288_47# 0.17643f
C7 a_193_47# a_288_47# 0
C8 a_1279_413# a_872_316# 0.00134f
C9 a_1281_47# VPWR 0
C10 VGND A3 0.04111f
C11 VPB S1 0.20632f
C12 a_27_47# a_288_47# 0.39481f
C13 a_288_47# S0 0.06956f
C14 a_1281_47# a_788_316# 0
C15 a_1060_369# a_872_316# 0.01364f
C16 a_600_345# A3 0.00325f
C17 VPWR a_788_316# 0.45321f
C18 a_372_413# a_600_345# 0
C19 VGND a_288_47# 0.09739f
C20 VPB A1 0.07895f
C21 a_1281_47# A0 0.00485f
C22 A2 a_288_47# 0.01726f
C23 a_1281_47# S0 0
C24 S1 A1 0.00634f
C25 A0 VPWR 0.01237f
C26 a_27_47# VPWR 0.18465f
C27 VPWR S0 0.09872f
C28 a_872_316# a_288_47# 0
C29 a_600_345# a_288_47# 0.18073f
C30 A0 a_788_316# 0.12948f
C31 a_27_47# a_788_316# 0.20254f
C32 a_788_316# S0 0.07731f
C33 a_27_47# a_193_47# 0
C34 a_193_47# S0 0.00126f
C35 a_1281_47# VGND 0.0043f
C36 a_397_47# A3 0
C37 VGND VPWR 0.05336f
C38 A2 VPWR 0.01341f
C39 a_1281_47# a_872_316# 0.00133f
C40 VPB A3 0.06193f
C41 a_872_316# VPWR 0.12667f
C42 VGND a_788_316# 0.09072f
C43 a_27_47# A0 0.06095f
C44 A0 S0 0.05335f
C45 a_600_345# VPWR 0.01842f
C46 a_27_47# S0 1.10794f
C47 a_193_47# VGND 0.00481f
C48 A3 S1 0.13241f
C49 a_193_47# A2 0.00551f
C50 a_872_316# a_788_316# 0.16928f
C51 X VPWR 0.19134f
C52 a_600_345# a_788_316# 0.02959f
C53 a_397_47# a_288_47# 0.00489f
C54 a_1064_47# A0 0
C55 a_27_47# a_1064_47# 0
C56 a_1064_47# S0 0
C57 A0 VGND 0.08471f
C58 X a_788_316# 0.1237f
C59 a_27_47# VGND 0.09816f
C60 VGND S0 0.23504f
C61 a_27_47# A2 0.13939f
C62 A2 S0 0.16999f
C63 VPB a_288_47# 0.02906f
C64 a_872_316# A0 0.01205f
C65 a_27_47# a_872_316# 0.22381f
C66 S1 a_288_47# 0.03104f
C67 a_872_316# S0 0.07699f
C68 a_27_47# a_600_345# 0.01966f
C69 a_600_345# S0 0.03236f
C70 a_1064_47# VGND 0.00247f
C71 A0 X 0.00759f
C72 a_27_47# X 0
C73 X S0 0.00119f
C74 VGND A2 0.04995f
C75 a_1064_47# a_872_316# 0.00857f
C76 a_872_316# VGND 0.17016f
C77 A1 a_288_47# 0
C78 VPB VPWR 0.18178f
C79 a_600_345# VGND 0.07766f
C80 VPWR S1 0.05589f
C81 a_372_413# A3 0.00104f
C82 a_600_345# a_872_316# 0.01396f
C83 VGND X 0.14375f
C84 VPB a_788_316# 0.08421f
C85 S1 a_788_316# 0.02715f
C86 a_397_47# S0 0.0014f
C87 VPWR A1 0.0121f
C88 a_288_47# a_193_369# 0.00332f
C89 VPB A0 0.05738f
C90 a_27_47# VPB 0.17328f
C91 A3 a_288_47# 0.06334f
C92 VPB S0 0.27433f
C93 a_372_413# a_288_47# 0.01579f
C94 A1 a_788_316# 0.00384f
C95 a_27_47# S1 0.00644f
C96 S1 S0 0.02008f
C97 a_397_47# VGND 0.00677f
C98 a_1279_413# VPWR 0.00423f
C99 VPB VGND 0.01357f
C100 a_600_345# a_397_47# 0
C101 VPB A2 0.04286f
C102 VPWR a_193_369# 0.00755f
C103 a_1279_413# a_788_316# 0.01019f
C104 VGND S1 0.03529f
C105 a_27_47# A1 0.01893f
C106 A1 S0 0.0608f
C107 VPWR A3 0.01888f
C108 VPB a_872_316# 0.0322f
C109 a_1060_369# VPWR 0.00541f
C110 a_372_413# VPWR 0.01083f
C111 a_600_345# VPB 0.08659f
C112 a_872_316# S1 0.00638f
C113 a_600_345# S1 0.23476f
C114 a_1060_369# a_788_316# 0.00342f
C115 VPB X 0.00515f
C116 a_1279_413# A0 0
C117 a_27_47# a_1279_413# 0.00105f
C118 VGND A1 0.04934f
C119 X S1 0
C120 a_1279_413# S0 0
C121 a_872_316# A1 0.1803f
C122 a_27_47# a_193_369# 0.00734f
C123 VPWR a_288_47# 0.30526f
C124 a_193_369# S0 0.00258f
C125 a_600_345# A1 0.02241f
C126 X VNB 0.02573f
C127 VGND VNB 0.96928f
C128 A0 VNB 0.12933f
C129 A1 VNB 0.14082f
C130 S1 VNB 0.29851f
C131 A3 VNB 0.118f
C132 VPWR VNB 0.79947f
C133 A2 VNB 0.1131f
C134 S0 VNB 0.48965f
C135 VPB VNB 1.66792f
C136 a_872_316# VNB 0.03249f
C137 a_600_345# VNB 0.1671f
C138 a_788_316# VNB 0.21903f
C139 a_288_47# VNB 0.02923f
C140 a_27_47# VNB 0.30392f
.ends

.subckt ZR_sky130_fd_sc_hd__xor2_2 VPWR VGND X B A VPB VNB a_470_47# a_27_297# a_470_297#
+ a_112_47#
X0 a_27_297# A VPWR VPB sky130_fd_pr__pfet_01v8_hvt ad=0.135 pd=1.27 as=0.135 ps=1.27 w=1 l=0.15
X1 a_470_47# A VGND VNB sky130_fd_pr__nfet_01v8 ad=0.08775 pd=0.92 as=0.08775 ps=0.92 w=0.65 l=0.15
X2 a_470_297# A VPWR VPB sky130_fd_pr__pfet_01v8_hvt ad=0.135 pd=1.27 as=0.135 ps=1.27 w=1 l=0.15
X3 VPWR A a_470_297# VPB sky130_fd_pr__pfet_01v8_hvt ad=0.135 pd=1.27 as=0.26 ps=2.52 w=1 l=0.15
X4 a_112_47# B VGND VNB sky130_fd_pr__nfet_01v8 ad=0.08775 pd=0.92 as=0.08775 ps=0.92 w=0.65 l=0.15
X5 a_470_47# B X VNB sky130_fd_pr__nfet_01v8 ad=0.169 pd=1.82 as=0.10563 ps=0.975 w=0.65 l=0.15
X6 VGND A a_112_47# VNB sky130_fd_pr__nfet_01v8 ad=0.08775 pd=0.92 as=0.08775 ps=0.92 w=0.65 l=0.15
X7 a_112_47# A VGND VNB sky130_fd_pr__nfet_01v8 ad=0.08775 pd=0.92 as=0.17875 ps=1.85 w=0.65 l=0.15
X8 VGND B a_112_47# VNB sky130_fd_pr__nfet_01v8 ad=0.169 pd=1.82 as=0.08775 ps=0.92 w=0.65 l=0.15
X9 VPWR A a_27_297# VPB sky130_fd_pr__pfet_01v8_hvt ad=0.135 pd=1.27 as=0.275 ps=2.55 w=1 l=0.15
X10 a_470_297# B VPWR VPB sky130_fd_pr__pfet_01v8_hvt ad=0.26 pd=2.52 as=0.1625 ps=1.325 w=1 l=0.15
X11 X a_112_47# VGND VNB sky130_fd_pr__nfet_01v8 ad=0.08775 pd=0.92 as=0.169 ps=1.82 w=0.65 l=0.15
X12 VPWR B a_470_297# VPB sky130_fd_pr__pfet_01v8_hvt ad=0.1625 pd=1.325 as=0.135 ps=1.27 w=1 l=0.15
X13 VGND a_112_47# X VNB sky130_fd_pr__nfet_01v8 ad=0.169 pd=1.82 as=0.08775 ps=0.92 w=0.65 l=0.15
X14 VGND A a_470_47# VNB sky130_fd_pr__nfet_01v8 ad=0.08775 pd=0.92 as=0.169 ps=1.82 w=0.65 l=0.15
X15 a_27_297# B a_112_47# VPB sky130_fd_pr__pfet_01v8_hvt ad=0.26 pd=2.52 as=0.135 ps=1.27 w=1 l=0.15
X16 X a_112_47# a_470_297# VPB sky130_fd_pr__pfet_01v8_hvt ad=0.135 pd=1.27 as=0.26 ps=2.52 w=1 l=0.15
X17 a_470_297# a_112_47# X VPB sky130_fd_pr__pfet_01v8_hvt ad=0.28 pd=2.56 as=0.135 ps=1.27 w=1 l=0.15
X18 X B a_470_47# VNB sky130_fd_pr__nfet_01v8 ad=0.10563 pd=0.975 as=0.08775 ps=0.92 w=0.65 l=0.15
X19 a_112_47# B a_27_297# VPB sky130_fd_pr__pfet_01v8_hvt ad=0.135 pd=1.27 as=0.135 ps=1.27 w=1 l=0.15
C0 VPWR VGND 0.03995f
C1 VPWR VPB 0.12036f
C2 A a_470_47# 0.10609f
C3 VPWR B 0.13042f
C4 X a_470_297# 0.11717f
C5 VGND a_27_297# 0.0208f
C6 VPB a_27_297# 0.00985f
C7 B a_27_297# 0.03782f
C8 VPWR A 0.06229f
C9 X a_470_47# 0.08512f
C10 A a_27_297# 0.02937f
C11 VPWR X 0.01803f
C12 X a_27_297# 0
C13 VPWR a_470_297# 0.46804f
C14 VGND a_112_47# 0.28821f
C15 VPB a_112_47# 0.0941f
C16 B a_112_47# 0.23765f
C17 a_27_297# a_470_297# 0.02665f
C18 VPWR a_470_47# 0
C19 A a_112_47# 0.38093f
C20 VGND VPB 0.00685f
C21 VPWR a_27_297# 0.34211f
C22 VGND B 0.16844f
C23 X a_112_47# 0.19434f
C24 VPB B 0.12356f
C25 a_112_47# a_470_297# 0.27101f
C26 VGND A 0.07341f
C27 VPB A 0.12564f
C28 A B 0.31387f
C29 a_112_47# a_470_47# 0.01892f
C30 X VGND 0.11113f
C31 X VPB 0.0139f
C32 VPWR a_112_47# 0.08916f
C33 X B 0.06038f
C34 VGND a_470_297# 0.00518f
C35 VPB a_470_297# 0.0229f
C36 B a_470_297# 0.04347f
C37 a_112_47# a_27_297# 0.16061f
C38 X A 0
C39 VGND a_470_47# 0.30483f
C40 A a_470_297# 0.02856f
C41 VPB a_470_47# 0
C42 B a_470_47# 0.05172f
C43 VGND VNB 0.71645f
C44 X VNB 0.07126f
C45 VPWR VNB 0.55256f
C46 B VNB 0.3851f
C47 A VNB 0.39149f
C48 VPB VNB 1.22494f
C49 a_470_47# VNB 0.01853f
C50 a_470_297# VNB 0.02289f
C51 a_27_297# VNB 0.02117f
C52 a_112_47# VNB 0.28506f
.ends

.subckt pmu clk delay_sel[2] path[0] path[1] path[2] path[3] path[4] path[5] path[6]
+ path[7] path_sel[0] path_sel[2] tdi tdo dc_inst.x9/a_247_21# dc_inst.x2.x5/a_27_47#
+ dc_inst.x6.net4 _23_/a_193_47# clkbuf_1_0__f_clk/a_110_47# clkbuf_0_clk/a_110_47#
+ dc_inst.x7.x8/a_27_47# _14_/a_218_374# dc_inst.x2.net15 dc_inst.x3.x5/a_27_47# dc_inst.x7.net9
+ dc_inst.x2.net10 _17_/a_574_297# dc_inst.x5.net10 clkload0/X dc_inst.x2.net6 dc_inst.x9/a_668_97#
+ _23_/a_1108_47# dc_inst.x4.x5/a_27_47# dc_inst.x3.net15 dc_inst.x7.x18/a_27_47#
+ dc_inst.x5.net8 dc_inst.x3.net11 dc_inst.x6.x14/a_27_47# _24_/a_1108_47# dc_inst.x4.x16/a_27_47#
+ dc_inst.x1.net17 dc_inst.x6.net13 dc_inst.x5.x10/a_27_47# dc_inst.x8/a_27_413# dc_inst.x5.x5/a_27_47#
+ dc_inst.x8/a_750_97# dc_inst.x2.x18/a_27_47# dc_inst.x3.x12/a_27_47# dc_inst.x6.net10
+ dc_inst.x10/a_218_47# dc_inst.x3.net4 dc_inst.x1.x14/a_27_47# _23_/a_1217_47# shadow_q
+ dc_inst.x1.x2/a_27_47# dc_inst.x4.net15 _25_/a_1108_47# _19_/a_109_297# dc_inst.x6.x5/a_27_47#
+ dc_inst.x6.net2 _24_/a_193_47# dc_inst.x2.net17 dc_inst.x7.net13 _18_/a_218_374#
+ dc_inst.x2.x2/a_27_47# _23_/a_448_47# dc_inst.x6.x20/a_27_47# dc_inst.x4.net5 dc_inst.x7.x5/a_27_47#
+ dc_inst.net7 _15_/a_872_316# dc_inst.x1.x20/a_27_47# _25_/a_1217_47# dc_inst.x3.x2/a_27_47#
+ dc_inst.x3.net17 dc_inst.x3.net13 dc_inst.x4.x2/a_27_47# dc_inst.x7.x15/a_27_47#
+ dc_inst.x1.net19 dc_inst.x6.net15 dc_inst.x10/a_76_199# dc_inst.x1.net15 dc_inst.x5.x17/a_27_47#
+ dc_inst.x6.x11/a_27_47# _18_/a_505_21# dc_inst.x3.x19/a_27_47# _15_/a_193_47# dc_inst.x4.x13/a_27_47#
+ dc_inst.x3.net2 _14_/a_439_47# dc_inst.x2.x15/a_27_47# dc_inst.x5.x2/a_27_47# dc_inst.x1.x9/a_27_47#
+ _14_/a_218_47# dc_inst.x4.net13 dc_inst.x9/a_277_47# dc_inst.x1.x11/a_27_47# dc_inst.x6.net8
+ _24_/a_1462_47# _24_/a_805_47# _15_/a_788_316# dc_inst.x1.net5 _25_/a_193_47# dc_inst.x2.net19
+ dc_inst.x7.net15 dc_inst.x6.x2/a_27_47# dc_inst.x7.net11 dc_inst.x8/a_923_363# _24_/a_448_47#
+ _03_ dc_inst.x4.net7 dc_inst.x2.x9/a_27_47# _25_/a_1462_47# _13_/a_112_47# dc_inst.x5.net17
+ dc_inst.x5.net13 _15_/a_600_345# dc_inst.x7.x2/a_27_47# dc_inst.x3.x9/a_27_47# dc_inst.x7.net2
+ _08_ dc_inst.x2.net3 dc_inst.x10/a_218_374# _04_ dc_inst.x6.net17 dc_inst.net4 dc_inst.x4.x9/a_27_47#
+ dc_inst.x3.net8 dc_inst.x6.x18/a_27_47# dc_inst.x1.net1 dc_inst.x7.x12/a_27_47#
+ _14_/a_76_199# _06_ dc_inst.x8/a_1290_413# dc_inst.x4.net19 dc_inst.x5.x14/a_27_47#
+ _24_/a_639_47# dc_inst.x5.x9/a_27_47# dc_inst.x3.x16/a_27_47# dc_inst.x4.x10/a_27_47#
+ dc_inst.x1.x18/a_27_47# dc_inst.x6.net6 _25_/a_805_47# dc_inst.x1.net7 dc_inst.x2.x12/a_27_47#
+ _25_/a_1270_413# dc_inst.x7.net17 dc_inst.x1.x6/a_27_47# dc_inst.x9/a_1290_413#
+ _25_/a_448_47# dc_inst.x9/a_923_363# dc_inst.x4.net9 dc_inst.x6.x9/a_27_47# dc_inst.x8/a_193_47#
+ dc_inst.x2.net1 dc_inst.x5.net19 dc_inst.x2.x6/a_27_47# dc_inst.x5.net15 dc_inst.x8/a_1478_413#
+ dc_inst.x5.x20/a_27_47# dc_inst.x9/a_27_413# dc_inst.x7.x9/a_27_47# dc_inst.x2.net5
+ dc_inst.x9/a_750_97# dc_inst.x9/a_1478_413# dc_inst.x3.x6/a_27_47# _19_/a_465_47#
+ dc_inst.x3.net1 dc_inst.x5.net3 clkload0/a_27_47# dc_inst.x1.net12 dc_inst.x4.x6/a_27_47#
+ dc_inst.x3.net6 dc_inst.x7.x19/a_27_47# dc_inst.x4.net17 _25_/a_639_47# dc_inst.x6.x15/a_27_47#
+ dc_inst.x1.net9 dc_inst.x4.x17/a_27_47# dc_inst.x5.x11/a_27_47# dc_inst.x7.net19
+ dc_inst.x2.x19/a_27_47# dc_inst.x5.x6/a_27_47# dc_inst.x3.x13/a_27_47# _17_/a_478_47#
+ dc_inst.x1.x15/a_27_47# se dc_inst.x1.x3/a_27_47# dc_inst.x2.net12 dc_inst.x4.net4
+ dc_inst.x6.x6/a_27_47# dc_inst.net8 dc_inst.x5.net1 _19_/a_205_47# dc_inst.x2.x3/a_27_47#
+ dc_inst.x7.x6/a_27_47# dc_inst.x3.net12 dc_inst.x5.net9 dc_inst.x5.net5 _23_/a_651_413#
+ dc_inst.x3.x3/a_27_47# _15_/a_288_47# dc_inst.x1.net14 dc_inst.x6.net1 _24_/a_651_413#
+ dc_inst.x4.x3/a_27_47# dc_inst.x7.x16/a_27_47# _15_/a_1060_369# dc_inst.x6.net3
+ dc_inst.x5.x18/a_27_47# dc_inst.x6.x12/a_27_47# _15_/a_397_47# dc_inst.x4.x14/a_27_47#
+ dc_inst.x2.net14 _25_/a_651_413# dc_inst.x5.x3/a_27_47# dc_inst.x3.x10/a_27_47#
+ dc_inst.x2.x16/a_27_47# dc_inst.x4.net6 dc_inst.x4.net2 dc_inst.x1.x12/a_27_47#
+ _24_/a_1270_413# _23_/a_27_47# dc_inst.net2 dc_inst.x7.net8 dc_inst.x2.net9 dc_inst.x6.x3/a_27_47#
+ dc_inst.x7.net4 dc_inst.x3.net14 dc_inst.x5.net7 dc_inst.net1 dc_inst.x4.x20/a_27_47#
+ dc_inst.x7.x3/a_27_47# dc_inst.x6.net12 dc_inst.x3.net3 _07_ dc_inst.x9/a_193_47#
+ _18_/a_439_47# _02_ _18_/a_218_47# clknet_1_1__leaf_clk _10_ dc_inst.x4.net1 dc_inst.x6.net5
+ dc_inst.x1.net6 _15_/a_193_369# dc_inst.net5 dc_inst.x1.net2 _13_/a_470_47# dc_inst.x6.x19/a_27_47#
+ dc_inst.x7.x13/a_27_47# dc_inst.x2.net16 rst _19_/a_193_297# dc_inst.x4.net8 dc_inst.x5.x15/a_27_47#
+ dc_inst.x3.x17/a_27_47# dc_inst.x4.x11/a_27_47# dc_inst.x1.x19/a_27_47# dc_inst.x2.x13/a_27_47#
+ dc_inst.x7.net10 dc_inst.x5.net14 dc_inst.x1.x7/a_27_47# _05_ dc_inst.x7.net6 dc_inst.x2.net7
+ _15_/a_372_413# dc_inst.x2.x7/a_27_47# clknet_0_clk _23_/a_543_47# clkbuf_1_1__f_clk/a_110_47#
+ dc_inst.x6.net14 dc_inst.x3.net5 _20_/a_470_297# dc_inst.x3.x7/a_27_47# _18_/a_76_199#
+ dc_inst.x3.net19 _14_/a_535_374# dc_inst.x4.net16 dc_inst.x4.net12 dc_inst.x6.net7
+ dc_inst.x1.net8 dc_inst.x1.net4 dc_inst.x4.x7/a_27_47# dc_inst.x7.net14 _15_/a_1281_47#
+ dc_inst.x2.net18 dc_inst.x4.net10 dc_inst.x7.net1 _20_/a_79_21# dc_inst.x6.x16/a_27_47#
+ dc_inst.x7.x10/a_27_47# dc_inst.x5.x12/a_27_47# dc_inst.x5.net16 dc_inst.x4.x18/a_27_47#
+ dc_inst.x5.x7/a_27_47# delay_sel[1] dc_inst.x3.x14/a_27_47# dc_inst.x1.x16/a_27_47#
+ dc_inst.x2.x10/a_27_47# dc_inst.x1.x4/a_27_47# dc_inst.x3.net18 _23_/a_1270_413#
+ dc_inst.x8/a_27_47# _15_/a_1279_413# dc_inst.x6.x7/a_27_47# dc_inst.x5.net4 _24_/a_543_47#
+ delay_sel[0] dc_inst.x10/a_505_21# dc_inst.x6.net16 dc_inst.x1.net16 dc_inst.x2.x4/a_27_47#
+ dc_inst.x3.net7 dc_inst.x7.x7/a_27_47# _18_/a_535_374# dc_inst.x8/a_834_97# dc_inst.x3.x20/a_27_47#
+ dc_inst.x4.net14 dc_inst.x3.x4/a_27_47# dc_inst.x6.net9 _24_/a_27_47# dc_inst.x6.net19
+ _16_/a_27_93# dc_inst.x7.net16 dc_inst.x7.net12 capture_q dc_inst.x4.x4/a_27_47#
+ dc_inst.x5.net18 dc_inst.x7.x17/a_27_47# _23_/a_1283_21# dc_inst.x8/a_247_21# dc_inst.x6.x13/a_27_47#
+ dc_inst.x5.x19/a_27_47# _00_ dc_inst.x4.x15/a_27_47# dc_inst.x7.net3 dc_inst.x2.net4
+ dc_inst.x5.x4/a_27_47# dc_inst.x3.x11/a_27_47# dc_inst.x2.x17/a_27_47# dc_inst.x3.net16
+ dc_inst.x1.x13/a_27_47# _24_/a_1283_21# dc_inst.x1.x1/a_27_47# _17_/a_174_21# dc_inst.x6.net18
+ dc_inst.x5.net2 _25_/a_543_47# dc_inst.x5.net12 dc_inst.x1.net18 dc_inst.x6.x4/a_27_47#
+ dc_inst.x8/a_668_97# _14_/a_505_21# dc_inst.x1.net11 _25_/a_1283_21# _20_/a_384_47#
+ dc_inst.x2.x1/a_27_47# dc_inst.x8/a_193_413# dc_inst.x7.x4/a_27_47# dc_inst.x7.net18
+ dc_inst.x3.x1/a_27_47# dc_inst.x2.net11 dc_inst.x10/a_535_374# dc_inst.x4.net3 dc_inst.x4.x1/a_27_47#
+ _19_/a_27_47# capture_d dc_inst.x7.x14/a_27_47# dc_inst.x7.net5 dc_inst.net6 dc_inst.x2.net2
+ dc_inst.x5.x16/a_27_47# dc_inst.x6.x10/a_27_47# dc_inst.x3.x18/a_27_47# dc_inst.x4.x12/a_27_47#
+ dc_inst.x2.x14/a_27_47# dc_inst.x5.x1/a_27_47# dc_inst.x1.x8/a_27_47# _15_/a_1064_47#
+ _15_/a_27_47# dc_inst.x1.x10/a_27_47# _09_ dc_inst.x1.net13 _13_/a_470_297# _01_
+ dc_inst.x8/a_757_363# dc_inst.x6.x1/a_27_47# dc_inst.x1.net10 dc_inst.x2.x8/a_27_47#
+ dc_inst.x4.net18 dc_inst.x7.x20/a_27_47# dc_inst.x9/a_193_413# _13_/a_27_297# dc_inst.in
+ dc_inst.x4.net11 dc_inst.x1.net3 dc_inst.x7.x1/a_27_47# dc_inst.x2.x20/a_27_47#
+ dc_inst.x3.x8/a_27_47# dc_inst.x2.net13 dc_inst.net3 _23_/a_761_289# dc_inst.x8/a_277_47#
+ dc_inst.net9 dc_inst.x7.net7 dc_inst.x5.net11 dc_inst.x4.x8/a_27_47# dc_inst.x2.net8
+ dc_inst.x6.x17/a_27_47# VPWR _24_/a_761_289# dc_inst.x7.x11/a_27_47# dc_inst.x9/a_834_97#
+ dc_inst.x4.x19/a_27_47# dc_inst.x5.x13/a_27_47# dc_inst.x3.net10 dc_inst.x5.net6
+ clknet_1_0__leaf_clk dc_inst.x5.x8/a_27_47# _25_/a_27_47# dc_inst.x3.x15/a_27_47#
+ path_sel[1] dc_inst.x1.x17/a_27_47# _17_/a_27_93# _16_/a_229_47# dc_inst.x2.x11/a_27_47#
+ VGND dc_inst.x1.x5/a_27_47# dc_inst.x6.net11 dc_inst.x3.net9 _25_/a_761_289# dc_inst.x9/a_27_47#
+ dc_inst.x9/a_757_363# dc_inst.x6.x8/a_27_47#
XPHY_EDGE_ROW_0_Left_12 VPWR VGND VPWR VGND ZR_sky130_fd_sc_hd__decap_3
Xdc_inst.x4.x10 VGND VPWR dc_inst.x4.net1 dc_inst.x4.net10 VPWR VGND dc_inst.x4.x10/a_27_47#
+ ZR_sky130_fd_sc_hd__buf_1
XFILLER_0_57 VPWR VGND VPWR VGND ZR_sky130_fd_sc_hd__decap_3
Xdc_inst.x6.x8 VGND VPWR dc_inst.x6.net9 dc_inst.x6.net8 VPWR VGND dc_inst.x6.x8/a_27_47#
+ ZR_sky130_fd_sc_hd__buf_1
Xdc_inst.x1.x13 VGND VPWR dc_inst.x1.net13 dc_inst.x1.net12 VPWR VGND dc_inst.x1.x13/a_27_47#
+ ZR_sky130_fd_sc_hd__buf_1
Xdc_inst.x3.x9 VGND VPWR dc_inst.x3.net10 dc_inst.x3.net9 VPWR VGND dc_inst.x3.x9/a_27_47#
+ ZR_sky130_fd_sc_hd__buf_1
Xdc_inst.x4.x11 VGND VPWR dc_inst.x4.net11 dc_inst.x4.net1 VPWR VGND dc_inst.x4.x11/a_27_47#
+ ZR_sky130_fd_sc_hd__buf_1
Xdc_inst.x1.x14 VGND VPWR dc_inst.x1.net14 dc_inst.x1.net13 VPWR VGND dc_inst.x1.x14/a_27_47#
+ ZR_sky130_fd_sc_hd__buf_1
Xdc_inst.x6.x9 VGND VPWR dc_inst.x6.net10 dc_inst.x6.net9 VPWR VGND dc_inst.x6.x9/a_27_47#
+ ZR_sky130_fd_sc_hd__buf_1
XPHY_EDGE_ROW_6_Right_6 VPWR VGND VPWR VGND ZR_sky130_fd_sc_hd__decap_3
XFILLER_6_35 VPWR VGND VPWR VGND ZR_sky130_fd_sc_hd__decap_3
Xdc_inst.x4.x12 VGND VPWR dc_inst.x4.net12 dc_inst.x4.net11 VPWR VGND dc_inst.x4.x12/a_27_47#
+ ZR_sky130_fd_sc_hd__buf_1
Xdc_inst.x7.x20 VGND VPWR dc_inst.net7 dc_inst.x7.net19 VPWR VGND dc_inst.x7.x20/a_27_47#
+ ZR_sky130_fd_sc_hd__buf_1
Xdc_inst.x1.x15 VGND VPWR dc_inst.x1.net15 dc_inst.x1.net14 VPWR VGND dc_inst.x1.x15/a_27_47#
+ ZR_sky130_fd_sc_hd__buf_1
Xdc_inst.x7.x10 VGND VPWR dc_inst.x7.net1 dc_inst.x7.net10 VPWR VGND dc_inst.x7.x10/a_27_47#
+ ZR_sky130_fd_sc_hd__buf_1
Xdc_inst.x4.x13 VGND VPWR dc_inst.x4.net13 dc_inst.x4.net12 VPWR VGND dc_inst.x4.x13/a_27_47#
+ ZR_sky130_fd_sc_hd__buf_1
Xdc_inst.x1.x16 VGND VPWR dc_inst.x1.net16 dc_inst.x1.net15 VPWR VGND dc_inst.x1.x16/a_27_47#
+ ZR_sky130_fd_sc_hd__buf_1
XPHY_EDGE_ROW_4_Left_16 VPWR VGND VPWR VGND ZR_sky130_fd_sc_hd__decap_3
Xdc_inst.x4.x14 VGND VPWR dc_inst.x4.net14 dc_inst.x4.net13 VPWR VGND dc_inst.x4.x14/a_27_47#
+ ZR_sky130_fd_sc_hd__buf_1
Xdc_inst.x7.x11 VGND VPWR dc_inst.x7.net11 dc_inst.x7.net1 VPWR VGND dc_inst.x7.x11/a_27_47#
+ ZR_sky130_fd_sc_hd__buf_1
Xdc_inst.x1.x17 VGND VPWR dc_inst.x1.net17 dc_inst.x1.net16 VPWR VGND dc_inst.x1.x17/a_27_47#
+ ZR_sky130_fd_sc_hd__buf_1
Xdc_inst.x1.x1 VGND VPWR dc_inst.x1.net2 dc_inst.in VPWR VGND dc_inst.x1.x1/a_27_47#
+ ZR_sky130_fd_sc_hd__buf_1
Xclkload0 VGND VPWR clknet_1_1__leaf_clk clkload0/X VPWR VGND clkload0/a_27_47# ZR_sky130_fd_sc_hd__clkbuf_4
Xdc_inst.x7.x12 VGND VPWR dc_inst.x7.net12 dc_inst.x7.net11 VPWR VGND dc_inst.x7.x12/a_27_47#
+ ZR_sky130_fd_sc_hd__buf_1
Xdc_inst.x4.x15 VGND VPWR dc_inst.x4.net15 dc_inst.x4.net14 VPWR VGND dc_inst.x4.x15/a_27_47#
+ ZR_sky130_fd_sc_hd__buf_1
Xdc_inst.x1.x18 VGND VPWR dc_inst.x1.net18 dc_inst.x1.net17 VPWR VGND dc_inst.x1.x18/a_27_47#
+ ZR_sky130_fd_sc_hd__buf_1
Xdc_inst.x4.x1 VGND VPWR dc_inst.x4.net2 dc_inst.net3 VPWR VGND dc_inst.x4.x1/a_27_47#
+ ZR_sky130_fd_sc_hd__buf_1
Xdc_inst.x1.x2 VGND VPWR dc_inst.x1.net3 dc_inst.x1.net2 VPWR VGND dc_inst.x1.x2/a_27_47#
+ ZR_sky130_fd_sc_hd__buf_1
Xdc_inst.x7.x1 VGND VPWR dc_inst.x7.net2 dc_inst.net6 VPWR VGND dc_inst.x7.x1/a_27_47#
+ ZR_sky130_fd_sc_hd__buf_1
Xdc_inst.x4.x16 VGND VPWR dc_inst.x4.net16 dc_inst.x4.net15 VPWR VGND dc_inst.x4.x16/a_27_47#
+ ZR_sky130_fd_sc_hd__buf_1
Xdc_inst.x4.x2 VGND VPWR dc_inst.x4.net3 dc_inst.x4.net2 VPWR VGND dc_inst.x4.x2/a_27_47#
+ ZR_sky130_fd_sc_hd__buf_1
Xdc_inst.x7.x13 VGND VPWR dc_inst.x7.net13 dc_inst.x7.net12 VPWR VGND dc_inst.x7.x13/a_27_47#
+ ZR_sky130_fd_sc_hd__buf_1
Xdc_inst.x1.x19 VGND VPWR dc_inst.x1.net19 dc_inst.x1.net18 VPWR VGND dc_inst.x1.x19/a_27_47#
+ ZR_sky130_fd_sc_hd__buf_1
Xdc_inst.x1.x3 VGND VPWR dc_inst.x1.net4 dc_inst.x1.net3 VPWR VGND dc_inst.x1.x3/a_27_47#
+ ZR_sky130_fd_sc_hd__buf_1
Xdc_inst.x7.x2 VGND VPWR dc_inst.x7.net3 dc_inst.x7.net2 VPWR VGND dc_inst.x7.x2/a_27_47#
+ ZR_sky130_fd_sc_hd__buf_1
XPHY_EDGE_ROW_1_Right_1 VPWR VGND VPWR VGND ZR_sky130_fd_sc_hd__decap_3
Xdc_inst.x7.x14 VGND VPWR dc_inst.x7.net14 dc_inst.x7.net13 VPWR VGND dc_inst.x7.x14/a_27_47#
+ ZR_sky130_fd_sc_hd__buf_1
Xdc_inst.x4.x17 VGND VPWR dc_inst.x4.net17 dc_inst.x4.net16 VPWR VGND dc_inst.x4.x17/a_27_47#
+ ZR_sky130_fd_sc_hd__buf_1
Xdc_inst.x4.x3 VGND VPWR dc_inst.x4.net4 dc_inst.x4.net3 VPWR VGND dc_inst.x4.x3/a_27_47#
+ ZR_sky130_fd_sc_hd__buf_1
Xdc_inst.x1.x4 VGND VPWR dc_inst.x1.net5 dc_inst.x1.net4 VPWR VGND dc_inst.x1.x4/a_27_47#
+ ZR_sky130_fd_sc_hd__buf_1
XPHY_EDGE_ROW_11_Left_23 VPWR VGND VPWR VGND ZR_sky130_fd_sc_hd__decap_3
X_25_ VGND VPWR VPWR VGND clknet_1_0__leaf_clk _00_ _03_ tdo _25_/a_1462_47# _25_/a_543_47#
+ _25_/a_651_413# _25_/a_193_47# _25_/a_805_47# _25_/a_448_47# _25_/a_639_47# _25_/a_1283_21#
+ _25_/a_761_289# _25_/a_1108_47# _25_/a_1217_47# _25_/a_1270_413# _25_/a_27_47# ZR_sky130_fd_sc_hd__dfrtp_2
Xdc_inst.x7.x3 VGND VPWR dc_inst.x7.net4 dc_inst.x7.net3 VPWR VGND dc_inst.x7.x3/a_27_47#
+ ZR_sky130_fd_sc_hd__buf_1
Xdc_inst.x4.x4 VGND VPWR dc_inst.x4.net5 dc_inst.x4.net4 VPWR VGND dc_inst.x4.x4/a_27_47#
+ ZR_sky130_fd_sc_hd__buf_1
Xclkbuf_0_clk VGND VPWR VGND VPWR clk clknet_0_clk clkbuf_0_clk/a_110_47# ZR_sky130_fd_sc_hd__clkbuf_16
Xdc_inst.x7.x15 VGND VPWR dc_inst.x7.net15 dc_inst.x7.net14 VPWR VGND dc_inst.x7.x15/a_27_47#
+ ZR_sky130_fd_sc_hd__buf_1
Xdc_inst.x4.x18 VGND VPWR dc_inst.x4.net18 dc_inst.x4.net17 VPWR VGND dc_inst.x4.x18/a_27_47#
+ ZR_sky130_fd_sc_hd__buf_1
Xdc_inst.x1.x5 VGND VPWR dc_inst.x1.net6 dc_inst.x1.net5 VPWR VGND dc_inst.x1.x5/a_27_47#
+ ZR_sky130_fd_sc_hd__buf_1
X_24_ VGND VPWR VPWR VGND clknet_1_1__leaf_clk capture_d _02_ capture_q _24_/a_1462_47#
+ _24_/a_543_47# _24_/a_651_413# _24_/a_193_47# _24_/a_805_47# _24_/a_448_47# _24_/a_639_47#
+ _24_/a_1283_21# _24_/a_761_289# _24_/a_1108_47# _24_/a_1217_47# _24_/a_1270_413#
+ _24_/a_27_47# ZR_sky130_fd_sc_hd__dfrtp_2
Xdc_inst.x7.x4 VGND VPWR dc_inst.x7.net5 dc_inst.x7.net4 VPWR VGND dc_inst.x7.x4/a_27_47#
+ ZR_sky130_fd_sc_hd__buf_1
Xdc_inst.x4.x19 VGND VPWR dc_inst.x4.net19 dc_inst.x4.net18 VPWR VGND dc_inst.x4.x19/a_27_47#
+ ZR_sky130_fd_sc_hd__buf_1
Xdc_inst.x4.x5 VGND VPWR dc_inst.x4.net6 dc_inst.x4.net5 VPWR VGND dc_inst.x4.x5/a_27_47#
+ ZR_sky130_fd_sc_hd__buf_1
Xdc_inst.x7.x16 VGND VPWR dc_inst.x7.net16 dc_inst.x7.net15 VPWR VGND dc_inst.x7.x16/a_27_47#
+ ZR_sky130_fd_sc_hd__buf_1
Xdc_inst.x1.x6 VGND VPWR dc_inst.x1.net7 dc_inst.x1.net6 VPWR VGND dc_inst.x1.x6/a_27_47#
+ ZR_sky130_fd_sc_hd__buf_1
X_23_ VGND VPWR VPWR VGND clknet_1_0__leaf_clk dc_inst.in _01_ shadow_q _23_/a_1462_47#
+ _23_/a_543_47# _23_/a_651_413# _23_/a_193_47# _23_/a_805_47# _23_/a_448_47# _23_/a_639_47#
+ _23_/a_1283_21# _23_/a_761_289# _23_/a_1108_47# _23_/a_1217_47# _23_/a_1270_413#
+ _23_/a_27_47# ZR_sky130_fd_sc_hd__dfrtp_2
Xdc_inst.x7.x5 VGND VPWR dc_inst.x7.net6 dc_inst.x7.net5 VPWR VGND dc_inst.x7.x5/a_27_47#
+ ZR_sky130_fd_sc_hd__buf_1
Xdc_inst.x4.x6 VGND VPWR dc_inst.x4.net7 dc_inst.x4.net6 VPWR VGND dc_inst.x4.x6/a_27_47#
+ ZR_sky130_fd_sc_hd__buf_1
XPHY_EDGE_ROW_5_Right_5 VPWR VGND VPWR VGND ZR_sky130_fd_sc_hd__decap_3
Xdc_inst.x7.x17 VGND VPWR dc_inst.x7.net17 dc_inst.x7.net16 VPWR VGND dc_inst.x7.x17/a_27_47#
+ ZR_sky130_fd_sc_hd__buf_1
Xdc_inst.x1.x7 VGND VPWR dc_inst.x1.net8 dc_inst.x1.net7 VPWR VGND dc_inst.x1.x7/a_27_47#
+ ZR_sky130_fd_sc_hd__buf_1
Xdc_inst.x3.x20 VPWR VGND dc_inst.net3 dc_inst.x3.net19 VPWR VGND dc_inst.x3.x20/a_27_47#
+ ZR_sky130_fd_sc_hd__buf_2
X_22_ rst _03_ VPWR VGND VPWR VGND ZR_sky130_fd_sc_hd__inv_2
Xdc_inst.x7.x6 VGND VPWR dc_inst.x7.net7 dc_inst.x7.net6 VPWR VGND dc_inst.x7.x6/a_27_47#
+ ZR_sky130_fd_sc_hd__buf_1
Xdc_inst.x4.x7 VGND VPWR dc_inst.x4.net8 dc_inst.x4.net7 VPWR VGND dc_inst.x4.x7/a_27_47#
+ ZR_sky130_fd_sc_hd__buf_1
XPHY_EDGE_ROW_11_Right_11 VPWR VGND VPWR VGND ZR_sky130_fd_sc_hd__decap_3
Xdc_inst.x3.x10 VGND VPWR dc_inst.x3.net1 dc_inst.x3.net10 VPWR VGND dc_inst.x3.x10/a_27_47#
+ ZR_sky130_fd_sc_hd__buf_1
Xdc_inst.x7.x18 VGND VPWR dc_inst.x7.net18 dc_inst.x7.net17 VPWR VGND dc_inst.x7.x18/a_27_47#
+ ZR_sky130_fd_sc_hd__buf_1
Xdc_inst.x1.x8 VGND VPWR dc_inst.x1.net9 dc_inst.x1.net8 VPWR VGND dc_inst.x1.x8/a_27_47#
+ ZR_sky130_fd_sc_hd__buf_1
Xdc_inst.x8 VGND VPWR VGND VPWR dc_inst.net1 dc_inst.in delay_sel[0] dc_inst.net3
+ dc_inst.net2 delay_sel[1] dc_inst.net8 dc_inst.x8/a_1290_413# dc_inst.x8/a_757_363#
+ dc_inst.x8/a_1478_413# dc_inst.x8/a_277_47# dc_inst.x8/a_750_97# dc_inst.x8/a_27_413#
+ dc_inst.x8/a_923_363# dc_inst.x8/a_193_47# dc_inst.x8/a_834_97# dc_inst.x8/a_247_21#
+ dc_inst.x8/a_668_97# dc_inst.x8/a_193_413# dc_inst.x8/a_27_47# ZR_sky130_fd_sc_hd__mux4_1
XPHY_EDGE_ROW_3_Left_15 VPWR VGND VPWR VGND ZR_sky130_fd_sc_hd__decap_3
Xdc_inst.x7.x7 VGND VPWR dc_inst.x7.net8 dc_inst.x7.net7 VPWR VGND dc_inst.x7.x7/a_27_47#
+ ZR_sky130_fd_sc_hd__buf_1
X_21_ rst _02_ VPWR VGND VPWR VGND ZR_sky130_fd_sc_hd__inv_2
Xdc_inst.x4.x8 VGND VPWR dc_inst.x4.net9 dc_inst.x4.net8 VPWR VGND dc_inst.x4.x8/a_27_47#
+ ZR_sky130_fd_sc_hd__buf_1
Xdc_inst.x7.x19 VGND VPWR dc_inst.x7.net19 dc_inst.x7.net18 VPWR VGND dc_inst.x7.x19/a_27_47#
+ ZR_sky130_fd_sc_hd__buf_1
Xdc_inst.x3.x11 VGND VPWR dc_inst.x3.net11 dc_inst.x3.net1 VPWR VGND dc_inst.x3.x11/a_27_47#
+ ZR_sky130_fd_sc_hd__buf_1
Xdc_inst.x1.x9 VGND VPWR dc_inst.x1.net10 dc_inst.x1.net9 VPWR VGND dc_inst.x1.x9/a_27_47#
+ ZR_sky130_fd_sc_hd__buf_1
Xdc_inst.x9 VGND VPWR VGND VPWR dc_inst.net5 dc_inst.net4 delay_sel[0] dc_inst.net7
+ dc_inst.net6 delay_sel[1] dc_inst.net9 dc_inst.x9/a_1290_413# dc_inst.x9/a_757_363#
+ dc_inst.x9/a_1478_413# dc_inst.x9/a_277_47# dc_inst.x9/a_750_97# dc_inst.x9/a_27_413#
+ dc_inst.x9/a_923_363# dc_inst.x9/a_193_47# dc_inst.x9/a_834_97# dc_inst.x9/a_247_21#
+ dc_inst.x9/a_668_97# dc_inst.x9/a_193_413# dc_inst.x9/a_27_47# ZR_sky130_fd_sc_hd__mux4_1
XFILLER_1_57 VPWR VGND VPWR VGND ZR_sky130_fd_sc_hd__decap_3
Xdc_inst.x7.x8 VGND VPWR dc_inst.x7.net9 dc_inst.x7.net8 VPWR VGND dc_inst.x7.x8/a_27_47#
+ ZR_sky130_fd_sc_hd__buf_1
X_20_ VGND VPWR VGND VPWR dc_inst.in _10_ _06_ _04_ _20_/a_384_47# _20_/a_470_297#
+ _20_/a_79_21# ZR_sky130_fd_sc_hd__o21a_2
Xdc_inst.x4.x9 VGND VPWR dc_inst.x4.net10 dc_inst.x4.net9 VPWR VGND dc_inst.x4.x9/a_27_47#
+ ZR_sky130_fd_sc_hd__buf_1
XPHY_EDGE_ROW_9_Right_9 VPWR VGND VPWR VGND ZR_sky130_fd_sc_hd__decap_3
Xdc_inst.x3.x12 VGND VPWR dc_inst.x3.net12 dc_inst.x3.net11 VPWR VGND dc_inst.x3.x12/a_27_47#
+ ZR_sky130_fd_sc_hd__buf_1
Xdc_inst.x6.x20 VPWR VGND dc_inst.net6 dc_inst.x6.net19 VPWR VGND dc_inst.x6.x20/a_27_47#
+ ZR_sky130_fd_sc_hd__buf_2
Xdc_inst.x7.x9 VGND VPWR dc_inst.x7.net10 dc_inst.x7.net9 VPWR VGND dc_inst.x7.x9/a_27_47#
+ ZR_sky130_fd_sc_hd__buf_1
Xdc_inst.x6.x10 VGND VPWR dc_inst.x6.net1 dc_inst.x6.net10 VPWR VGND dc_inst.x6.x10/a_27_47#
+ ZR_sky130_fd_sc_hd__buf_1
Xdc_inst.x3.x13 VGND VPWR dc_inst.x3.net13 dc_inst.x3.net12 VPWR VGND dc_inst.x3.x13/a_27_47#
+ ZR_sky130_fd_sc_hd__buf_1
XPHY_EDGE_ROW_7_Left_19 VPWR VGND VPWR VGND ZR_sky130_fd_sc_hd__decap_3
XPHY_EDGE_ROW_0_Right_0 VPWR VGND VPWR VGND ZR_sky130_fd_sc_hd__decap_3
Xdc_inst.x6.x11 VGND VPWR dc_inst.x6.net11 dc_inst.x6.net1 VPWR VGND dc_inst.x6.x11/a_27_47#
+ ZR_sky130_fd_sc_hd__buf_1
Xdc_inst.x3.x14 VGND VPWR dc_inst.x3.net14 dc_inst.x3.net13 VPWR VGND dc_inst.x3.x14/a_27_47#
+ ZR_sky130_fd_sc_hd__buf_1
Xdc_inst.x6.x12 VGND VPWR dc_inst.x6.net12 dc_inst.x6.net11 VPWR VGND dc_inst.x6.x12/a_27_47#
+ ZR_sky130_fd_sc_hd__buf_1
XPHY_EDGE_ROW_10_Left_22 VPWR VGND VPWR VGND ZR_sky130_fd_sc_hd__decap_3
Xdc_inst.x3.x15 VGND VPWR dc_inst.x3.net15 dc_inst.x3.net14 VPWR VGND dc_inst.x3.x15/a_27_47#
+ ZR_sky130_fd_sc_hd__buf_1
Xdc_inst.x2.x1 VGND VPWR dc_inst.x2.net2 dc_inst.net1 VPWR VGND dc_inst.x2.x1/a_27_47#
+ ZR_sky130_fd_sc_hd__buf_1
Xdc_inst.x6.x13 VGND VPWR dc_inst.x6.net13 dc_inst.x6.net12 VPWR VGND dc_inst.x6.x13/a_27_47#
+ ZR_sky130_fd_sc_hd__buf_1
Xdc_inst.x5.x1 VGND VPWR dc_inst.x5.net2 dc_inst.net4 VPWR VGND dc_inst.x5.x1/a_27_47#
+ ZR_sky130_fd_sc_hd__buf_1
Xdc_inst.x3.x16 VGND VPWR dc_inst.x3.net16 dc_inst.x3.net15 VPWR VGND dc_inst.x3.x16/a_27_47#
+ ZR_sky130_fd_sc_hd__buf_1
Xdc_inst.x2.x2 VGND VPWR dc_inst.x2.net3 dc_inst.x2.net2 VPWR VGND dc_inst.x2.x2/a_27_47#
+ ZR_sky130_fd_sc_hd__buf_1
Xdc_inst.x6.x14 VGND VPWR dc_inst.x6.net14 dc_inst.x6.net13 VPWR VGND dc_inst.x6.x14/a_27_47#
+ ZR_sky130_fd_sc_hd__buf_1
XPHY_EDGE_ROW_4_Right_4 VPWR VGND VPWR VGND ZR_sky130_fd_sc_hd__decap_3
Xdc_inst.x3.x17 VGND VPWR dc_inst.x3.net17 dc_inst.x3.net16 VPWR VGND dc_inst.x3.x17/a_27_47#
+ ZR_sky130_fd_sc_hd__buf_1
Xdc_inst.x5.x2 VGND VPWR dc_inst.x5.net3 dc_inst.x5.net2 VPWR VGND dc_inst.x5.x2/a_27_47#
+ ZR_sky130_fd_sc_hd__buf_1
Xdc_inst.x2.x3 VGND VPWR dc_inst.x2.net4 dc_inst.x2.net3 VPWR VGND dc_inst.x2.x3/a_27_47#
+ ZR_sky130_fd_sc_hd__buf_1
Xdc_inst.x6.x15 VGND VPWR dc_inst.x6.net15 dc_inst.x6.net14 VPWR VGND dc_inst.x6.x15/a_27_47#
+ ZR_sky130_fd_sc_hd__buf_1
Xdc_inst.x5.x3 VGND VPWR dc_inst.x5.net4 dc_inst.x5.net3 VPWR VGND dc_inst.x5.x3/a_27_47#
+ ZR_sky130_fd_sc_hd__buf_1
Xdc_inst.x3.x18 VGND VPWR dc_inst.x3.net18 dc_inst.x3.net17 VPWR VGND dc_inst.x3.x18/a_27_47#
+ ZR_sky130_fd_sc_hd__buf_1
Xdc_inst.x2.x4 VGND VPWR dc_inst.x2.net5 dc_inst.x2.net4 VPWR VGND dc_inst.x2.x4/a_27_47#
+ ZR_sky130_fd_sc_hd__buf_1
XPHY_EDGE_ROW_2_Left_14 VPWR VGND VPWR VGND ZR_sky130_fd_sc_hd__decap_3
Xdc_inst.x6.x16 VGND VPWR dc_inst.x6.net16 dc_inst.x6.net15 VPWR VGND dc_inst.x6.x16/a_27_47#
+ ZR_sky130_fd_sc_hd__buf_1
Xclkbuf_1_0__f_clk VGND VPWR VGND VPWR clknet_0_clk clknet_1_0__leaf_clk clkbuf_1_0__f_clk/a_110_47#
+ ZR_sky130_fd_sc_hd__clkbuf_16
Xdc_inst.x3.x19 VGND VPWR dc_inst.x3.net19 dc_inst.x3.net18 VPWR VGND dc_inst.x3.x19/a_27_47#
+ ZR_sky130_fd_sc_hd__buf_1
Xdc_inst.x5.x4 VGND VPWR dc_inst.x5.net5 dc_inst.x5.net4 VPWR VGND dc_inst.x5.x4/a_27_47#
+ ZR_sky130_fd_sc_hd__buf_1
Xdc_inst.x2.x5 VGND VPWR dc_inst.x2.net6 dc_inst.x2.net5 VPWR VGND dc_inst.x2.x5/a_27_47#
+ ZR_sky130_fd_sc_hd__buf_1
Xdc_inst.x6.x17 VGND VPWR dc_inst.x6.net17 dc_inst.x6.net16 VPWR VGND dc_inst.x6.x17/a_27_47#
+ ZR_sky130_fd_sc_hd__buf_1
XPHY_EDGE_ROW_10_Right_10 VPWR VGND VPWR VGND ZR_sky130_fd_sc_hd__decap_3
Xdc_inst.x5.x5 VGND VPWR dc_inst.x5.net6 dc_inst.x5.net5 VPWR VGND dc_inst.x5.x5/a_27_47#
+ ZR_sky130_fd_sc_hd__buf_1
Xdc_inst.x2.x20 VPWR VGND dc_inst.net2 dc_inst.x2.net19 VPWR VGND dc_inst.x2.x20/a_27_47#
+ ZR_sky130_fd_sc_hd__buf_2
Xdc_inst.x2.x6 VGND VPWR dc_inst.x2.net7 dc_inst.x2.net6 VPWR VGND dc_inst.x2.x6/a_27_47#
+ ZR_sky130_fd_sc_hd__buf_1
XFILLER_5_31 VPWR VGND VPWR VGND ZR_sky130_fd_sc_hd__decap_3
XPHY_EDGE_ROW_8_Right_8 VPWR VGND VPWR VGND ZR_sky130_fd_sc_hd__decap_3
Xdc_inst.x6.x18 VGND VPWR dc_inst.x6.net18 dc_inst.x6.net17 VPWR VGND dc_inst.x6.x18/a_27_47#
+ ZR_sky130_fd_sc_hd__buf_1
Xdc_inst.x2.x10 VGND VPWR dc_inst.x2.net1 dc_inst.x2.net10 VPWR VGND dc_inst.x2.x10/a_27_47#
+ ZR_sky130_fd_sc_hd__buf_1
Xdc_inst.x5.x6 VGND VPWR dc_inst.x5.net7 dc_inst.x5.net6 VPWR VGND dc_inst.x5.x6/a_27_47#
+ ZR_sky130_fd_sc_hd__buf_1
Xdc_inst.x2.x7 VGND VPWR dc_inst.x2.net8 dc_inst.x2.net7 VPWR VGND dc_inst.x2.x7/a_27_47#
+ ZR_sky130_fd_sc_hd__buf_1
Xdc_inst.x6.x19 VGND VPWR dc_inst.x6.net19 dc_inst.x6.net18 VPWR VGND dc_inst.x6.x19/a_27_47#
+ ZR_sky130_fd_sc_hd__buf_1
XPHY_EDGE_ROW_6_Left_18 VPWR VGND VPWR VGND ZR_sky130_fd_sc_hd__decap_3
Xdc_inst.x5.x7 VGND VPWR dc_inst.x5.net8 dc_inst.x5.net7 VPWR VGND dc_inst.x5.x7/a_27_47#
+ ZR_sky130_fd_sc_hd__buf_1
Xdc_inst.x2.x11 VGND VPWR dc_inst.x2.net11 dc_inst.x2.net1 VPWR VGND dc_inst.x2.x11/a_27_47#
+ ZR_sky130_fd_sc_hd__buf_1
X_19_ VPWR VGND VPWR VGND path_sel[2] path_sel[1] _09_ _07_ _08_ _10_ _19_/a_193_297#
+ _19_/a_465_47# _19_/a_205_47# _19_/a_109_297# _19_/a_27_47# ZR_sky130_fd_sc_hd__a221o_2
Xdc_inst.x2.x8 VGND VPWR dc_inst.x2.net9 dc_inst.x2.net8 VPWR VGND dc_inst.x2.x8/a_27_47#
+ ZR_sky130_fd_sc_hd__buf_1
XPHY_EDGE_ROW_9_Left_21 VPWR VGND VPWR VGND ZR_sky130_fd_sc_hd__decap_3
Xdc_inst.x5.x20 VPWR VGND dc_inst.net5 dc_inst.x5.net19 VPWR VGND dc_inst.x5.x20/a_27_47#
+ ZR_sky130_fd_sc_hd__buf_2
Xdc_inst.x5.x8 VGND VPWR dc_inst.x5.net9 dc_inst.x5.net8 VPWR VGND dc_inst.x5.x8/a_27_47#
+ ZR_sky130_fd_sc_hd__buf_1
Xdc_inst.x2.x12 VGND VPWR dc_inst.x2.net12 dc_inst.x2.net11 VPWR VGND dc_inst.x2.x12/a_27_47#
+ ZR_sky130_fd_sc_hd__buf_1
X_18_ VGND VPWR VPWR VGND _09_ path[3] path_sel[0] path[2] _18_/a_505_21# _18_/a_535_374#
+ _18_/a_439_47# _18_/a_218_47# _18_/a_76_199# _18_/a_218_374# ZR_sky130_fd_sc_hd__mux2_1
Xdc_inst.x2.x9 VGND VPWR dc_inst.x2.net10 dc_inst.x2.net9 VPWR VGND dc_inst.x2.x9/a_27_47#
+ ZR_sky130_fd_sc_hd__buf_1
Xdc_inst.x5.x9 VGND VPWR dc_inst.x5.net10 dc_inst.x5.net9 VPWR VGND dc_inst.x5.x9/a_27_47#
+ ZR_sky130_fd_sc_hd__buf_1
Xdc_inst.x5.x10 VGND VPWR dc_inst.x5.net1 dc_inst.x5.net10 VPWR VGND dc_inst.x5.x10/a_27_47#
+ ZR_sky130_fd_sc_hd__buf_1
X_17_ VGND VPWR VGND VPWR path_sel[0] path[0] path_sel[1] _08_ _17_/a_478_47# _17_/a_27_93#
+ _17_/a_574_297# _17_/a_174_21# ZR_sky130_fd_sc_hd__o21ba_2
Xdc_inst.x2.x13 VGND VPWR dc_inst.x2.net13 dc_inst.x2.net12 VPWR VGND dc_inst.x2.x13/a_27_47#
+ ZR_sky130_fd_sc_hd__buf_1
Xdc_inst.x5.x11 VGND VPWR dc_inst.x5.net11 dc_inst.x5.net1 VPWR VGND dc_inst.x5.x11/a_27_47#
+ ZR_sky130_fd_sc_hd__buf_1
X_16_ VGND VPWR VGND VPWR path[1] _07_ path_sel[0] _16_/a_229_47# _16_/a_27_93# ZR_sky130_fd_sc_hd__nand2b_2
Xdc_inst.x2.x14 VGND VPWR dc_inst.x2.net14 dc_inst.x2.net13 VPWR VGND dc_inst.x2.x14/a_27_47#
+ ZR_sky130_fd_sc_hd__buf_1
XPHY_EDGE_ROW_3_Right_3 VPWR VGND VPWR VGND ZR_sky130_fd_sc_hd__decap_3
Xclkbuf_1_1__f_clk VGND VPWR VGND VPWR clknet_0_clk clknet_1_1__leaf_clk clkbuf_1_1__f_clk/a_110_47#
+ ZR_sky130_fd_sc_hd__clkbuf_16
Xdc_inst.x5.x12 VGND VPWR dc_inst.x5.net12 dc_inst.x5.net11 VPWR VGND dc_inst.x5.x12/a_27_47#
+ ZR_sky130_fd_sc_hd__buf_1
Xdc_inst.x2.x15 VGND VPWR dc_inst.x2.net15 dc_inst.x2.net14 VPWR VGND dc_inst.x2.x15/a_27_47#
+ ZR_sky130_fd_sc_hd__buf_1
X_15_ VGND VPWR VGND VPWR path_sel[0] path[6] path[7] path_sel[1] path[5] path[4]
+ _06_ _15_/a_193_369# _15_/a_372_413# _15_/a_1281_47# _15_/a_193_47# _15_/a_1064_47#
+ _15_/a_1060_369# _15_/a_288_47# _15_/a_397_47# _15_/a_872_316# _15_/a_1279_413#
+ _15_/a_788_316# _15_/a_600_345# _15_/a_27_47# ZR_sky130_fd_sc_hd__mux4_2
XPHY_EDGE_ROW_1_Left_13 VPWR VGND VPWR VGND ZR_sky130_fd_sc_hd__decap_3
Xdc_inst.x5.x13 VGND VPWR dc_inst.x5.net13 dc_inst.x5.net12 VPWR VGND dc_inst.x5.x13/a_27_47#
+ ZR_sky130_fd_sc_hd__buf_1
Xdc_inst.x2.x16 VGND VPWR dc_inst.x2.net16 dc_inst.x2.net15 VPWR VGND dc_inst.x2.x16/a_27_47#
+ ZR_sky130_fd_sc_hd__buf_1
X_14_ VGND VPWR VPWR VGND _00_ tdi se _05_ _14_/a_505_21# _14_/a_535_374# _14_/a_439_47#
+ _14_/a_218_47# _14_/a_76_199# _14_/a_218_374# ZR_sky130_fd_sc_hd__mux2_1
Xdc_inst.x3.x1 VGND VPWR dc_inst.x3.net2 dc_inst.net2 VPWR VGND dc_inst.x3.x1/a_27_47#
+ ZR_sky130_fd_sc_hd__buf_1
Xdc_inst.x10 VGND VPWR VPWR VGND capture_d dc_inst.net9 delay_sel[2] dc_inst.net8
+ dc_inst.x10/a_505_21# dc_inst.x10/a_535_374# dc_inst.x10/a_439_47# dc_inst.x10/a_218_47#
+ dc_inst.x10/a_76_199# dc_inst.x10/a_218_374# ZR_sky130_fd_sc_hd__mux2_1
Xdc_inst.x5.x14 VGND VPWR dc_inst.x5.net14 dc_inst.x5.net13 VPWR VGND dc_inst.x5.x14/a_27_47#
+ ZR_sky130_fd_sc_hd__buf_1
Xdc_inst.x2.x17 VGND VPWR dc_inst.x2.net17 dc_inst.x2.net16 VPWR VGND dc_inst.x2.x17/a_27_47#
+ ZR_sky130_fd_sc_hd__buf_1
Xdc_inst.x6.x1 VGND VPWR dc_inst.x6.net2 dc_inst.net5 VPWR VGND dc_inst.x6.x1/a_27_47#
+ ZR_sky130_fd_sc_hd__buf_1
X_13_ VPWR VGND _05_ shadow_q capture_q VPWR VGND _13_/a_470_47# _13_/a_27_297# _13_/a_470_297#
+ _13_/a_112_47# ZR_sky130_fd_sc_hd__xor2_2
XPHY_EDGE_ROW_7_Right_7 VPWR VGND VPWR VGND ZR_sky130_fd_sc_hd__decap_3
Xdc_inst.x3.x2 VGND VPWR dc_inst.x3.net3 dc_inst.x3.net2 VPWR VGND dc_inst.x3.x2/a_27_47#
+ ZR_sky130_fd_sc_hd__buf_1
Xdc_inst.x5.x15 VGND VPWR dc_inst.x5.net15 dc_inst.x5.net14 VPWR VGND dc_inst.x5.x15/a_27_47#
+ ZR_sky130_fd_sc_hd__buf_1
Xdc_inst.x2.x18 VGND VPWR dc_inst.x2.net18 dc_inst.x2.net17 VPWR VGND dc_inst.x2.x18/a_27_47#
+ ZR_sky130_fd_sc_hd__buf_1
X_12_ rst _01_ VPWR VGND VPWR VGND ZR_sky130_fd_sc_hd__inv_2
Xdc_inst.x6.x2 VGND VPWR dc_inst.x6.net3 dc_inst.x6.net2 VPWR VGND dc_inst.x6.x2/a_27_47#
+ ZR_sky130_fd_sc_hd__buf_1
Xdc_inst.x3.x3 VGND VPWR dc_inst.x3.net4 dc_inst.x3.net3 VPWR VGND dc_inst.x3.x3/a_27_47#
+ ZR_sky130_fd_sc_hd__buf_1
Xdc_inst.x5.x16 VGND VPWR dc_inst.x5.net16 dc_inst.x5.net15 VPWR VGND dc_inst.x5.x16/a_27_47#
+ ZR_sky130_fd_sc_hd__buf_1
XPHY_EDGE_ROW_5_Left_17 VPWR VGND VPWR VGND ZR_sky130_fd_sc_hd__decap_3
X_11_ path_sel[2] _04_ VPWR VGND VPWR VGND ZR_sky130_fd_sc_hd__inv_2
Xdc_inst.x2.x19 VGND VPWR dc_inst.x2.net19 dc_inst.x2.net18 VPWR VGND dc_inst.x2.x19/a_27_47#
+ ZR_sky130_fd_sc_hd__buf_1
Xdc_inst.x6.x3 VGND VPWR dc_inst.x6.net4 dc_inst.x6.net3 VPWR VGND dc_inst.x6.x3/a_27_47#
+ ZR_sky130_fd_sc_hd__buf_1
XPHY_EDGE_ROW_8_Left_20 VPWR VGND VPWR VGND ZR_sky130_fd_sc_hd__decap_3
Xdc_inst.x3.x4 VGND VPWR dc_inst.x3.net5 dc_inst.x3.net4 VPWR VGND dc_inst.x3.x4/a_27_47#
+ ZR_sky130_fd_sc_hd__buf_1
Xdc_inst.x5.x17 VGND VPWR dc_inst.x5.net17 dc_inst.x5.net16 VPWR VGND dc_inst.x5.x17/a_27_47#
+ ZR_sky130_fd_sc_hd__buf_1
Xdc_inst.x1.x20 VPWR VGND dc_inst.net1 dc_inst.x1.net19 VPWR VGND dc_inst.x1.x20/a_27_47#
+ ZR_sky130_fd_sc_hd__buf_2
XFILLER_0_53 VPWR VGND VPWR VGND ZR_sky130_fd_sc_hd__decap_3
Xdc_inst.x6.x4 VGND VPWR dc_inst.x6.net5 dc_inst.x6.net4 VPWR VGND dc_inst.x6.x4/a_27_47#
+ ZR_sky130_fd_sc_hd__buf_1
Xdc_inst.x3.x5 VGND VPWR dc_inst.x3.net6 dc_inst.x3.net5 VPWR VGND dc_inst.x3.x5/a_27_47#
+ ZR_sky130_fd_sc_hd__buf_1
Xdc_inst.x5.x18 VGND VPWR dc_inst.x5.net18 dc_inst.x5.net17 VPWR VGND dc_inst.x5.x18/a_27_47#
+ ZR_sky130_fd_sc_hd__buf_1
Xdc_inst.x1.x10 VGND VPWR dc_inst.x1.net1 dc_inst.x1.net10 VPWR VGND dc_inst.x1.x10/a_27_47#
+ ZR_sky130_fd_sc_hd__buf_1
Xdc_inst.x6.x5 VGND VPWR dc_inst.x6.net6 dc_inst.x6.net5 VPWR VGND dc_inst.x6.x5/a_27_47#
+ ZR_sky130_fd_sc_hd__buf_1
Xdc_inst.x3.x6 VGND VPWR dc_inst.x3.net7 dc_inst.x3.net6 VPWR VGND dc_inst.x3.x6/a_27_47#
+ ZR_sky130_fd_sc_hd__buf_1
Xdc_inst.x1.x11 VGND VPWR dc_inst.x1.net11 dc_inst.x1.net1 VPWR VGND dc_inst.x1.x11/a_27_47#
+ ZR_sky130_fd_sc_hd__buf_1
Xdc_inst.x5.x19 VGND VPWR dc_inst.x5.net19 dc_inst.x5.net18 VPWR VGND dc_inst.x5.x19/a_27_47#
+ ZR_sky130_fd_sc_hd__buf_1
Xdc_inst.x6.x6 VGND VPWR dc_inst.x6.net7 dc_inst.x6.net6 VPWR VGND dc_inst.x6.x6/a_27_47#
+ ZR_sky130_fd_sc_hd__buf_1
XPHY_EDGE_ROW_2_Right_2 VPWR VGND VPWR VGND ZR_sky130_fd_sc_hd__decap_3
Xdc_inst.x3.x7 VGND VPWR dc_inst.x3.net8 dc_inst.x3.net7 VPWR VGND dc_inst.x3.x7/a_27_47#
+ ZR_sky130_fd_sc_hd__buf_1
XFILLER_6_32 VPWR VGND VPWR VGND ZR_sky130_fd_sc_hd__decap_3
Xdc_inst.x4.x20 VPWR VGND dc_inst.net4 dc_inst.x4.net19 VPWR VGND dc_inst.x4.x20/a_27_47#
+ ZR_sky130_fd_sc_hd__buf_2
Xdc_inst.x1.x12 VGND VPWR dc_inst.x1.net12 dc_inst.x1.net11 VPWR VGND dc_inst.x1.x12/a_27_47#
+ ZR_sky130_fd_sc_hd__buf_1
Xdc_inst.x6.x7 VGND VPWR dc_inst.x6.net8 dc_inst.x6.net7 VPWR VGND dc_inst.x6.x7/a_27_47#
+ ZR_sky130_fd_sc_hd__buf_1
Xdc_inst.x3.x8 VGND VPWR dc_inst.x3.net9 dc_inst.x3.net8 VPWR VGND dc_inst.x3.x8/a_27_47#
+ ZR_sky130_fd_sc_hd__buf_1
C0 dc_inst.x2.x5/a_27_47# dc_inst.x2.net2 0
C1 dc_inst.x2.x16/a_27_47# dc_inst.x8/a_750_97# 0
C2 dc_inst.x1.net11 path[2] 0.00189f
C3 clknet_1_1__leaf_clk _14_/a_439_47# 0
C4 _02_ _14_/a_535_374# 0
C5 dc_inst.x3.net9 dc_inst.x3.x10/a_27_47# 0.01149f
C6 clknet_1_0__leaf_clk dc_inst.x7.x19/a_27_47# 0.00131f
C7 clkbuf_1_0__f_clk/a_110_47# dc_inst.x7.net19 0.00198f
C8 _24_/a_448_47# _03_ 0
C9 VPWR path[1] 0.05598f
C10 dc_inst.x6.net6 dc_inst.x4.net12 0
C11 dc_inst.x7.net9 dc_inst.x7.x6/a_27_47# 0
C12 dc_inst.x6.net9 dc_inst.x5.net18 0.00582f
C13 dc_inst.x2.net12 path_sel[1] 0.02272f
C14 dc_inst.x3.net6 path_sel[0] 0
C15 dc_inst.x3.x3/a_27_47# dc_inst.x1.net8 0
C16 _02_ _13_/a_27_297# 0.00424f
C17 dc_inst.x1.net13 dc_inst.in 0
C18 dc_inst.x3.net5 _15_/a_288_47# 0
C19 dc_inst.x6.net4 dc_inst.x6.net7 0
C20 dc_inst.x9/a_750_97# dc_inst.net4 0.02818f
C21 path_sel[1] _15_/a_372_413# 0
C22 dc_inst.x2.x18/a_27_47# dc_inst.net1 0
C23 capture_q dc_inst.x3.net14 0
C24 dc_inst.x4.net16 dc_inst.x4.net10 0
C25 dc_inst.x2.net17 dc_inst.x2.x20/a_27_47# 0.01105f
C26 dc_inst.x4.net3 dc_inst.in 0
C27 dc_inst.x5.net17 dc_inst.x6.net8 0.02608f
C28 dc_inst.x2.net1 _08_ 0
C29 _06_ dc_inst.x3.x12/a_27_47# 0.00109f
C30 dc_inst.x1.x12/a_27_47# _07_ 0.00699f
C31 dc_inst.x4.x20/a_27_47# dc_inst.x5.net12 0
C32 _02_ dc_inst.x3.x3/a_27_47# 0
C33 _25_/a_27_47# delay_sel[2] 0
C34 dc_inst.x4.net14 dc_inst.x4.net13 0.00606f
C35 dc_inst.x4.net15 dc_inst.x4.net12 0
C36 _24_/a_805_47# delay_sel[2] 0
C37 _04_ _15_/a_788_316# 0
C38 dc_inst.x3.x1/a_27_47# dc_inst.x8/a_750_97# 0
C39 dc_inst.x2.net7 dc_inst.x5.net8 0
C40 dc_inst.x2.net6 dc_inst.x5.net9 0.02742f
C41 VPWR dc_inst.x6.x16/a_27_47# -0.00415f
C42 _02_ dc_inst.x3.x16/a_27_47# 0
C43 VPWR path_sel[2] 1.09194f
C44 _24_/a_27_47# _24_/a_193_47# -0.21508f
C45 dc_inst.in _23_/a_193_47# 0.09912f
C46 dc_inst.x2.net1 dc_inst.x2.x11/a_27_47# 0.12267f
C47 dc_inst.x3.x18/a_27_47# path_sel[1] 0
C48 dc_inst.x7.net6 dc_inst.x7.net18 0
C49 dc_inst.net4 dc_inst.x6.x14/a_27_47# 0.00214f
C50 dc_inst.x6.x16/a_27_47# path_sel[2] 0.00663f
C51 clkload0/a_27_47# _23_/a_27_47# 0
C52 _02_ _03_ 0
C53 dc_inst.x1.net3 dc_inst.x3.x14/a_27_47# 0.03048f
C54 dc_inst.x8/a_834_97# dc_inst.net2 0.00486f
C55 _01_ _23_/a_448_47# 0
C56 dc_inst.x6.net1 dc_inst.x7.x5/a_27_47# 0
C57 dc_inst.x5.x17/a_27_47# dc_inst.x6.net7 0
C58 dc_inst.x5.net14 dc_inst.x4.net19 0.05398f
C59 dc_inst.net4 dc_inst.x4.net8 0
C60 VPWR dc_inst.x6.net15 0.0069f
C61 clknet_1_1__leaf_clk dc_inst.x3.net15 0
C62 capture_q _05_ 0.00347f
C63 capture_q dc_inst.x3.x15/a_27_47# 0
C64 tdo dc_inst.x7.x17/a_27_47# 0
C65 dc_inst.x6.x4/a_27_47# dc_inst.x9/a_247_21# 0
C66 dc_inst.x6.net6 dc_inst.x7.net6 0
C67 dc_inst.x5.x13/a_27_47# dc_inst.x4.net19 0
C68 dc_inst.x6.net8 dc_inst.x5.net12 0
C69 dc_inst.x4.x13/a_27_47# dc_inst.x4.net13 0.00201f
C70 _24_/a_448_47# VPWR 0.00844f
C71 _13_/a_470_297# dc_inst.x3.x5/a_27_47# 0
C72 dc_inst.x2.net19 dc_inst.in 0.03445f
C73 dc_inst.x5.net6 dc_inst.x1.x9/a_27_47# 0
C74 dc_inst.x6.net15 path_sel[2] 0.00675f
C75 dc_inst.x6.net15 dc_inst.x6.x16/a_27_47# 0.12554f
C76 dc_inst.x1.x15/a_27_47# path[6] 0
C77 dc_inst.x7.net12 _25_/a_1108_47# 0
C78 dc_inst.x5.net14 dc_inst.x5.x2/a_27_47# 0
C79 dc_inst.x5.x14/a_27_47# dc_inst.x5.net3 0.14165f
C80 dc_inst.x2.net6 dc_inst.x2.x9/a_27_47# 0.01435f
C81 dc_inst.x6.x19/a_27_47# dc_inst.x6.net19 0.04302f
C82 clknet_0_clk _23_/a_1108_47# 0
C83 dc_inst.x6.net2 dc_inst.x7.net4 0
C84 dc_inst.x5.x3/a_27_47# dc_inst.x2.net6 0.00721f
C85 dc_inst.x7.net1 dc_inst.x9/a_193_413# 0.00847f
C86 dc_inst.x2.x20/a_27_47# dc_inst.x8/a_277_47# 0
C87 dc_inst.x5.net16 path_sel[0] 0
C88 dc_inst.x4.net14 dc_inst.x4.net11 0
C89 dc_inst.x7.net1 clknet_0_clk 0.07198f
C90 dc_inst.x3.net8 dc_inst.x3.net17 0
C91 rst dc_inst.x7.net17 0
C92 dc_inst.x7.net2 dc_inst.x7.net4 0.02592f
C93 dc_inst.net6 dc_inst.x7.net5 0.02712f
C94 VPWR dc_inst.x4.net5 0.66587f
C95 dc_inst.x5.net8 dc_inst.x5.net3 0.16683f
C96 dc_inst.x4.x17/a_27_47# dc_inst.x5.net3 0
C97 dc_inst.x4.x2/a_27_47# dc_inst.x4.x3/a_27_47# 0.02448f
C98 VPWR dc_inst.x1.net8 0.12554f
C99 dc_inst.x5.net14 dc_inst.x6.net6 0.00607f
C100 dc_inst.x6.net8 dc_inst.x7.x7/a_27_47# 0
C101 dc_inst.x6.x16/a_27_47# dc_inst.x4.net5 0
C102 dc_inst.x4.net2 delay_sel[0] 0.00295f
C103 dc_inst.x6.x6/a_27_47# dc_inst.x5.net12 0
C104 path_sel[2] dc_inst.x4.net5 0.05034f
C105 dc_inst.x9/a_277_47# dc_inst.x7.x17/a_27_47# 0
C106 clknet_1_0__leaf_clk dc_inst.x7.x17/a_27_47# 0.00122f
C107 clkbuf_1_0__f_clk/a_110_47# dc_inst.x7.net17 0.00496f
C108 path_sel[2] dc_inst.x1.net8 0.04512f
C109 dc_inst.x1.net17 dc_inst.x1.x16/a_27_47# 0
C110 VPWR dc_inst.x5.net15 0.0235f
C111 dc_inst.x2.net6 dc_inst.x2.net9 0.05487f
C112 dc_inst.x6.net2 dc_inst.net4 0.03476f
C113 _25_/a_651_413# VPWR 0
C114 dc_inst.x2.net7 dc_inst.x5.net10 0
C115 dc_inst.x2.net6 dc_inst.x5.net1 0
C116 dc_inst.x4.x11/a_27_47# dc_inst.x4.net13 0.02644f
C117 dc_inst.x4.net11 dc_inst.x4.x13/a_27_47# 0.00139f
C118 dc_inst.x3.net2 dc_inst.x3.x14/a_27_47# 0
C119 dc_inst.x4.x1/a_27_47# dc_inst.x8/a_757_363# 0
C120 dc_inst.net3 dc_inst.x8/a_247_21# 0.03314f
C121 _02_ VPWR 0.34917f
C122 dc_inst.x2.x7/a_27_47# dc_inst.x2.net12 0
C123 dc_inst.x3.net14 dc_inst.x3.x20/a_27_47# 0
C124 dc_inst.x6.net15 dc_inst.x4.net5 0
C125 dc_inst.x7.net4 dc_inst.x8/a_757_363# 0.00725f
C126 dc_inst.x7.net9 dc_inst.x7.net8 0.00417f
C127 dc_inst.x5.net15 path_sel[2] 0
C128 dc_inst.x7.net12 _00_ 0
C129 dc_inst.x4.net3 dc_inst.x7.x3/a_27_47# 0
C130 VPWR dc_inst.x2.net2 0.20739f
C131 dc_inst.x7.net2 dc_inst.net4 0.01587f
C132 clknet_0_clk dc_inst.x7.x18/a_27_47# 0.01061f
C133 dc_inst.x4.net15 dc_inst.x5.net14 0
C134 dc_inst.x4.x16/a_27_47# dc_inst.x5.x6/a_27_47# 0
C135 dc_inst.x4.net4 dc_inst.x2.net4 0
C136 dc_inst.x7.net1 dc_inst.x9/a_834_97# 0
C137 dc_inst.x7.net3 dc_inst.x3.x1/a_27_47# 0.00182f
C138 dc_inst.x4.net15 dc_inst.x5.x13/a_27_47# 0
C139 path_sel[2] dc_inst.x2.net2 0.00312f
C140 dc_inst.net3 path[6] 0.004f
C141 tdo path_sel[0] 0.07877f
C142 dc_inst.x3.net8 dc_inst.x3.net11 0
C143 dc_inst.net6 dc_inst.x6.x10/a_27_47# 0
C144 _19_/a_109_297# _20_/a_79_21# 0
C145 dc_inst.x1.x1/a_27_47# dc_inst.net2 0.00419f
C146 dc_inst.x5.x20/a_27_47# dc_inst.x9/a_27_413# 0
C147 _17_/a_27_93# path[0] 0.0026f
C148 _25_/a_27_47# _25_/a_543_47# -0.00454f
C149 _25_/a_193_47# _25_/a_761_289# -0.0105f
C150 dc_inst.x4.x3/a_27_47# dc_inst.x2.x19/a_27_47# 0
C151 dc_inst.x6.net16 dc_inst.x7.net6 0
C152 clknet_0_clk _03_ 0.12397f
C153 dc_inst.x3.net18 dc_inst.x3.net10 0
C154 dc_inst.x2.x19/a_27_47# delay_sel[1] 0
C155 _24_/a_448_47# _02_ 0
C156 _24_/a_543_47# capture_q 0
C157 delay_sel[2] dc_inst.in 0.01756f
C158 dc_inst.x1.x20/a_27_47# dc_inst.x2.net7 0
C159 dc_inst.x4.net5 dc_inst.x1.net8 0
C160 dc_inst.x2.net6 dc_inst.x4.net7 0
C161 dc_inst.x1.net16 dc_inst.x1.net12 0
C162 _09_ path[7] 0
C163 _15_/a_788_316# dc_inst.x3.x12/a_27_47# 0
C164 dc_inst.x3.x15/a_27_47# dc_inst.x3.x20/a_27_47# 0
C165 dc_inst.x4.x11/a_27_47# dc_inst.x4.net11 0.04349f
C166 dc_inst.x1.x11/a_27_47# _19_/a_27_47# 0
C167 dc_inst.x1.net4 dc_inst.x1.x1/a_27_47# 0.00823f
C168 dc_inst.x7.x13/a_27_47# dc_inst.x9/a_247_21# 0
C169 dc_inst.x1.net5 path[5] 0
C170 dc_inst.x1.net6 path[7] 0
C171 _15_/a_27_47# dc_inst.x3.x14/a_27_47# 0
C172 dc_inst.x2.x5/a_27_47# dc_inst.x2.net12 0.00502f
C173 dc_inst.x6.x12/a_27_47# dc_inst.x7.net4 0
C174 dc_inst.x1.net17 dc_inst.x6.net17 0.00115f
C175 dc_inst.x9/a_834_97# dc_inst.x7.x18/a_27_47# 0
C176 dc_inst.x4.net13 dc_inst.x5.net9 0
C177 dc_inst.x10/a_218_47# dc_inst.x7.net16 0
C178 dc_inst.net9 _23_/a_448_47# 0
C179 _14_/a_439_47# dc_inst.x3.net8 0
C180 se dc_inst.x3.x7/a_27_47# 0
C181 dc_inst.x3.net4 dc_inst.x3.net19 0.01129f
C182 dc_inst.x2.net2 dc_inst.x4.net5 0.01741f
C183 _18_/a_76_199# _17_/a_174_21# 0.00158f
C184 dc_inst.x1.x17/a_27_47# dc_inst.x1.net16 0.05296f
C185 dc_inst.net8 dc_inst.x3.x20/a_27_47# 0.00414f
C186 dc_inst.x6.x13/a_27_47# dc_inst.net4 0
C187 dc_inst.x7.x6/a_27_47# dc_inst.x7.net7 0.04269f
C188 dc_inst.x1.net19 dc_inst.x6.net11 0.00148f
C189 dc_inst.in dc_inst.x6.x20/a_27_47# 0
C190 _13_/a_470_47# dc_inst.x3.net8 0.00311f
C191 dc_inst.x5.net19 dc_inst.x6.net1 0
C192 dc_inst.x1.net17 dc_inst.x4.net6 -0
C193 dc_inst.x3.net5 path_sel[1] 0
C194 path_sel[1] _08_ 0.00286f
C195 dc_inst.x4.net3 dc_inst.x5.net6 0
C196 _00_ _24_/a_1270_413# 0
C197 tdo _24_/a_1283_21# 0
C198 dc_inst.x7.net14 clknet_1_0__leaf_clk 0
C199 dc_inst.x1.x1/a_27_47# dc_inst.x1.net9 0.00115f
C200 dc_inst.x1.x10/a_27_47# dc_inst.x5.net11 0.00329f
C201 dc_inst.x1.x12/a_27_47# _06_ 0
C202 dc_inst.x4.x12/a_27_47# dc_inst.x4.net13 0.03187f
C203 dc_inst.x7.x20/a_27_47# dc_inst.x7.net1 0
C204 VPWR dc_inst.x6.x15/a_27_47# 0.06584f
C205 dc_inst.x6.x5/a_27_47# dc_inst.x5.net19 0.00181f
C206 VPWR dc_inst.x9/a_193_413# -0
C207 dc_inst.x4.net4 dc_inst.x2.net6 0
C208 dc_inst.x6.x12/a_27_47# dc_inst.net4 0.00629f
C209 dc_inst.x1.x19/a_27_47# dc_inst.x1.x17/a_27_47# 0
C210 VPWR clknet_0_clk 0.27284f
C211 dc_inst.x5.net16 dc_inst.x5.net17 0.00501f
C212 dc_inst.x6.net3 dc_inst.x6.net5 0
C213 dc_inst.x2.net17 dc_inst.x2.net18 0.00682f
C214 dc_inst.x4.x10/a_27_47# dc_inst.x4.net13 0
C215 _23_/a_27_47# dc_inst.x8/a_757_363# 0
C216 dc_inst.x4.net13 dc_inst.x2.x9/a_27_47# 0
C217 path_sel[2] dc_inst.x6.x15/a_27_47# 0.00505f
C218 dc_inst.x6.x16/a_27_47# dc_inst.x6.x15/a_27_47# 0
C219 dc_inst.x2.net8 dc_inst.x5.net7 0.00247f
C220 dc_inst.x6.x8/a_27_47# dc_inst.x7.x6/a_27_47# 0
C221 path_sel[2] dc_inst.x9/a_193_413# 0
C222 dc_inst.x7.net12 dc_inst.x9/a_193_47# 0
C223 _24_/a_193_47# clkload0/a_27_47# 0.00129f
C224 dc_inst.x9/a_757_363# dc_inst.x6.x20/a_27_47# 0
C225 dc_inst.x2.x11/a_27_47# path_sel[1] 0.01299f
C226 dc_inst.x1.x4/a_27_47# dc_inst.x1.net5 0.00202f
C227 dc_inst.x1.net11 dc_inst.x1.x12/a_27_47# 0.02018f
C228 delay_sel[0] dc_inst.x7.net18 0
C229 dc_inst.x5.net9 dc_inst.x2.x2/a_27_47# 0
C230 dc_inst.x1.net17 dc_inst.x2.net3 0
C231 dc_inst.x10/a_218_47# dc_inst.net9 0
C232 dc_inst.x4.net3 dc_inst.x2.x16/a_27_47# 0
C233 dc_inst.x3.x8/a_27_47# dc_inst.x3.x11/a_27_47# 0
C234 dc_inst.x4.net4 dc_inst.x2.net18 0.00542f
C235 dc_inst.net6 dc_inst.x7.net9 0
C236 _18_/a_505_21# _08_ 0
C237 path[2] _17_/a_174_21# 0.01057f
C238 dc_inst.x6.net15 dc_inst.x6.x15/a_27_47# 0.04368f
C239 dc_inst.x3.net17 dc_inst.net2 0
C240 dc_inst.x6.net6 delay_sel[0] 0
C241 dc_inst.x2.x4/a_27_47# dc_inst.x2.net5 0.01506f
C242 VPWR dc_inst.x1.x14/a_27_47# -0.00595f
C243 dc_inst.x4.net17 dc_inst.x5.x17/a_27_47# 0
C244 dc_inst.x3.net8 dc_inst.x3.net15 0.00271f
C245 dc_inst.x1.net6 _17_/a_478_47# 0
C246 _14_/a_505_21# path[6] 0.00863f
C247 _25_/a_1108_47# tdo 0
C248 dc_inst.x5.net9 dc_inst.net1 0
C249 tdo clknet_1_1__leaf_clk 0.03066f
C250 dc_inst.x3.net18 dc_inst.x3.net13 0
C251 dc_inst.x2.net7 dc_inst.x4.net10 0.04458f
C252 dc_inst.x1.x14/a_27_47# path_sel[2] 0.0113f
C253 dc_inst.x4.net11 dc_inst.x4.x12/a_27_47# 0.12789f
C254 dc_inst.x4.net13 dc_inst.x2.net9 0
C255 VPWR dc_inst.x4.x7/a_27_47# -0
C256 dc_inst.x7.x3/a_27_47# delay_sel[2] 0.0039f
C257 dc_inst.x2.x6/a_27_47# dc_inst.x5.net7 0
C258 dc_inst.x1.x13/a_27_47# dc_inst.x1.net4 0.00168f
C259 dc_inst.x7.net15 dc_inst.x7.net16 0.03523f
C260 dc_inst.x2.net19 path[7] 0.00105f
C261 dc_inst.net8 dc_inst.x2.net17 0
C262 path[4] dc_inst.x3.net12 0.01619f
C263 VPWR dc_inst.x9/a_834_97# -0
C264 dc_inst.x1.net4 dc_inst.x3.net17 0
C265 dc_inst.x2.x13/a_27_47# dc_inst.x5.x12/a_27_47# 0
C266 dc_inst.x5.net19 dc_inst.x6.net8 0.06959f
C267 path_sel[2] dc_inst.x4.x7/a_27_47# 0.00194f
C268 dc_inst.x4.net2 dc_inst.x1.x4/a_27_47# 0
C269 dc_inst.x1.x5/a_27_47# _04_ 0
C270 dc_inst.x4.x2/a_27_47# dc_inst.x1.net4 0
C271 dc_inst.x3.x9/a_27_47# _15_/a_788_316# 0
C272 _23_/a_1283_21# dc_inst.x8/a_834_97# 0
C273 dc_inst.x4.x10/a_27_47# dc_inst.x2.x2/a_27_47# 0
C274 dc_inst.x2.net14 dc_inst.x2.net3 0
C275 tdo dc_inst.x1.net17 0.02307f
C276 dc_inst.x6.x15/a_27_47# dc_inst.x4.net5 0
C277 tdo dc_inst.x5.x8/a_27_47# 0.01841f
C278 dc_inst.x7.net13 dc_inst.net7 0
C279 dc_inst.x6.net16 dc_inst.x9/a_1290_413# 0
C280 dc_inst.x7.net12 delay_sel[1] 0.17559f
C281 dc_inst.x7.x2/a_27_47# clkbuf_0_clk/a_110_47# 0
C282 capture_q rst 0
C283 dc_inst.x2.net18 dc_inst.x8/a_277_47# 0.00126f
C284 dc_inst.x6.net9 dc_inst.x6.net1 0.01816f
C285 dc_inst.x2.x15/a_27_47# dc_inst.x1.x9/a_27_47# 0.03162f
C286 dc_inst.x2.x16/a_27_47# dc_inst.x2.net19 0
C287 dc_inst.x3.net5 dc_inst.x3.net16 0
C288 dc_inst.x4.x3/a_27_47# dc_inst.x1.x16/a_27_47# 0.01013f
C289 dc_inst.x4.net17 dc_inst.x5.net13 0
C290 dc_inst.x4.x1/a_27_47# dc_inst.x7.net4 0.00964f
C291 dc_inst.x4.net2 dc_inst.x7.net3 0
C292 dc_inst.x1.net18 dc_inst.x1.net19 0.0414f
C293 dc_inst.x4.x10/a_27_47# dc_inst.net1 0
C294 dc_inst.x1.x13/a_27_47# dc_inst.x1.net9 0.00481f
C295 path[3] _08_ 0.16184f
C296 path_sel[0] _15_/a_600_345# -0.01126f
C297 dc_inst.x2.x19/a_27_47# dc_inst.net2 0.00357f
C298 dc_inst.x2.x4/a_27_47# dc_inst.x2.x3/a_27_47# 0
C299 dc_inst.net5 dc_inst.x6.x5/a_27_47# 0
C300 _25_/a_651_413# clknet_0_clk 0.00151f
C301 _25_/a_1108_47# dc_inst.x9/a_277_47# 0
C302 _25_/a_1108_47# clknet_1_0__leaf_clk 0
C303 dc_inst.x2.net1 _07_ 0
C304 dc_inst.x5.net7 dc_inst.x4.net19 0
C305 _24_/a_27_47# delay_sel[0] 0
C306 dc_inst.x4.net13 dc_inst.x4.net7 0
C307 dc_inst.x1.net9 dc_inst.x3.net17 0
C308 _02_ clknet_0_clk 0.00262f
C309 dc_inst.x4.x2/a_27_47# dc_inst.x1.net9 0
C310 se path[7] 0
C311 tdi path[6] 0.07185f
C312 _00_ tdo 0.05476f
C313 dc_inst.x1.x14/a_27_47# dc_inst.x4.net5 0
C314 dc_inst.x3.x20/a_27_47# dc_inst.x1.x8/a_27_47# 0
C315 dc_inst.x3.net6 dc_inst.x3.net8 0.01852f
C316 VPWR dc_inst.x2.net12 0.11254f
C317 tdo dc_inst.x2.net14 0
C318 dc_inst.x4.net10 dc_inst.x5.net3 0
C319 dc_inst.x1.net14 dc_inst.x1.x7/a_27_47# 0
C320 tdo dc_inst.x5.net12 0.0699f
C321 dc_inst.x4.x18/a_27_47# dc_inst.x4.net17 0.01227f
C322 dc_inst.x7.net7 dc_inst.x7.net8 0.03405f
C323 dc_inst.x4.net5 dc_inst.x4.x7/a_27_47# 0.01107f
C324 dc_inst.x7.x16/a_27_47# dc_inst.x7.net6 0
C325 dc_inst.x4.x5/a_27_47# dc_inst.x4.net7 0.02511f
C326 path_sel[2] dc_inst.x2.net12 0.00192f
C327 dc_inst.x1.net4 dc_inst.x2.x19/a_27_47# 0
C328 shadow_q dc_inst.x8/a_1290_413# 0
C329 VPWR dc_inst.x7.x1/a_27_47# 0.01415f
C330 dc_inst.x1.x2/a_27_47# dc_inst.x1.net3 0.00171f
C331 dc_inst.x1.net4 dc_inst.x3.net11 0
C332 dc_inst.net8 dc_inst.x8/a_277_47# 0.59274f
C333 dc_inst.x4.net16 dc_inst.x4.x20/a_27_47# 0
C334 dc_inst.x6.net16 delay_sel[0] 0
C335 dc_inst.net4 dc_inst.x7.net4 0.07217f
C336 path_sel[2] _15_/a_372_413# 0
C337 dc_inst.x5.net9 dc_inst.x2.net10 0.01307f
C338 _18_/a_535_374# path[2] 0
C339 dc_inst.x7.x1/a_27_47# path_sel[2] 0.00581f
C340 dc_inst.x6.x19/a_27_47# dc_inst.x6.net14 0
C341 dc_inst.x5.net5 path_sel[0] 0.00234f
C342 dc_inst.x1.net10 dc_inst.x2.x13/a_27_47# 0.00479f
C343 VPWR dc_inst.x7.x20/a_27_47# 0.06129f
C344 dc_inst.x6.net6 dc_inst.x5.net7 0
C345 dc_inst.x5.net4 dc_inst.x5.net9 0.07058f
C346 capture_q dc_inst.x3.net9 0
C347 dc_inst.x1.x12/a_27_47# _15_/a_788_316# 0
C348 path_sel[0] path[6] 0.0757f
C349 _00_ clknet_1_0__leaf_clk 0.00379f
C350 dc_inst.x4.net1 dc_inst.x4.net8 0
C351 dc_inst.x4.x3/a_27_47# dc_inst.x6.net17 0
C352 dc_inst.x1.net5 dc_inst.x1.net6 0.00759f
C353 VPWR dc_inst.x8/a_27_413# -0.01205f
C354 dc_inst.x6.net9 dc_inst.x6.net8 0.02168f
C355 dc_inst.x2.net2 dc_inst.x4.x7/a_27_47# 0.0016f
C356 dc_inst.x2.x2/a_27_47# dc_inst.x4.net7 0.0016f
C357 dc_inst.net5 dc_inst.x6.net8 0
C358 VPWR dc_inst.x3.x18/a_27_47# -0.00406f
C359 capture_q dc_inst.x3.net2 0
C360 path_sel[0] dc_inst.x1.x6/a_27_47# 0.01963f
C361 dc_inst.x6.net17 delay_sel[1] 0
C362 dc_inst.x5.x15/a_27_47# path_sel[0] 0
C363 _04_ dc_inst.x3.net11 0
C364 dc_inst.x6.net18 dc_inst.x7.x5/a_27_47# 0
C365 path[5] dc_inst.x3.x13/a_27_47# 0.01188f
C366 dc_inst.net6 dc_inst.x6.x17/a_27_47# 0
C367 path_sel[2] dc_inst.x8/a_27_413# 0
C368 dc_inst.x7.x20/a_27_47# dc_inst.x6.net15 0
C369 dc_inst.x3.net5 _23_/a_1108_47# 0
C370 dc_inst.x6.net3 dc_inst.x6.net4 0.01445f
C371 dc_inst.x6.x9/a_27_47# dc_inst.x7.x4/a_27_47# 0
C372 dc_inst.x4.net15 dc_inst.x5.net7 0
C373 dc_inst.x5.x4/a_27_47# dc_inst.x2.net13 0
C374 dc_inst.x2.x9/a_27_47# dc_inst.x2.net10 0.00877f
C375 dc_inst.net1 dc_inst.x4.net7 0.00434f
C376 dc_inst.x5.net6 dc_inst.x6.x20/a_27_47# 0
C377 dc_inst.x2.net17 dc_inst.x1.x8/a_27_47# 0.01477f
C378 dc_inst.x7.x19/a_27_47# dc_inst.x7.net19 0.00148f
C379 dc_inst.x5.net18 dc_inst.x6.net11 0
C380 dc_inst.x4.x16/a_27_47# dc_inst.x4.net18 0
C381 dc_inst.x1.net18 dc_inst.x1.x20/a_27_47# 0.00662f
C382 dc_inst.x7.x1/a_27_47# dc_inst.x4.net5 0
C383 _10_ _15_/a_1060_369# 0
C384 dc_inst.x4.x1/a_27_47# _23_/a_27_47# 0
C385 _19_/a_27_47# path[4] 0
C386 dc_inst.x5.x3/a_27_47# dc_inst.x5.net4 0.015f
C387 dc_inst.x5.x20/a_27_47# dc_inst.x7.x9/a_27_47# 0.00104f
C388 dc_inst.x1.net2 dc_inst.x3.x2/a_27_47# 0
C389 dc_inst.x7.net4 _23_/a_27_47# 0
C390 _15_/a_600_345# dc_inst.x1.net7 0
C391 dc_inst.x6.net9 dc_inst.x6.x6/a_27_47# 0
C392 dc_inst.x5.net7 dc_inst.x6.x11/a_27_47# 0
C393 dc_inst.x2.net7 dc_inst.x5.x11/a_27_47# 0
C394 dc_inst.x4.net3 dc_inst.x1.net5 0
C395 dc_inst.x2.net5 dc_inst.x2.net13 0.04819f
C396 dc_inst.x7.x10/a_27_47# dc_inst.x7.net4 0.00958f
C397 dc_inst.x4.net4 dc_inst.x1.x8/a_27_47# 0
C398 _25_/a_1217_47# dc_inst.net7 0
C399 dc_inst.x4.net13 dc_inst.x5.x7/a_27_47# 0
C400 dc_inst.x1.x13/a_27_47# dc_inst.x2.net15 0
C401 dc_inst.x2.net12 dc_inst.x2.net2 0
C402 VPWR dc_inst.x8/a_668_97# 0.0019f
C403 dc_inst.x3.x1/a_27_47# delay_sel[2] 0
C404 dc_inst.x2.net17 dc_inst.net1 0.00695f
C405 _24_/a_1283_21# path[6] 0.00126f
C406 dc_inst.x2.net9 dc_inst.x2.net10 0.00485f
C407 dc_inst.x6.net3 dc_inst.x5.x17/a_27_47# 0
C408 dc_inst.x2.net10 dc_inst.x5.net1 0.01134f
C409 dc_inst.x6.x2/a_27_47# dc_inst.x5.net17 0
C410 dc_inst.x3.net4 dc_inst.x3.x4/a_27_47# 0.13315f
C411 dc_inst.x3.x3/a_27_47# dc_inst.x3.net5 0
C412 dc_inst.x1.net2 dc_inst.x1.net14 0.09651f
C413 dc_inst.x9/a_1478_413# dc_inst.in 0
C414 dc_inst.x7.net3 dc_inst.x3.net4 0.00243f
C415 dc_inst.x5.net4 dc_inst.x5.net1 0
C416 dc_inst.x6.net2 dc_inst.x7.net6 0.02869f
C417 dc_inst.x7.net3 dc_inst.x7.net18 0
C418 dc_inst.x6.net16 dc_inst.x5.net7 0
C419 dc_inst.x7.net12 dc_inst.net5 0.02278f
C420 dc_inst.x7.net3 capture_d 0.03558f
C421 _17_/a_27_93# path_sel[0] 0.03636f
C422 dc_inst.x2.net16 dc_inst.x1.x16/a_27_47# 0.0013f
C423 dc_inst.x3.net5 dc_inst.x3.x16/a_27_47# 0
C424 dc_inst.net6 dc_inst.x7.net7 0
C425 dc_inst.x7.net2 dc_inst.x7.net6 0
C426 dc_inst.x4.net4 dc_inst.net1 0.0038f
C427 dc_inst.x1.net19 dc_inst.x6.net14 0
C428 dc_inst.x1.net4 dc_inst.x3.net15 0
C429 dc_inst.x4.net2 dc_inst.x4.net3 0.01665f
C430 dc_inst.x7.x10/a_27_47# dc_inst.net4 0.00147f
C431 dc_inst.x3.x8/a_27_47# path[5] 0.00604f
C432 dc_inst.x1.net15 dc_inst.x1.net14 0.20071f
C433 dc_inst.net6 dc_inst.net1 0.00278f
C434 clknet_1_1__leaf_clk dc_inst.x8/a_247_21# 0
C435 _02_ dc_inst.x3.x18/a_27_47# 0
C436 path[6] dc_inst.x1.net7 0
C437 dc_inst.x3.net12 dc_inst.x3.net1 0.03178f
C438 dc_inst.x9/a_247_21# dc_inst.x9/a_668_97# 0
C439 dc_inst.x9/a_750_97# dc_inst.x9/a_1290_413# -0.00475f
C440 clknet_0_clk dc_inst.x9/a_834_97# 0
C441 dc_inst.x6.net17 dc_inst.x8/a_27_47# 0
C442 dc_inst.net6 dc_inst.x6.x18/a_27_47# 0
C443 dc_inst.x7.x15/a_27_47# dc_inst.x7.net10 0
C444 dc_inst.x4.net12 dc_inst.x6.x12/a_27_47# 0
C445 dc_inst.x1.x6/a_27_47# dc_inst.x1.net7 0.00914f
C446 tdo delay_sel[1] 0.0341f
C447 dc_inst.x3.net13 dc_inst.x3.net10 0.01406f
C448 dc_inst.x2.x20/a_27_47# shadow_q 0
C449 dc_inst.x4.net14 dc_inst.x4.x16/a_27_47# 0.03765f
C450 dc_inst.x5.x7/a_27_47# dc_inst.x2.x2/a_27_47# 0
C451 clkbuf_0_clk/a_110_47# clk 0.00654f
C452 dc_inst.x3.x2/a_27_47# dc_inst.x3.net19 0.02435f
C453 dc_inst.x3.net2 dc_inst.x3.x20/a_27_47# 0.04519f
C454 dc_inst.x3.net16 _23_/a_448_47# 0
C455 clknet_1_1__leaf_clk path[6] 0.03377f
C456 dc_inst.x2.x19/a_27_47# dc_inst.x2.net15 0
C457 dc_inst.x4.x17/a_27_47# dc_inst.x4.net9 0
C458 dc_inst.x1.net3 dc_inst.x2.net17 0
C459 dc_inst.net7 dc_inst.in 0
C460 dc_inst.x4.net5 dc_inst.x8/a_668_97# 0
C461 tdo dc_inst.x4.x14/a_27_47# 0.00455f
C462 dc_inst.x5.x5/a_27_47# dc_inst.x5.net8 0
C463 dc_inst.x1.net17 dc_inst.x5.net5 0
C464 dc_inst.x5.net5 dc_inst.x5.x8/a_27_47# 0
C465 dc_inst.x1.net16 dc_inst.x5.net6 0
C466 dc_inst.net1 dc_inst.x8/a_277_47# 0.00166f
C467 _15_/a_288_47# _06_ 0
C468 dc_inst.x5.net7 dc_inst.x2.x1/a_27_47# 0
C469 path_sel[1] _07_ 0.08409f
C470 dc_inst.x6.x1/a_27_47# dc_inst.x6.net16 0.00209f
C471 dc_inst.x1.x12/a_27_47# _17_/a_174_21# 0
C472 dc_inst.x6.x19/a_27_47# dc_inst.x6.net13 0
C473 dc_inst.x5.x4/a_27_47# path_sel[0] 0.00273f
C474 dc_inst.x1.net12 dc_inst.x5.x12/a_27_47# 0
C475 dc_inst.x1.net10 _19_/a_27_47# 0
C476 dc_inst.x4.net2 dc_inst.x2.net19 0.00548f
C477 dc_inst.x4.net1 dc_inst.x6.x13/a_27_47# 0
C478 dc_inst.x1.net18 dc_inst.x8/a_193_413# 0
C479 _13_/a_112_47# dc_inst.x3.net17 0
C480 dc_inst.x1.net18 dc_inst.x4.net10 0
C481 dc_inst.x3.x12/a_27_47# dc_inst.x3.net11 0.03631f
C482 dc_inst.x7.net3 _24_/a_27_47# 0
C483 dc_inst.x7.x19/a_27_47# dc_inst.x7.net17 0
C484 dc_inst.x7.net19 dc_inst.x7.x17/a_27_47# 0.03689f
C485 dc_inst.x1.x16/a_27_47# dc_inst.x1.net9 0
C486 capture_q dc_inst.x8/a_1478_413# 0
C487 dc_inst.x1.net19 dc_inst.x5.x5/a_27_47# 0
C488 dc_inst.x1.x19/a_27_47# dc_inst.x5.net6 0.02054f
C489 dc_inst.x6.x4/a_27_47# dc_inst.x6.x5/a_27_47# 0.02448f
C490 dc_inst.x6.x19/a_27_47# dc_inst.x6.net12 0
C491 dc_inst.x9/a_757_363# dc_inst.net7 0.00419f
C492 _00_ dc_inst.x7.x12/a_27_47# 0
C493 dc_inst.x9/a_750_97# delay_sel[0] 0.39033f
C494 dc_inst.x9/a_277_47# delay_sel[1] 0.77113f
C495 delay_sel[0] dc_inst.x7.x16/a_27_47# 0.01427f
C496 clknet_1_0__leaf_clk delay_sel[1] 0.02463f
C497 dc_inst.x1.net16 dc_inst.x2.x16/a_27_47# 0.11175f
C498 VPWR dc_inst.x3.net5 0.20057f
C499 VPWR _08_ 0.08726f
C500 dc_inst.net5 dc_inst.x6.net17 0.00131f
C501 dc_inst.x2.x19/a_27_47# _23_/a_1283_21# 0
C502 dc_inst.x3.x17/a_27_47# shadow_q 0
C503 dc_inst.x5.net5 dc_inst.x5.net12 0.00207f
C504 _00_ path[6] 0.05611f
C505 _15_/a_27_47# dc_inst.x3.x20/a_27_47# 0
C506 dc_inst.x2.net1 dc_inst.x5.net10 0
C507 rst dc_inst.x8/a_277_47# 0
C508 path_sel[2] _08_ 0
C509 _18_/a_218_47# path_sel[0] 0
C510 dc_inst.x5.x9/a_27_47# path_sel[1] 0.00437f
C511 shadow_q dc_inst.x3.net1 0
C512 dc_inst.x1.x14/a_27_47# dc_inst.x2.net12 0
C513 dc_inst.x2.net6 dc_inst.x2.x13/a_27_47# 0
C514 _04_ dc_inst.x3.net6 0
C515 dc_inst.x2.net17 dc_inst.x3.net2 0
C516 path_sel[0] dc_inst.x5.x1/a_27_47# 0
C517 VPWR dc_inst.x2.x11/a_27_47# -0.00202f
C518 dc_inst.x2.net12 dc_inst.x4.x7/a_27_47# 0
C519 dc_inst.x6.x9/a_27_47# dc_inst.x4.net18 0
C520 dc_inst.x2.x11/a_27_47# path_sel[2] 0
C521 tdo dc_inst.x8/a_27_47# 0.0025f
C522 dc_inst.x1.net10 dc_inst.x1.net12 0
C523 dc_inst.x5.net5 dc_inst.x2.x8/a_27_47# 0
C524 dc_inst.x1.net15 dc_inst.x8/a_757_363# 0
C525 dc_inst.x5.net5 dc_inst.x5.x10/a_27_47# 0.00129f
C526 dc_inst.x4.x17/a_27_47# dc_inst.x6.net13 0
C527 dc_inst.x3.net12 dc_inst.x3.net14 0.04463f
C528 _19_/a_109_297# _09_ 0.0077f
C529 dc_inst.x7.net2 dc_inst.x9/a_1290_413# 0.03216f
C530 dc_inst.in dc_inst.x8/a_1290_413# 0
C531 _24_/a_193_47# dc_inst.x7.net4 0
C532 dc_inst.x4.net2 delay_sel[2] 0
C533 dc_inst.x5.net4 dc_inst.x5.x7/a_27_47# 0
C534 dc_inst.x5.net19 clknet_1_0__leaf_clk 0
C535 path[3] _07_ 0.00269f
C536 dc_inst.x4.x17/a_27_47# dc_inst.x6.net12 0
C537 dc_inst.x1.net19 dc_inst.x6.net13 0
C538 dc_inst.x3.x19/a_27_47# dc_inst.x3.net19 0.00305f
C539 dc_inst.x1.x17/a_27_47# dc_inst.x1.net10 0
C540 path[4] dc_inst.in 0
C541 dc_inst.x1.x5/a_27_47# dc_inst.x1.x12/a_27_47# 0.02448f
C542 dc_inst.x6.net18 dc_inst.net2 0
C543 dc_inst.x6.net1 dc_inst.x5.net3 0
C544 dc_inst.x7.net14 dc_inst.x7.net19 0.10072f
C545 tdo dc_inst.x2.net16 0
C546 dc_inst.x1.net18 dc_inst.x4.x4/a_27_47# 0
C547 _23_/a_761_289# shadow_q 0
C548 _02_ dc_inst.x3.net5 0
C549 capture_d _23_/a_193_47# 0.04618f
C550 dc_inst.x3.net2 dc_inst.x8/a_277_47# 0.01407f
C551 dc_inst.x3.x2/a_27_47# dc_inst.x8/a_750_97# 0
C552 dc_inst.net5 dc_inst.x6.net18 0
C553 dc_inst.x1.net19 dc_inst.x6.net12 0
C554 dc_inst.x5.x14/a_27_47# path_sel[1] 0.00509f
C555 dc_inst.x3.net18 dc_inst.x3.net19 0.01505f
C556 dc_inst.x3.x20/a_27_47# dc_inst.x8/a_1478_413# 0.01731f
C557 dc_inst.x6.net2 delay_sel[0] 0
C558 dc_inst.x3.x9/a_27_47# dc_inst.x3.net11 0.0169f
C559 dc_inst.x3.x6/a_27_47# dc_inst.x3.net17 0.03206f
C560 tdo dc_inst.net5 0.00932f
C561 dc_inst.x7.x17/a_27_47# dc_inst.x7.net17 0.00726f
C562 dc_inst.x4.x16/a_27_47# dc_inst.x5.net9 0
C563 dc_inst.x1.x16/a_27_47# dc_inst.x2.net15 0.0322f
C564 _14_/a_76_199# shadow_q 0.00236f
C565 dc_inst.x4.net12 dc_inst.net4 0.09308f
C566 dc_inst.x4.net2 dc_inst.x6.x20/a_27_47# 0
C567 clkbuf_1_1__f_clk/a_110_47# dc_inst.x3.net17 0
C568 _23_/a_448_47# _03_ 0
C569 dc_inst.x3.net7 dc_inst.x3.net1 0.03092f
C570 dc_inst.x7.net2 delay_sel[0] 0.02317f
C571 dc_inst.x5.net9 path[0] 0
C572 dc_inst.x4.net16 tdo 0.02516f
C573 dc_inst.x5.net8 path_sel[1] 0.00487f
C574 dc_inst.x3.x2/a_27_47# path[5] 0.00375f
C575 dc_inst.x1.net10 dc_inst.x2.x14/a_27_47# 0
C576 dc_inst.x4.x20/a_27_47# dc_inst.x5.net3 0
C577 dc_inst.x4.x17/a_27_47# path_sel[1] 0.00661f
C578 dc_inst.x7.net1 dc_inst.x5.x20/a_27_47# 0.00555f
C579 dc_inst.x3.net15 _23_/a_1283_21# 0.00116f
C580 dc_inst.x9/a_1290_413# dc_inst.x6.x13/a_27_47# 0
C581 dc_inst.x4.net10 dc_inst.x6.net14 0
C582 dc_inst.x1.x18/a_27_47# dc_inst.x4.net7 0
C583 dc_inst.x4.x16/a_27_47# dc_inst.x4.x12/a_27_47# 0
C584 dc_inst.x1.x2/a_27_47# dc_inst.x1.x15/a_27_47# 0.08729f
C585 dc_inst.x3.net14 shadow_q 0
C586 path_sel[0] dc_inst.x3.x14/a_27_47# 0
C587 dc_inst.x1.net19 path_sel[1] 0
C588 dc_inst.x7.net4 dc_inst.x7.net6 0.05055f
C589 dc_inst.x5.net7 dc_inst.x4.net8 0.11063f
C590 dc_inst.x4.x6/a_27_47# dc_inst.x4.net8 0
C591 delay_sel[1] dc_inst.x8/a_247_21# 0.27349f
C592 delay_sel[0] dc_inst.x8/a_757_363# 0.00724f
C593 dc_inst.net9 dc_inst.x8/a_193_413# 0
C594 delay_sel[2] _23_/a_805_47# 0
C595 dc_inst.x3.net3 dc_inst.x8/a_834_97# 0
C596 dc_inst.x1.x10/a_27_47# dc_inst.x1.x11/a_27_47# 0
C597 dc_inst.x5.x18/a_27_47# dc_inst.x5.x19/a_27_47# 0
C598 dc_inst.x6.x1/a_27_47# dc_inst.x9/a_750_97# 0
C599 dc_inst.net5 dc_inst.x9/a_277_47# -0
C600 dc_inst.x3.net8 path[6] 0.0325f
C601 _13_/a_112_47# dc_inst.x3.net15 0
C602 dc_inst.x7.x12/a_27_47# delay_sel[1] 0.00493f
C603 dc_inst.net5 clknet_1_0__leaf_clk 0
C604 dc_inst.x2.net10 _17_/a_574_297# 0
C605 dc_inst.x5.x4/a_27_47# dc_inst.x5.net12 0.00446f
C606 dc_inst.x6.net8 dc_inst.x5.net3 0
C607 dc_inst.x2.x19/a_27_47# dc_inst.x6.net19 0
C608 dc_inst.x4.net3 dc_inst.x6.net16 0
C609 path_sel[1] _06_ 0
C610 _24_/a_193_47# _23_/a_27_47# 0
C611 _24_/a_27_47# _23_/a_193_47# 0
C612 dc_inst.x1.x3/a_27_47# dc_inst.x8/a_1290_413# 0
C613 dc_inst.x4.x11/a_27_47# dc_inst.x4.x8/a_27_47# 0
C614 path[6] delay_sel[1] 0
C615 dc_inst.x6.x2/a_27_47# dc_inst.x5.net19 0.00853f
C616 dc_inst.x6.net3 dc_inst.x5.x19/a_27_47# 0
C617 dc_inst.x6.net1 dc_inst.x6.net11 0.27556f
C618 dc_inst.x1.x20/a_27_47# dc_inst.x6.net13 0
C619 dc_inst.x7.x14/a_27_47# dc_inst.x7.net9 0
C620 _15_/a_193_369# path[6] 0.00165f
C621 dc_inst.x2.net17 dc_inst.x8/a_1478_413# 0
C622 path_sel[0] dc_inst.x4.net18 0.00333f
C623 dc_inst.net4 dc_inst.x7.net6 0.08389f
C624 _05_ shadow_q 0.00113f
C625 dc_inst.x2.net5 dc_inst.x2.net14 0
C626 dc_inst.x3.x15/a_27_47# shadow_q 0.0043f
C627 dc_inst.x2.net5 dc_inst.x5.net12 0
C628 VPWR _23_/a_448_47# 0.00221f
C629 dc_inst.x6.x5/a_27_47# dc_inst.x6.net11 0.001f
C630 dc_inst.x7.net15 dc_inst.x7.net1 0.02169f
C631 dc_inst.x6.net7 dc_inst.x4.net19 0.1392f
C632 se dc_inst.x3.x13/a_27_47# 0
C633 dc_inst.x1.x3/a_27_47# path[4] 0.00109f
C634 dc_inst.x4.net9 dc_inst.x4.net10 0.01448f
C635 _25_/a_1108_47# dc_inst.x7.net19 0
C636 dc_inst.x1.net16 dc_inst.x2.x15/a_27_47# 0.01342f
C637 dc_inst.x1.net11 path_sel[1] 0.08633f
C638 dc_inst.x1.x20/a_27_47# dc_inst.x6.net12 0
C639 dc_inst.x7.net13 dc_inst.x7.net9 0.00672f
C640 dc_inst.x1.net17 dc_inst.x2.x3/a_27_47# 0
C641 VPWR _14_/a_218_47# -0
C642 dc_inst.x7.x2/a_27_47# dc_inst.x7.net16 0
C643 dc_inst.x7.net3 dc_inst.x7.x16/a_27_47# 0
C644 dc_inst.x5.net6 dc_inst.x4.x9/a_27_47# 0
C645 dc_inst.x5.net10 path_sel[1] 0.00551f
C646 dc_inst.x5.net1 path[0] 0
C647 delay_sel[2] dc_inst.x3.net4 0
C648 dc_inst.x2.x20/a_27_47# dc_inst.in 0.05418f
C649 dc_inst.x5.x4/a_27_47# dc_inst.x5.x10/a_27_47# 0.08729f
C650 dc_inst.x6.x6/a_27_47# dc_inst.x5.net3 0
C651 _18_/a_218_47# dc_inst.x5.net12 0
C652 dc_inst.x4.x1/a_27_47# dc_inst.x1.net2 0
C653 _14_/a_76_199# dc_inst.x3.net7 0
C654 delay_sel[2] dc_inst.x7.net18 0
C655 dc_inst.x1.x15/a_27_47# dc_inst.x5.net1 0
C656 delay_sel[0] dc_inst.x6.x12/a_27_47# 0
C657 dc_inst.x7.net14 dc_inst.x7.net17 0
C658 capture_d delay_sel[2] 0.10177f
C659 dc_inst.x1.x4/a_27_47# dc_inst.x1.net14 0
C660 _18_/a_505_21# _06_ 0
C661 VPWR _13_/a_470_297# -0
C662 dc_inst.x3.x9/a_27_47# dc_inst.x3.net15 0
C663 dc_inst.x5.net12 dc_inst.x5.x1/a_27_47# 0
C664 dc_inst.x6.x3/a_27_47# dc_inst.x6.net8 0.01273f
C665 dc_inst.x6.net4 dc_inst.x6.x7/a_27_47# 0
C666 dc_inst.x1.net5 _20_/a_470_297# 0
C667 dc_inst.x3.net7 dc_inst.x3.net14 0.30059f
C668 dc_inst.x1.net15 dc_inst.x4.x1/a_27_47# 0
C669 dc_inst.x6.net6 dc_inst.x6.net7 0.00299f
C670 _15_/a_397_47# path[7] 0
C671 _25_/a_448_47# clk 0
C672 _15_/a_1060_369# path[5] 0.00119f
C673 _15_/a_872_316# path[4] 0.00547f
C674 dc_inst.x7.x15/a_27_47# dc_inst.x7.net18 0.01666f
C675 dc_inst.x1.net15 dc_inst.x7.net4 0
C676 dc_inst.x2.net14 dc_inst.x2.x3/a_27_47# 0
C677 dc_inst.x1.net15 dc_inst.x2.net11 0
C678 dc_inst.x4.net2 dc_inst.x1.x19/a_27_47# 0
C679 dc_inst.x4.x2/a_27_47# dc_inst.x1.net18 0
C680 VPWR dc_inst.x10/a_218_47# -0
C681 dc_inst.x7.x13/a_27_47# dc_inst.x7.net12 0.01455f
C682 dc_inst.x1.x20/a_27_47# path_sel[1] 0
C683 dc_inst.x4.x4/a_27_47# dc_inst.x6.net14 0.00118f
C684 dc_inst.x3.x19/a_27_47# path[5] 0.00938f
C685 dc_inst.x1.x1/a_27_47# dc_inst.x3.net3 0
C686 dc_inst.x8/a_757_363# dc_inst.x8/a_750_97# -0.00705f
C687 dc_inst.x8/a_277_47# dc_inst.x8/a_1478_413# -0.00884f
C688 dc_inst.x1.net14 dc_inst.x1.x9/a_27_47# 0
C689 dc_inst.in dc_inst.x7.net5 0
C690 _00_ dc_inst.x7.net19 0
C691 dc_inst.x6.net8 dc_inst.x6.net11 0
C692 dc_inst.x1.net12 dc_inst.x3.net14 0
C693 dc_inst.x7.x10/a_27_47# dc_inst.x7.net6 0.01375f
C694 dc_inst.x7.x4/a_27_47# dc_inst.x7.x5/a_27_47# 0.02448f
C695 _24_/a_1108_47# _13_/a_470_47# 0
C696 dc_inst.x5.x15/a_27_47# dc_inst.x5.net19 0
C697 dc_inst.x3.x5/a_27_47# dc_inst.x3.net17 0
C698 dc_inst.x7.x2/a_27_47# dc_inst.net9 0
C699 dc_inst.x4.net14 path_sel[0] 0.00403f
C700 dc_inst.x4.x18/a_27_47# dc_inst.x6.x10/a_27_47# 0
C701 dc_inst.x1.x14/a_27_47# dc_inst.x2.x11/a_27_47# 0
C702 VPWR dc_inst.x5.x20/a_27_47# -0
C703 dc_inst.in dc_inst.x3.x17/a_27_47# 0
C704 dc_inst.x6.x1/a_27_47# dc_inst.x6.net2 0.0023f
C705 dc_inst.x5.x17/a_27_47# dc_inst.x6.x7/a_27_47# 0
C706 dc_inst.x1.x19/a_27_47# dc_inst.x2.net8 0
C707 dc_inst.x2.net1 _17_/a_174_21# 0
C708 dc_inst.x1.net19 dc_inst.x2.x7/a_27_47# 0
C709 path[3] _06_ 0.00618f
C710 se dc_inst.x3.x8/a_27_47# 0
C711 dc_inst.x3.net18 path[5] 0.02311f
C712 _15_/a_600_345# dc_inst.net2 0
C713 path[1] _07_ 0.00409f
C714 _01_ dc_inst.x3.net17 0.00224f
C715 path_sel[2] dc_inst.x5.x20/a_27_47# 0.0038f
C716 dc_inst.x7.net2 dc_inst.x6.x1/a_27_47# 0.03115f
C717 dc_inst.x1.net14 dc_inst.x5.net11 0
C718 dc_inst.x1.net19 dc_inst.x6.net10 0
C719 dc_inst.x3.net7 dc_inst.x3.x15/a_27_47# 0
C720 _05_ dc_inst.x3.net7 0
C721 dc_inst.x9/a_1290_413# dc_inst.x7.net4 0
C722 _24_/a_27_47# delay_sel[2] 0.0312f
C723 _24_/a_543_47# shadow_q 0
C724 _24_/a_761_289# capture_d 0
C725 dc_inst.net3 dc_inst.x3.x20/a_27_47# 0.00684f
C726 dc_inst.x9/a_757_363# dc_inst.x7.net5 0
C727 dc_inst.x1.net16 dc_inst.x2.x6/a_27_47# 0
C728 dc_inst.x1.x17/a_27_47# dc_inst.x2.net6 0.00189f
C729 dc_inst.x2.x10/a_27_47# dc_inst.x1.x9/a_27_47# 0
C730 tdo dc_inst.x2.net15 0
C731 _25_/a_1270_413# dc_inst.x7.net1 0
C732 dc_inst.x2.net17 dc_inst.x1.x15/a_27_47# 0
C733 clkbuf_1_1__f_clk/a_110_47# dc_inst.x3.net15 0
C734 tdo clkbuf_0_clk/a_110_47# 0
C735 path[7] path[4] 0.17682f
C736 dc_inst.x6.net4 dc_inst.x5.net2 0
C737 dc_inst.x6.x13/a_27_47# dc_inst.x4.x6/a_27_47# 0
C738 dc_inst.x1.net18 dc_inst.x6.x5/a_27_47# 0
C739 dc_inst.x4.x13/a_27_47# path_sel[0] 0
C740 dc_inst.x2.x16/a_27_47# dc_inst.x8/a_1290_413# 0
C741 dc_inst.x7.x19/a_27_47# dc_inst.x7.net8 0
C742 dc_inst.x1.net11 path[3] 0.01656f
C743 dc_inst.x1.net4 _15_/a_600_345# 0
C744 _19_/a_27_47# _19_/a_465_47# -0
C745 dc_inst.x6.x19/a_27_47# _03_ 0
C746 VPWR _07_ 0.22784f
C747 dc_inst.x8/a_247_21# dc_inst.net2 -0.00142f
C748 dc_inst.x5.net9 dc_inst.x2.net13 0
C749 dc_inst.x1.x1/a_27_47# _15_/a_288_47# 0
C750 dc_inst.x1.x17/a_27_47# dc_inst.x2.net18 0
C751 _02_ _13_/a_470_297# 0.00914f
C752 dc_inst.x5.net6 dc_inst.x5.x12/a_27_47# 0
C753 dc_inst.x2.x10/a_27_47# dc_inst.x5.net11 0.11178f
C754 dc_inst.x2.net1 dc_inst.x5.x11/a_27_47# 0.00131f
C755 _25_/a_1108_47# dc_inst.x7.net17 0
C756 path_sel[2] _07_ 0
C757 dc_inst.x3.net19 dc_inst.x3.net10 0
C758 dc_inst.x5.x9/a_27_47# path[1] 0
C759 dc_inst.x7.net3 dc_inst.x7.net2 0.00552f
C760 dc_inst.x2.net6 dc_inst.x2.x14/a_27_47# 0
C761 path[6] dc_inst.net2 0.01232f
C762 _01_ dc_inst.x2.x19/a_27_47# 0
C763 dc_inst.x7.net15 VPWR -0.00394f
C764 dc_inst.x2.net7 dc_inst.x2.net3 0.01358f
C765 dc_inst.x3.x4/a_27_47# dc_inst.x3.x19/a_27_47# 0.02448f
C766 dc_inst.x4.x1/a_27_47# delay_sel[0] 0.00925f
C767 dc_inst.x4.net16 dc_inst.x5.net5 0
C768 rst dc_inst.x3.net12 0
C769 dc_inst.x1.net4 dc_inst.x8/a_247_21# 0
C770 dc_inst.x2.x11/a_27_47# dc_inst.x2.net12 0.00362f
C771 dc_inst.x2.net11 dc_inst.x2.x12/a_27_47# 0.03648f
C772 _25_/a_193_47# delay_sel[2] 0.00113f
C773 delay_sel[0] dc_inst.x7.net4 0.01886f
C774 _24_/a_1217_47# delay_sel[2] 0
C775 dc_inst.x3.x1/a_27_47# dc_inst.x8/a_1290_413# 0.00209f
C776 clkbuf_0_clk/a_110_47# clknet_1_0__leaf_clk 0
C777 _04_ _15_/a_600_345# 0
C778 dc_inst.x3.x6/a_27_47# dc_inst.x3.net6 0.03883f
C779 dc_inst.x4.x11/a_27_47# path_sel[0] 0
C780 VPWR dc_inst.x5.x9/a_27_47# 0.05231f
C781 dc_inst.x5.net18 path_sel[1] 0.0028f
C782 dc_inst.x3.x7/a_27_47# dc_inst.x3.net1 0
C783 dc_inst.x2.x18/a_27_47# dc_inst.x2.net14 0
C784 dc_inst.x3.net5 dc_inst.x3.x18/a_27_47# 0
C785 _24_/a_27_47# _24_/a_761_289# -0.00784f
C786 dc_inst.in _23_/a_761_289# 0
C787 dc_inst.x3.x4/a_27_47# dc_inst.x3.net18 0.00173f
C788 path_sel[1] dc_inst.x4.net10 0.03305f
C789 _25_/a_1270_413# _03_ -0
C790 dc_inst.x1.net4 path[6] 0.17439f
C791 dc_inst.x3.net3 dc_inst.x3.net17 0.09203f
C792 _19_/a_193_297# _10_ 0
C793 dc_inst.x6.net16 dc_inst.x6.x20/a_27_47# 0
C794 clkload0/a_27_47# _23_/a_193_47# 0
C795 dc_inst.net3 dc_inst.x2.net17 0
C796 dc_inst.x7.x11/a_27_47# dc_inst.x7.net11 0.00287f
C797 _00_ dc_inst.x7.net17 0
C798 dc_inst.x5.net12 dc_inst.x4.net18 0.04961f
C799 dc_inst.x6.x4/a_27_47# dc_inst.x9/a_277_47# 0
C800 dc_inst.x6.x1/a_27_47# dc_inst.x6.x12/a_27_47# 0
C801 _24_/a_651_413# VPWR -0.00409f
C802 VPWR dc_inst.x6.x19/a_27_47# 0.03288f
C803 tdo dc_inst.x2.net7 0
C804 dc_inst.x4.net7 dc_inst.x4.x8/a_27_47# 0
C805 delay_sel[0] dc_inst.net4 0.36399f
C806 dc_inst.x5.net16 dc_inst.x5.net3 0
C807 _13_/a_470_47# dc_inst.x3.x5/a_27_47# 0
C808 dc_inst.x1.net13 dc_inst.x1.net14 0.30267f
C809 dc_inst.x7.x8/a_27_47# dc_inst.x7.x7/a_27_47# 0
C810 dc_inst.x7.net12 _25_/a_448_47# 0
C811 dc_inst.x5.net13 dc_inst.x5.net2 0.0111f
C812 dc_inst.x4.net4 dc_inst.net3 0.00354f
C813 dc_inst.x1.net10 dc_inst.x5.net6 0.00487f
C814 dc_inst.x6.x16/a_27_47# dc_inst.x6.x19/a_27_47# 0
C815 dc_inst.x6.x19/a_27_47# path_sel[2] 0.00282f
C816 clknet_0_clk _23_/a_448_47# 0
C817 dc_inst.x7.net1 dc_inst.x9/a_247_21# 0.0121f
C818 dc_inst.x6.net17 dc_inst.x6.net19 0
C819 dc_inst.in dc_inst.x3.net14 0
C820 dc_inst.x4.net17 dc_inst.x4.net19 0.0365f
C821 dc_inst.x5.net19 dc_inst.x7.x4/a_27_47# 0
C822 dc_inst.x3.net9 dc_inst.x3.net12 0.05878f
C823 dc_inst.x4.net14 dc_inst.x5.x8/a_27_47# 0
C824 _04_ dc_inst.x1.x6/a_27_47# 0.0107f
C825 dc_inst.x7.net19 delay_sel[1] 0
C826 dc_inst.x10/a_76_199# dc_inst.in 0.02939f
C827 dc_inst.x4.x18/a_27_47# dc_inst.x5.net2 0
C828 dc_inst.x4.net17 dc_inst.x5.x2/a_27_47# 0
C829 dc_inst.x1.net13 dc_inst.x2.x10/a_27_47# 0
C830 dc_inst.x2.x20/a_27_47# path[7] 0
C831 rst shadow_q 0
C832 dc_inst.x2.net18 dc_inst.in 0.28459f
C833 dc_inst.x3.net2 dc_inst.x3.net12 0
C834 dc_inst.x5.net9 path_sel[0] 0.00728f
C835 path[3] _15_/a_788_316# 0.00202f
C836 dc_inst.x4.net16 dc_inst.x5.x6/a_27_47# 0.00121f
C837 dc_inst.x4.net1 dc_inst.x4.net12 0
C838 dc_inst.x1.x10/a_27_47# dc_inst.x5.x12/a_27_47# 0.04629f
C839 _25_/a_1270_413# VPWR 0
C840 clkload0/a_27_47# se 0
C841 _15_/a_872_316# dc_inst.x3.net1 0
C842 dc_inst.net3 dc_inst.x8/a_277_47# 0.04768f
C843 dc_inst.x4.x1/a_27_47# dc_inst.x8/a_750_97# 0
C844 VPWR dc_inst.x5.x14/a_27_47# -0.00271f
C845 dc_inst.x3.net13 dc_inst.x3.net19 0
C846 dc_inst.x3.x5/a_27_47# dc_inst.x3.net15 0.00106f
C847 tdo dc_inst.x5.net3 0.03054f
C848 dc_inst.x7.net4 dc_inst.x8/a_750_97# 0.02528f
C849 dc_inst.x4.net17 dc_inst.x6.net6 0
C850 dc_inst.x6.net11 dc_inst.x4.net6 0
C851 delay_sel[0] _23_/a_27_47# 0
C852 _14_/a_76_199# dc_inst.x3.x7/a_27_47# 0
C853 dc_inst.x6.x5/a_27_47# dc_inst.x6.net14 0
C854 dc_inst.x4.x12/a_27_47# path_sel[0] 0
C855 dc_inst.x1.net18 dc_inst.x1.x16/a_27_47# 0
C856 dc_inst.x7.x5/a_27_47# dc_inst.x7.net17 0
C857 _01_ dc_inst.x3.net15 0.00619f
C858 dc_inst.x4.net14 dc_inst.x5.net12 0.00132f
C859 VPWR dc_inst.x5.net8 0.00983f
C860 dc_inst.x4.x17/a_27_47# VPWR 0.02493f
C861 _19_/a_193_297# _20_/a_79_21# 0
C862 _19_/a_27_47# _20_/a_384_47# 0
C863 dc_inst.x4.x10/a_27_47# path_sel[0] 0
C864 _17_/a_174_21# path_sel[1] 0
C865 _17_/a_574_297# path[0] 0.0024f
C866 dc_inst.x9/a_247_21# _03_ 0
C867 _25_/a_193_47# _25_/a_543_47# -0.01017f
C868 dc_inst.x4.x17/a_27_47# path_sel[2] 0.00231f
C869 dc_inst.x7.x14/a_27_47# clkbuf_1_0__f_clk/a_110_47# 0.0095f
C870 dc_inst.x3.x7/a_27_47# dc_inst.x3.net14 0.05149f
C871 _24_/a_1283_21# capture_q 0.03307f
C872 dc_inst.net8 dc_inst.in 0.02711f
C873 dc_inst.x5.x3/a_27_47# path_sel[0] 0
C874 clkload0/a_27_47# delay_sel[2] 0.00732f
C875 dc_inst.x4.net17 dc_inst.x4.net15 0.169f
C876 dc_inst.x4.net3 dc_inst.x7.net2 0
C877 dc_inst.x1.net19 VPWR 0.09248f
C878 dc_inst.x1.net3 _19_/a_27_47# 0.00118f
C879 _15_/a_27_47# dc_inst.x3.net12 0
C880 dc_inst.x5.net14 dc_inst.x4.net12 0
C881 dc_inst.x5.net7 dc_inst.net4 0.0247f
C882 dc_inst.x5.x16/a_27_47# dc_inst.x5.x17/a_27_47# 0
C883 dc_inst.net4 dc_inst.x4.x6/a_27_47# 0.00124f
C884 dc_inst.x2.x17/a_27_47# dc_inst.x2.x18/a_27_47# 0
C885 dc_inst.x3.x1/a_27_47# dc_inst.x2.x20/a_27_47# 0
C886 dc_inst.x5.net18 dc_inst.x6.net10 0
C887 dc_inst.x2.x7/a_27_47# dc_inst.x4.net10 0.00164f
C888 dc_inst.x6.net18 dc_inst.x6.net19 0.01452f
C889 path[7] dc_inst.x3.net1 0.00659f
C890 path[5] dc_inst.x3.net10 0.01399f
C891 dc_inst.x4.x13/a_27_47# dc_inst.x5.net12 0
C892 dc_inst.x7.x13/a_27_47# dc_inst.x9/a_277_47# 0.003f
C893 dc_inst.x1.net19 path_sel[2] 0.01881f
C894 dc_inst.x7.x13/a_27_47# clknet_1_0__leaf_clk 0
C895 dc_inst.x7.net13 clkbuf_1_0__f_clk/a_110_47# 0.00973f
C896 path[2] dc_inst.x1.x6/a_27_47# 0.00101f
C897 dc_inst.x6.x8/a_27_47# dc_inst.x6.net4 0
C898 dc_inst.x3.net9 shadow_q 0
C899 tdo dc_inst.x6.net19 0.00314f
C900 dc_inst.net9 _23_/a_651_413# 0
C901 dc_inst.x1.x10/a_27_47# dc_inst.x1.net10 0.02773f
C902 dc_inst.x6.x1/a_27_47# dc_inst.x7.net4 0
C903 dc_inst.x10/a_439_47# dc_inst.x7.net16 0
C904 dc_inst.net5 dc_inst.x7.x4/a_27_47# 0.06962f
C905 dc_inst.x3.x5/a_27_47# dc_inst.x3.net6 0.00202f
C906 delay_sel[2] dc_inst.x7.x16/a_27_47# 0
C907 dc_inst.x5.net6 dc_inst.x6.x10/a_27_47# 0.00181f
C908 dc_inst.x4.x3/a_27_47# dc_inst.x2.x18/a_27_47# 0
C909 dc_inst.x1.x3/a_27_47# dc_inst.x3.net14 0.11287f
C910 dc_inst.x3.net2 shadow_q 0
C911 VPWR _06_ 0.11223f
C912 dc_inst.x2.net9 path_sel[0] 0
C913 dc_inst.x5.net10 path[1] 0
C914 dc_inst.x5.net6 dc_inst.x2.net4 0.02217f
C915 dc_inst.x5.net1 path_sel[0] 0.00252f
C916 path_sel[1] dc_inst.x5.x11/a_27_47# 0.01776f
C917 dc_inst.x1.x1/a_27_47# path_sel[1] 0
C918 dc_inst.x4.x18/a_27_47# dc_inst.x4.net13 0
C919 _18_/a_505_21# _17_/a_174_21# 0.00151f
C920 _18_/a_76_199# _17_/a_27_93# 0
C921 path_sel[0] dc_inst.x3.x20/a_27_47# 0.01126f
C922 dc_inst.x4.net3 dc_inst.x8/a_757_363# 0
C923 path_sel[2] _06_ 0
C924 _10_ _20_/a_79_21# 0.02305f
C925 rst dc_inst.x3.net7 0
C926 _05_ dc_inst.x3.x7/a_27_47# 0.00119f
C927 dc_inst.x7.net14 dc_inst.x7.net8 0
C928 tdo dc_inst.x6.net11 0.02241f
C929 tdo _24_/a_1108_47# 0
C930 dc_inst.x5.x14/a_27_47# dc_inst.x5.net15 0
C931 dc_inst.x5.net13 dc_inst.x5.x16/a_27_47# 0.01107f
C932 clknet_1_1__leaf_clk capture_q 0.00249f
C933 VPWR dc_inst.x1.net11 0.1365f
C934 dc_inst.x7.x15/a_27_47# dc_inst.x7.x16/a_27_47# 0
C935 dc_inst.x1.net3 dc_inst.x3.net7 0
C936 dc_inst.x7.x3/a_27_47# dc_inst.x2.net18 0
C937 delay_sel[1] dc_inst.x7.net17 0.00183f
C938 dc_inst.x1.net2 _10_ 0
C939 dc_inst.x3.net3 dc_inst.x3.net15 0.01044f
C940 VPWR dc_inst.x9/a_247_21# -0.06411f
C941 VPWR dc_inst.x5.net10 -0.00853f
C942 dc_inst.x6.x1/a_27_47# dc_inst.net4 0.00628f
C943 dc_inst.x1.net2 dc_inst.x1.x7/a_27_47# 0
C944 dc_inst.x1.x2/a_27_47# dc_inst.x1.net7 0.00279f
C945 dc_inst.x1.net11 path_sel[2] 0.03897f
C946 _23_/a_193_47# dc_inst.x8/a_757_363# 0
C947 _23_/a_27_47# dc_inst.x8/a_750_97# 0
C948 _23_/a_543_47# dc_inst.x8/a_277_47# 0
C949 dc_inst.x7.net13 dc_inst.x9/a_27_47# 0
C950 dc_inst.x3.x1/a_27_47# dc_inst.x3.x17/a_27_47# 0
C951 dc_inst.x1.net19 dc_inst.x4.net5 0.12096f
C952 dc_inst.x7.net10 dc_inst.x7.net5 0
C953 path_sel[2] dc_inst.x9/a_247_21# 0.00144f
C954 dc_inst.x9/a_750_97# dc_inst.x6.x20/a_27_47# 0
C955 _15_/a_872_316# dc_inst.x3.net14 0
C956 _25_/a_27_47# rst 0
C957 dc_inst.x7.net3 dc_inst.x7.net4 0.15f
C958 dc_inst.x1.x19/a_27_47# dc_inst.x2.x1/a_27_47# 0.01126f
C959 dc_inst.x1.net3 dc_inst.x1.net12 0.1039f
C960 dc_inst.x1.net19 dc_inst.x1.net8 0
C961 dc_inst.net7 dc_inst.x7.net18 0.00316f
C962 dc_inst.x5.net8 dc_inst.x2.net2 0
C963 capture_d dc_inst.net7 0
C964 dc_inst.x10/a_439_47# dc_inst.net9 0.00157f
C965 dc_inst.x6.net7 dc_inst.x4.net8 0
C966 _15_/a_27_47# shadow_q 0
C967 path[6] _23_/a_1283_21# 0.00194f
C968 path[2] _17_/a_27_93# 0.00611f
C969 _18_/a_218_374# _08_ 0
C970 dc_inst.x1.net15 dc_inst.x1.x7/a_27_47# 0
C971 path[3] _17_/a_174_21# 0.01068f
C972 dc_inst.x5.x8/a_27_47# dc_inst.x5.net9 0.00115f
C973 dc_inst.x5.net19 dc_inst.x7.x8/a_27_47# 0.01382f
C974 _25_/a_27_47# clkbuf_1_0__f_clk/a_110_47# 0.0248f
C975 _24_/a_651_413# clknet_0_clk 0.00199f
C976 dc_inst.x1.x5/a_27_47# path_sel[1] 0
C977 dc_inst.net5 dc_inst.x7.net19 0.00234f
C978 dc_inst.x5.x18/a_27_47# dc_inst.x5.x2/a_27_47# 0
C979 _14_/a_76_199# path[7] 0
C980 _14_/a_218_374# path[6] 0.00106f
C981 _25_/a_448_47# tdo 0
C982 VPWR dc_inst.x1.x20/a_27_47# 0.04831f
C983 _00_ capture_q 0.0384f
C984 dc_inst.x7.x3/a_27_47# dc_inst.net8 0
C985 dc_inst.x1.net18 dc_inst.x2.net3 0
C986 dc_inst.x1.net1 _18_/a_218_47# 0
C987 dc_inst.x1.net19 dc_inst.x2.net2 0.04724f
C988 dc_inst.x3.net7 dc_inst.x3.net9 0
C989 se dc_inst.x3.x19/a_27_47# 0
C990 dc_inst.x5.net5 dc_inst.x2.net7 0.05888f
C991 dc_inst.x5.net6 dc_inst.x2.net6 0.4225f
C992 dc_inst.x7.x6/a_27_47# dc_inst.x7.x7/a_27_47# 0
C993 dc_inst.x1.x20/a_27_47# path_sel[2] 0.01621f
C994 _04_ dc_inst.x3.x10/a_27_47# 0
C995 dc_inst.x5.net14 dc_inst.x5.x13/a_27_47# 0.02399f
C996 dc_inst.x1.net5 dc_inst.x1.net10 0
C997 dc_inst.x2.net11 dc_inst.x5.net11 0
C998 _13_/a_112_47# path[6] 0.02507f
C999 dc_inst.x7.x13/a_27_47# dc_inst.x6.x2/a_27_47# 0
C1000 dc_inst.in dc_inst.x1.x8/a_27_47# 0.03443f
C1001 dc_inst.x6.x5/a_27_47# dc_inst.x6.net13 0
C1002 path[5] dc_inst.x3.net13 0.02625f
C1003 path[7] dc_inst.x3.net14 0
C1004 dc_inst.x1.x1/a_27_47# dc_inst.x3.net16 0
C1005 dc_inst.x1.x13/a_27_47# path_sel[1] 0.00461f
C1006 dc_inst.x4.x10/a_27_47# dc_inst.x1.net17 0
C1007 dc_inst.x5.net9 dc_inst.x2.net14 0
C1008 dc_inst.x5.net9 dc_inst.x5.net12 0.03946f
C1009 dc_inst.x5.x19/a_27_47# dc_inst.x5.net2 0
C1010 dc_inst.x5.net1 dc_inst.x1.net7 0.00116f
C1011 se dc_inst.x3.net18 0
C1012 dc_inst.x1.net10 dc_inst.x2.x15/a_27_47# 0
C1013 path_sel[1] dc_inst.x3.net17 0
C1014 dc_inst.x6.net2 dc_inst.x6.net7 0
C1015 dc_inst.x6.net3 dc_inst.x6.net6 0
C1016 dc_inst.x7.net2 delay_sel[2] 0
C1017 dc_inst.x4.x14/a_27_47# dc_inst.x4.net14 0.00273f
C1018 dc_inst.x6.x5/a_27_47# dc_inst.x6.net12 0.00131f
C1019 path_sel[0] _15_/a_193_47# -0
C1020 dc_inst.x2.net18 path[7] 0
C1021 dc_inst.x1.net18 tdo 0.00118f
C1022 _25_/a_1270_413# clknet_0_clk 0
C1023 _25_/a_448_47# clknet_1_0__leaf_clk 0
C1024 _24_/a_193_47# delay_sel[0] 0
C1025 dc_inst.in dc_inst.net1 0.36395f
C1026 dc_inst.x2.x20/a_27_47# dc_inst.x2.x15/a_27_47# 0
C1027 dc_inst.x6.x18/a_27_47# dc_inst.in 0.02942f
C1028 dc_inst.x4.x12/a_27_47# dc_inst.x5.net12 0
C1029 dc_inst.x1.x20/a_27_47# dc_inst.x4.net5 0.00872f
C1030 dc_inst.x6.x2/a_27_47# dc_inst.x6.x3/a_27_47# 0
C1031 _05_ path[7] 0.00692f
C1032 dc_inst.x7.net3 _23_/a_27_47# 0
C1033 dc_inst.x5.net5 dc_inst.x5.net3 0.17678f
C1034 dc_inst.x4.x10/a_27_47# dc_inst.x5.net12 0
C1035 dc_inst.x2.net10 dc_inst.x2.x14/a_27_47# 0
C1036 dc_inst.x2.x8/a_27_47# dc_inst.x5.net9 0
C1037 dc_inst.x2.x16/a_27_47# dc_inst.x2.net18 0
C1038 dc_inst.x2.net16 dc_inst.x2.x18/a_27_47# 0.01149f
C1039 dc_inst.x3.x9/a_27_47# path[6] 0
C1040 dc_inst.x5.net9 dc_inst.x5.x10/a_27_47# 0.05039f
C1041 path_sel[1] dc_inst.x6.net1 0.00239f
C1042 dc_inst.x2.x9/a_27_47# dc_inst.x5.net12 0.00179f
C1043 dc_inst.x4.net2 dc_inst.x2.x20/a_27_47# 0
C1044 VPWR _15_/a_788_316# 0.02184f
C1045 shadow_q dc_inst.x8/a_1478_413# 0
C1046 dc_inst.x5.x4/a_27_47# dc_inst.x2.net15 0
C1047 dc_inst.x7.x2/a_27_47# dc_inst.x7.net1 0
C1048 dc_inst.x5.net4 dc_inst.x2.x14/a_27_47# 0
C1049 tdo _01_ 0
C1050 dc_inst.x6.net16 dc_inst.net7 0
C1051 dc_inst.x5.x3/a_27_47# dc_inst.x5.net12 0.00212f
C1052 dc_inst.x7.net11 delay_sel[2] 0.00158f
C1053 dc_inst.x2.x18/a_27_47# dc_inst.net2 0.00127f
C1054 dc_inst.x5.x7/a_27_47# path_sel[0] 0.00238f
C1055 _18_/a_218_47# path[2] 0
C1056 _20_/a_384_47# dc_inst.in 0
C1057 _18_/a_535_374# path[3] 0
C1058 dc_inst.x7.net2 dc_inst.x6.x20/a_27_47# 0.02194f
C1059 dc_inst.x1.net4 dc_inst.x3.x14/a_27_47# 0
C1060 dc_inst.x6.x5/a_27_47# path_sel[1] 0
C1061 dc_inst.x6.net17 dc_inst.x6.net14 0.13692f
C1062 dc_inst.x5.x15/a_27_47# dc_inst.x5.net3 0
C1063 dc_inst.x1.x5/a_27_47# path[3] 0.00131f
C1064 rst dc_inst.in 0.02657f
C1065 dc_inst.x2.net5 dc_inst.x2.net15 0
C1066 dc_inst.x1.net12 _15_/a_27_47# 0
C1067 dc_inst.x1.net15 dc_inst.x1.net2 0
C1068 VPWR dc_inst.x5.net18 0.05512f
C1069 _25_/a_193_47# dc_inst.net7 0
C1070 dc_inst.x1.net16 dc_inst.x1.net14 0
C1071 dc_inst.x6.net9 dc_inst.x4.net18 0
C1072 VPWR dc_inst.x8/a_193_413# 0.00538f
C1073 dc_inst.x4.x20/a_27_47# path_sel[1] 0.00892f
C1074 VPWR dc_inst.x4.net10 0.04539f
C1075 dc_inst.x1.net4 dc_inst.x2.x18/a_27_47# 0
C1076 dc_inst.x1.net3 dc_inst.in 0.02823f
C1077 dc_inst.x4.net3 dc_inst.x4.x1/a_27_47# 0
C1078 dc_inst.x6.net17 dc_inst.net9 0
C1079 dc_inst.x2.x8/a_27_47# dc_inst.x2.x9/a_27_47# 0
C1080 dc_inst.x2.net9 dc_inst.x5.net12 0
C1081 dc_inst.x5.net18 path_sel[2] 0.00575f
C1082 dc_inst.x2.net17 dc_inst.x1.net7 0
C1083 dc_inst.net5 dc_inst.x7.net17 0
C1084 dc_inst.x6.net14 dc_inst.x4.net6 0
C1085 dc_inst.x5.net1 dc_inst.x5.net12 0.09339f
C1086 dc_inst.x4.net16 dc_inst.x4.net18 0
C1087 dc_inst.x5.x8/a_27_47# dc_inst.x4.net7 0
C1088 dc_inst.x5.net8 dc_inst.x4.x7/a_27_47# 0
C1089 dc_inst.x1.net17 dc_inst.x4.net7 0
C1090 path_sel[2] dc_inst.x8/a_193_413# 0
C1091 dc_inst.x4.net3 dc_inst.x7.net4 0.00132f
C1092 path_sel[2] dc_inst.x4.net10 0
C1093 clkbuf_1_0__f_clk/a_110_47# dc_inst.in 0
C1094 dc_inst.x7.x2/a_27_47# dc_inst.x7.x18/a_27_47# 0.08729f
C1095 dc_inst.x7.net9 dc_inst.x7.net10 0.0053f
C1096 delay_sel[0] dc_inst.x7.net6 0.00126f
C1097 _01_ clknet_1_0__leaf_clk 0
C1098 _04_ dc_inst.x3.x14/a_27_47# 0
C1099 dc_inst.x4.x14/a_27_47# dc_inst.x4.x11/a_27_47# 0.01224f
C1100 dc_inst.x1.net19 dc_inst.x1.x14/a_27_47# 0
C1101 dc_inst.x3.net16 dc_inst.x3.net17 0.01003f
C1102 dc_inst.x4.x1/a_27_47# _23_/a_193_47# 0
C1103 dc_inst.x7.x7/a_27_47# dc_inst.x7.net8 0.04365f
C1104 dc_inst.x2.x18/a_27_47# dc_inst.x1.net9 0.03525f
C1105 clkbuf_1_1__f_clk/a_110_47# path[6] 0.0098f
C1106 capture_q dc_inst.x3.net8 0
C1107 _24_/a_1283_21# dc_inst.x8/a_277_47# 0
C1108 dc_inst.x7.x2/a_27_47# _03_ 0
C1109 dc_inst.x3.x12/a_27_47# dc_inst.x3.x10/a_27_47# 0.01254f
C1110 dc_inst.x1.net2 dc_inst.x3.net19 0.00349f
C1111 dc_inst.x7.net4 _23_/a_193_47# 0
C1112 dc_inst.x9/a_27_413# dc_inst.x9/a_277_47# -0.00157f
C1113 dc_inst.x9/a_193_413# dc_inst.x9/a_247_21# -0.0024f
C1114 dc_inst.x6.net8 path_sel[1] 0.00539f
C1115 dc_inst.x5.x15/a_27_47# dc_inst.x6.x3/a_27_47# 0
C1116 _13_/a_470_297# dc_inst.x3.net5 0
C1117 clknet_0_clk dc_inst.x9/a_247_21# 0
C1118 dc_inst.x2.x8/a_27_47# dc_inst.x2.net9 0.04368f
C1119 dc_inst.x5.x10/a_27_47# dc_inst.x5.net1 0.00105f
C1120 tdo dc_inst.x7.net16 0
C1121 dc_inst.x5.x6/a_27_47# dc_inst.x5.net3 0
C1122 dc_inst.x5.net12 dc_inst.x4.net7 0
C1123 dc_inst.x5.x4/a_27_47# dc_inst.x2.net7 0
C1124 dc_inst.x3.x1/a_27_47# dc_inst.net8 0
C1125 VPWR dc_inst.x8/a_834_97# -0
C1126 dc_inst.x4.x1/a_27_47# dc_inst.x2.net19 0.00236f
C1127 dc_inst.x4.net13 dc_inst.x5.net6 0
C1128 dc_inst.x1.x12/a_27_47# dc_inst.x1.x6/a_27_47# 0
C1129 _24_/a_1108_47# path[6] 0
C1130 dc_inst.x5.x16/a_27_47# dc_inst.x5.x19/a_27_47# 0
C1131 dc_inst.x7.net12 dc_inst.x7.x9/a_27_47# 0.01149f
C1132 rst dc_inst.x3.x7/a_27_47# 0
C1133 dc_inst.x2.net19 dc_inst.x7.net4 0
C1134 dc_inst.x1.net15 dc_inst.x3.net19 0
C1135 dc_inst.x4.net10 dc_inst.x4.net5 0
C1136 dc_inst.x4.net9 dc_inst.x4.net6 0.00134f
C1137 dc_inst.x1.x16/a_27_47# dc_inst.x6.net13 0
C1138 clkbuf_0_clk/a_110_47# dc_inst.x7.net19 0
C1139 dc_inst.x4.net2 dc_inst.x2.net4 0
C1140 dc_inst.x4.net4 dc_inst.x1.net17 0
C1141 dc_inst.x1.x1/a_27_47# dc_inst.x3.x16/a_27_47# 0
C1142 dc_inst.x3.net2 dc_inst.in 0.00405f
C1143 dc_inst.x1.net3 dc_inst.x3.x7/a_27_47# 0
C1144 _17_/a_174_21# path[1] 0.00321f
C1145 _17_/a_574_297# path_sel[0] 0.00143f
C1146 dc_inst.x6.net18 dc_inst.x6.net14 0
C1147 dc_inst.x4.net17 dc_inst.x4.net8 0
C1148 dc_inst.x5.net6 dc_inst.x4.x5/a_27_47# 0.07088f
C1149 dc_inst.x5.net15 dc_inst.x5.net18 0
C1150 dc_inst.x6.x6/a_27_47# path_sel[1] 0.01154f
C1151 dc_inst.x4.net16 dc_inst.x4.net14 0.2086f
C1152 dc_inst.x5.net19 dc_inst.x7.x6/a_27_47# 0.00622f
C1153 tdo dc_inst.x6.net14 0.2289f
C1154 dc_inst.x2.net17 dc_inst.x2.net14 0.00789f
C1155 dc_inst.x4.x14/a_27_47# dc_inst.x5.net9 0
C1156 clknet_1_1__leaf_clk dc_inst.x8/a_277_47# 0
C1157 dc_inst.x2.net8 dc_inst.x2.net4 0.01358f
C1158 dc_inst.x6.net10 dc_inst.x6.net1 0.18548f
C1159 dc_inst.x9/a_277_47# dc_inst.x7.net16 0
C1160 dc_inst.x9/a_277_47# dc_inst.x9/a_668_97# -0.01493f
C1161 dc_inst.x9/a_750_97# dc_inst.x9/a_1478_413# -0.00487f
C1162 dc_inst.x7.x3/a_27_47# rst 0.01786f
C1163 clknet_1_0__leaf_clk dc_inst.x7.net16 0
C1164 dc_inst.x4.net9 dc_inst.x2.net3 0
C1165 dc_inst.x4.net1 dc_inst.x5.net7 0.01765f
C1166 dc_inst.x4.net10 dc_inst.x2.net2 0.01084f
C1167 VPWR _17_/a_174_21# 0.01331f
C1168 tdo dc_inst.net9 0.03396f
C1169 dc_inst.x7.x2/a_27_47# VPWR 0.00454f
C1170 dc_inst.x1.x3/a_27_47# dc_inst.x1.net3 0.04921f
C1171 dc_inst.x4.net11 dc_inst.x5.net6 0
C1172 dc_inst.x3.net16 _23_/a_651_413# 0
C1173 dc_inst.x6.x5/a_27_47# dc_inst.x6.net10 0
C1174 dc_inst.x5.x6/a_27_47# dc_inst.x6.net19 0
C1175 dc_inst.x4.x4/a_27_47# VPWR 0.05217f
C1176 dc_inst.x5.x4/a_27_47# dc_inst.x5.net3 0
C1177 dc_inst.x5.net6 dc_inst.x2.x2/a_27_47# 0.00221f
C1178 dc_inst.x6.x8/a_27_47# dc_inst.x5.x19/a_27_47# 0
C1179 dc_inst.x5.x7/a_27_47# dc_inst.x5.x8/a_27_47# 0.02448f
C1180 dc_inst.x4.x4/a_27_47# path_sel[2] 0
C1181 _15_/a_27_47# dc_inst.in 0.00642f
C1182 _08_ _07_ 0.45869f
C1183 dc_inst.x4.x20/a_27_47# dc_inst.x6.net10 0
C1184 dc_inst.x1.x16/a_27_47# path_sel[1] 0
C1185 dc_inst.x2.net7 dc_inst.x2.x3/a_27_47# 0
C1186 dc_inst.x1.net10 _19_/a_109_297# 0
C1187 dc_inst.x5.net6 dc_inst.net1 0.00691f
C1188 dc_inst.x5.x6/a_27_47# dc_inst.x6.net11 0.00165f
C1189 dc_inst.x1.net11 dc_inst.x2.net12 0
C1190 _23_/a_27_47# _23_/a_193_47# -0.04261f
C1191 dc_inst.net3 shadow_q 0
C1192 dc_inst.x7.net3 _24_/a_193_47# 0
C1193 tdo dc_inst.x4.net9 0.18134f
C1194 VPWR dc_inst.x5.x11/a_27_47# 0.06647f
C1195 dc_inst.x4.x4/a_27_47# dc_inst.x6.net15 0
C1196 dc_inst.x2.x13/a_27_47# dc_inst.x2.net13 0.01506f
C1197 delay_sel[1] dc_inst.x7.net8 0
C1198 dc_inst.x7.net5 dc_inst.x7.net18 0
C1199 dc_inst.x1.x1/a_27_47# VPWR 0.04206f
C1200 dc_inst.x1.net3 _15_/a_872_316# 0.00384f
C1201 dc_inst.x1.net18 dc_inst.x5.net5 0
C1202 dc_inst.x2.net12 dc_inst.x5.net10 0
C1203 dc_inst.x1.x4/a_27_47# _10_ 0
C1204 delay_sel[2] dc_inst.x7.net4 0.0111f
C1205 dc_inst.x9/a_750_97# dc_inst.net7 0.02258f
C1206 dc_inst.x9/a_277_47# dc_inst.net9 -0
C1207 dc_inst.net7 dc_inst.x7.x16/a_27_47# 0
C1208 dc_inst.x3.x12/a_27_47# dc_inst.x3.x14/a_27_47# 0
C1209 dc_inst.x9/a_1290_413# delay_sel[0] 0.05466f
C1210 dc_inst.x3.x9/a_27_47# dc_inst.x3.x10/a_27_47# 0
C1211 tdo dc_inst.x5.x5/a_27_47# 0.00116f
C1212 dc_inst.x6.x8/a_27_47# dc_inst.x5.net6 0
C1213 dc_inst.x6.net13 dc_inst.x4.net6 0
C1214 dc_inst.x1.x4/a_27_47# dc_inst.x1.x7/a_27_47# 0
C1215 dc_inst.x6.net17 dc_inst.x6.net12 0
C1216 dc_inst.x1.x1/a_27_47# path_sel[2] 0.00257f
C1217 path_sel[2] dc_inst.x5.x11/a_27_47# 0
C1218 clk dc_inst.x7.net1 0.2107f
C1219 dc_inst.x3.x3/a_27_47# dc_inst.x3.net17 0.1581f
C1220 dc_inst.x3.net4 dc_inst.x3.x17/a_27_47# 0.00117f
C1221 delay_sel[1] dc_inst.x3.x20/a_27_47# 0
C1222 delay_sel[0] dc_inst.x3.net19 0
C1223 dc_inst.x5.x7/a_27_47# dc_inst.x5.net12 0
C1224 dc_inst.x6.net6 dc_inst.x7.net5 0
C1225 dc_inst.x6.net5 dc_inst.x6.x9/a_27_47# 0
C1226 dc_inst.x3.net6 path_sel[1] 0
C1227 _01_ dc_inst.x8/a_247_21# 0
C1228 dc_inst.x5.x1/a_27_47# dc_inst.x5.net3 0
C1229 dc_inst.x4.net16 dc_inst.x4.x11/a_27_47# 0.00838f
C1230 dc_inst.x2.x16/a_27_47# dc_inst.net1 0
C1231 dc_inst.x3.x16/a_27_47# dc_inst.x3.net17 0
C1232 dc_inst.x6.net8 dc_inst.x6.net10 0.00212f
C1233 _18_/a_218_374# _07_ 0.00176f
C1234 _09_ _16_/a_229_47# 0
C1235 _18_/a_439_47# path_sel[0] 0
C1236 dc_inst.x1.x3/a_27_47# dc_inst.x3.net2 0.03068f
C1237 dc_inst.x4.net2 dc_inst.x2.net18 0.01468f
C1238 dc_inst.x2.net6 dc_inst.x2.net8 0
C1239 dc_inst.x6.net9 dc_inst.x7.x6/a_27_47# 0
C1240 dc_inst.x6.x1/a_27_47# dc_inst.x7.net6 0
C1241 dc_inst.x3.x5/a_27_47# path[6] 0.00526f
C1242 dc_inst.x6.net12 dc_inst.x4.net6 0
C1243 dc_inst.x4.x4/a_27_47# dc_inst.x4.net5 0.03066f
C1244 dc_inst.x7.x3/a_27_47# dc_inst.x3.net2 0
C1245 _14_/a_505_21# dc_inst.x3.net12 0
C1246 path[5] _20_/a_79_21# 0.00636f
C1247 clkbuf_0_clk/a_110_47# dc_inst.x7.net17 0
C1248 dc_inst.x1.net12 dc_inst.x1.x15/a_27_47# 0.07418f
C1249 dc_inst.x7.x14/a_27_47# dc_inst.x7.x19/a_27_47# 0
C1250 dc_inst.x1.x9/a_27_47# dc_inst.x1.x7/a_27_47# 0.02448f
C1251 dc_inst.net6 dc_inst.x7.x5/a_27_47# 0.01802f
C1252 dc_inst.x9/a_247_21# dc_inst.x8/a_27_413# 0
C1253 rst path[7] 0.00125f
C1254 _01_ path[6] 0.01078f
C1255 dc_inst.x6.net19 dc_inst.x7.x4/a_27_47# 0
C1256 dc_inst.x3.net15 dc_inst.x3.net16 0.00349f
C1257 dc_inst.x6.x20/a_27_47# dc_inst.x7.net4 0.03111f
C1258 dc_inst.x6.net7 dc_inst.net4 0
C1259 dc_inst.x3.x13/a_27_47# dc_inst.x3.net1 0.01163f
C1260 _13_/a_27_297# dc_inst.x3.net11 0
C1261 dc_inst.x3.x7/a_27_47# _15_/a_27_47# 0
C1262 dc_inst.x1.net3 path[7] 0.03857f
C1263 dc_inst.x1.net2 path[5] 0
C1264 dc_inst.x1.net15 dc_inst.x8/a_750_97# 0
C1265 dc_inst.x7.net13 dc_inst.x7.x19/a_27_47# 0
C1266 dc_inst.x2.x17/a_27_47# dc_inst.x2.net17 0.01467f
C1267 dc_inst.x1.x18/a_27_47# dc_inst.in 0
C1268 dc_inst.x1.x5/a_27_47# VPWR -0.01123f
C1269 dc_inst.x3.x6/a_27_47# dc_inst.x3.x10/a_27_47# 0
C1270 dc_inst.x2.x6/a_27_47# dc_inst.x2.net6 0.01247f
C1271 _19_/a_193_297# _09_ 0.00899f
C1272 dc_inst.x5.net19 dc_inst.x7.net8 0.05214f
C1273 dc_inst.x7.x15/a_27_47# dc_inst.net4 0
C1274 dc_inst.x7.net2 dc_inst.x9/a_1478_413# 0.00986f
C1275 dc_inst.in dc_inst.x8/a_1478_413# 0.01234f
C1276 dc_inst.x5.net11 dc_inst.x1.x7/a_27_47# 0
C1277 dc_inst.x5.net6 dc_inst.x2.net10 0
C1278 dc_inst.x7.net10 dc_inst.x7.net7 0
C1279 dc_inst.x4.net2 dc_inst.net8 0
C1280 path_sel[1] dc_inst.x4.net6 0.00275f
C1281 dc_inst.x1.x5/a_27_47# path_sel[2] 0.00252f
C1282 dc_inst.x5.net4 dc_inst.x5.net6 0.00711f
C1283 path[5] dc_inst.x3.x11/a_27_47# 0.00606f
C1284 dc_inst.x6.net8 dc_inst.x7.net1 0
C1285 dc_inst.x1.net4 capture_q 0
C1286 dc_inst.x4.x3/a_27_47# dc_inst.x2.net17 0.0026f
C1287 tdi dc_inst.x3.net12 0
C1288 tdo dc_inst.x6.net13 0.0056f
C1289 dc_inst.x4.net16 dc_inst.x5.net9 0
C1290 dc_inst.x6.net3 dc_inst.x6.x14/a_27_47# 0
C1291 dc_inst.x4.net10 dc_inst.x4.x7/a_27_47# 0
C1292 dc_inst.x4.x9/a_27_47# dc_inst.x4.net8 0
C1293 dc_inst.x1.x4/a_27_47# _20_/a_79_21# 0
C1294 dc_inst.x1.x13/a_27_47# VPWR -0.01126f
C1295 dc_inst.x6.net18 dc_inst.x6.net12 0
C1296 dc_inst.x5.net16 path_sel[1] 0.01993f
C1297 dc_inst.x4.x15/a_27_47# dc_inst.x6.net1 0
C1298 dc_inst.x6.x7/a_27_47# dc_inst.x4.net19 0
C1299 dc_inst.x6.x8/a_27_47# dc_inst.x7.net10 0
C1300 _23_/a_543_47# shadow_q 0
C1301 delay_sel[2] _23_/a_27_47# 0.03341f
C1302 capture_d _23_/a_761_289# 0.00601f
C1303 dc_inst.x3.net3 dc_inst.x8/a_247_21# 0
C1304 dc_inst.x3.x2/a_27_47# dc_inst.x8/a_1290_413# 0
C1305 VPWR dc_inst.x3.net17 0.27649f
C1306 dc_inst.x2.x16/a_27_47# dc_inst.x2.net10 0
C1307 dc_inst.x4.x3/a_27_47# dc_inst.x4.net4 0.0092f
C1308 dc_inst.x1.x13/a_27_47# path_sel[2] 0.01042f
C1309 dc_inst.x3.net19 dc_inst.x8/a_750_97# 0
C1310 dc_inst.x4.x2/a_27_47# VPWR 0.00316f
C1311 dc_inst.x2.x13/a_27_47# path_sel[0] 0
C1312 tdo dc_inst.x6.net12 0.00996f
C1313 dc_inst.x6.net2 dc_inst.net7 0
C1314 dc_inst.x3.net6 dc_inst.x3.net16 0.00268f
C1315 dc_inst.x3.x1/a_27_47# rst 0
C1316 dc_inst.x3.net9 path[7] 0
C1317 path_sel[1] dc_inst.x2.net3 0.00783f
C1318 path_sel[2] dc_inst.x3.net17 0
C1319 dc_inst.x4.x2/a_27_47# path_sel[2] 0.00628f
C1320 dc_inst.x1.x4/a_27_47# dc_inst.x1.net2 0
C1321 dc_inst.x4.net16 dc_inst.x4.x12/a_27_47# 0.03296f
C1322 dc_inst.x6.x10/a_27_47# dc_inst.x6.x11/a_27_47# 0.02448f
C1323 _10_ _09_ 0
C1324 dc_inst.net6 delay_sel[1] 0.01759f
C1325 dc_inst.x7.net2 dc_inst.net7 0.13481f
C1326 dc_inst.x4.x18/a_27_47# dc_inst.x4.x16/a_27_47# 0.08729f
C1327 dc_inst.x3.net3 path[6] 0.08039f
C1328 dc_inst.x3.x2/a_27_47# path[4] 0
C1329 dc_inst.x3.net2 path[7] 0
C1330 _09_ dc_inst.x1.x7/a_27_47# 0
C1331 dc_inst.x3.x8/a_27_47# dc_inst.x3.net1 0.03793f
C1332 path[5] dc_inst.x3.net19 0.04528f
C1333 dc_inst.x1.net6 _10_ 0.03146f
C1334 dc_inst.x3.net15 _23_/a_1108_47# 0
C1335 dc_inst.x4.x15/a_27_47# dc_inst.x4.x20/a_27_47# 0
C1336 path_sel[0] dc_inst.x3.net12 0
C1337 dc_inst.x3.net4 dc_inst.x3.net14 0.01044f
C1338 dc_inst.x5.net9 dc_inst.x1.net9 0
C1339 dc_inst.x6.x6/a_27_47# dc_inst.x4.x19/a_27_47# 0
C1340 dc_inst.x4.x2/a_27_47# dc_inst.x6.net15 0
C1341 dc_inst.x1.net16 dc_inst.x4.x1/a_27_47# 0
C1342 dc_inst.x6.net6 dc_inst.x6.x7/a_27_47# 0.00336f
C1343 VPWR dc_inst.x6.net1 0.00948f
C1344 dc_inst.x1.x4/a_27_47# dc_inst.x1.net15 0
C1345 dc_inst.x7.x13/a_27_47# dc_inst.x7.x8/a_27_47# 0
C1346 dc_inst.x6.net2 dc_inst.x5.x18/a_27_47# 0.01273f
C1347 clk VPWR 0.07929f
C1348 dc_inst.x2.net12 dc_inst.x4.net10 0
C1349 dc_inst.x1.net2 dc_inst.x1.x9/a_27_47# 0
C1350 dc_inst.x4.x3/a_27_47# dc_inst.x8/a_277_47# 0
C1351 dc_inst.x7.x2/a_27_47# clknet_0_clk 0.00146f
C1352 path_sel[2] dc_inst.x6.net1 0.00484f
C1353 dc_inst.x7.net12 dc_inst.x7.net1 0.10592f
C1354 clkbuf_1_0__f_clk/a_110_47# dc_inst.x7.net10 0
C1355 delay_sel[1] dc_inst.x8/a_277_47# 0.15614f
C1356 delay_sel[0] dc_inst.x8/a_750_97# 0.01114f
C1357 dc_inst.net9 dc_inst.x8/a_247_21# 0.01206f
C1358 tdo path_sel[1] 0.03675f
C1359 dc_inst.x4.x4/a_27_47# dc_inst.x6.x15/a_27_47# 0
C1360 VPWR dc_inst.x6.x5/a_27_47# 0.01404f
C1361 dc_inst.x1.x2/a_27_47# dc_inst.x1.net1 0.00122f
C1362 dc_inst.x6.net2 dc_inst.x6.net3 0.01963f
C1363 dc_inst.x1.net5 dc_inst.x1.x8/a_27_47# 0
C1364 dc_inst.x10/a_76_199# capture_d 0.01955f
C1365 delay_sel[2] _23_/a_1217_47# 0
C1366 VPWR dc_inst.x2.x19/a_27_47# 0
C1367 _25_/a_543_47# dc_inst.net4 0
C1368 _13_/a_27_297# dc_inst.x3.net15 0
C1369 dc_inst.x3.x20/a_27_47# dc_inst.net2 0.00281f
C1370 VPWR dc_inst.x3.net11 0.21192f
C1371 dc_inst.x3.x13/a_27_47# dc_inst.x3.net14 0.00407f
C1372 dc_inst.x5.net3 dc_inst.x4.net18 0.08807f
C1373 dc_inst.x5.net2 dc_inst.x4.net19 0.0331f
C1374 dc_inst.x6.x5/a_27_47# path_sel[2] 0.01084f
C1375 dc_inst.x1.x13/a_27_47# dc_inst.x1.net8 0.03051f
C1376 dc_inst.x2.x19/a_27_47# path_sel[2] 0
C1377 dc_inst.x4.x2/a_27_47# dc_inst.x4.net5 0.0255f
C1378 _24_/a_27_47# _23_/a_761_289# 0
C1379 _24_/a_761_289# _23_/a_27_47# 0.00135f
C1380 _24_/a_193_47# _23_/a_193_47# 0
C1381 dc_inst.x3.net17 dc_inst.x1.net8 0
C1382 VPWR dc_inst.x4.x20/a_27_47# 0.01627f
C1383 dc_inst.x1.net15 dc_inst.x1.x9/a_27_47# 0
C1384 dc_inst.x1.x15/a_27_47# dc_inst.in 0
C1385 dc_inst.x4.net13 dc_inst.x2.net8 0
C1386 dc_inst.x3.x6/a_27_47# dc_inst.x3.x14/a_27_47# 0.01254f
C1387 dc_inst.x3.net4 dc_inst.x3.x15/a_27_47# 0
C1388 dc_inst.x3.x3/a_27_47# dc_inst.x3.net15 0
C1389 _15_/a_27_47# path[7] 0.02524f
C1390 _15_/a_288_47# path[6] 0.01701f
C1391 dc_inst.x5.x2/a_27_47# dc_inst.x5.net2 0.02051f
C1392 dc_inst.x4.net14 dc_inst.x2.net7 0
C1393 dc_inst.x4.x20/a_27_47# path_sel[2] 0.00326f
C1394 dc_inst.net6 dc_inst.x5.net19 0
C1395 VPWR _23_/a_651_413# 0.01656f
C1396 dc_inst.x3.x1/a_27_47# dc_inst.x3.net2 0.00249f
C1397 dc_inst.x1.net4 dc_inst.x3.x20/a_27_47# 0.02385f
C1398 dc_inst.x1.x4/a_27_47# dc_inst.x3.net19 0
C1399 dc_inst.x3.net15 dc_inst.x3.x16/a_27_47# 0.12306f
C1400 dc_inst.x3.net6 _23_/a_1108_47# 0
C1401 _02_ dc_inst.x3.net17 0
C1402 dc_inst.x4.net2 dc_inst.x1.x8/a_27_47# 0
C1403 dc_inst.x1.net11 _08_ 0.01026f
C1404 dc_inst.x1.x12/a_27_47# dc_inst.x3.x14/a_27_47# 0
C1405 dc_inst.x1.net15 dc_inst.x5.net11 0
C1406 dc_inst.x7.net3 dc_inst.x9/a_1290_413# 0
C1407 VPWR _14_/a_439_47# -0
C1408 dc_inst.x6.net10 dc_inst.x4.net6 0.00979f
C1409 _14_/a_505_21# dc_inst.x3.net7 0
C1410 dc_inst.x3.x4/a_27_47# dc_inst.x3.net19 0.00448f
C1411 dc_inst.x6.net6 dc_inst.x5.net2 0.09492f
C1412 dc_inst.net7 dc_inst.x6.x12/a_27_47# 0
C1413 capture_d dc_inst.net8 0.00218f
C1414 dc_inst.x5.x5/a_27_47# dc_inst.x5.net5 0.01513f
C1415 VPWR dc_inst.x6.net8 0.17991f
C1416 dc_inst.x6.x1/a_27_47# delay_sel[0] 0
C1417 _09_ _20_/a_79_21# 0
C1418 dc_inst.x4.x13/a_27_47# dc_inst.x2.net7 0
C1419 dc_inst.x2.x10/a_27_47# dc_inst.x5.x12/a_27_47# 0
C1420 VPWR _13_/a_470_47# -0
C1421 dc_inst.x4.net16 dc_inst.x4.net7 0
C1422 dc_inst.x5.net1 dc_inst.x1.net9 0
C1423 dc_inst.x7.net12 _03_ 0
C1424 dc_inst.x1.net6 _20_/a_79_21# 0
C1425 dc_inst.x1.x1/a_27_47# dc_inst.x1.x14/a_27_47# 0
C1426 dc_inst.x1.net18 dc_inst.x2.x3/a_27_47# 0
C1427 _24_/a_27_47# dc_inst.x10/a_76_199# 0
C1428 dc_inst.x6.net8 path_sel[2] 0.00407f
C1429 dc_inst.x2.net16 dc_inst.x2.net17 0.0047f
C1430 dc_inst.x4.net2 dc_inst.net1 0.04364f
C1431 dc_inst.x2.x11/a_27_47# dc_inst.x5.net10 0.01151f
C1432 dc_inst.x2.x7/a_27_47# dc_inst.x2.net3 0
C1433 dc_inst.x6.x4/a_27_47# dc_inst.x7.x6/a_27_47# 0
C1434 _15_/a_1064_47# path[7] 0.00165f
C1435 _15_/a_1279_413# path[5] 0
C1436 _15_/a_1060_369# path[4] 0.00105f
C1437 dc_inst.x4.net2 dc_inst.x6.x18/a_27_47# 0
C1438 dc_inst.net3 dc_inst.in 0.05576f
C1439 dc_inst.x4.net15 dc_inst.x5.net2 0
C1440 dc_inst.x4.net14 dc_inst.x5.net3 0.12403f
C1441 VPWR dc_inst.x10/a_439_47# 0.00107f
C1442 dc_inst.x4.net17 dc_inst.net4 0.06713f
C1443 dc_inst.x1.net5 dc_inst.x1.net3 0.20478f
C1444 dc_inst.x8/a_277_47# dc_inst.x8/a_27_47# -0.0075f
C1445 dc_inst.x6.net11 dc_inst.x4.net18 0
C1446 dc_inst.x5.net9 dc_inst.x2.net15 0
C1447 dc_inst.x1.net10 dc_inst.x1.net14 0
C1448 _02_ dc_inst.x3.net11 0.00405f
C1449 VPWR dc_inst.x6.x6/a_27_47# -0.0055f
C1450 dc_inst.x6.x2/a_27_47# dc_inst.x7.x9/a_27_47# 0
C1451 dc_inst.x7.x14/a_27_47# dc_inst.x7.net14 0.00301f
C1452 _24_/a_27_47# _05_ 0
C1453 dc_inst.x3.net6 dc_inst.x3.x16/a_27_47# 0
C1454 dc_inst.x7.net3 delay_sel[0] 0
C1455 dc_inst.x5.net7 dc_inst.x4.x6/a_27_47# 0.11198f
C1456 _19_/a_27_47# path_sel[0] 0.0046f
C1457 tdi dc_inst.x3.net7 0
C1458 dc_inst.x4.net13 dc_inst.x4.net19 0
C1459 dc_inst.x6.net3 dc_inst.x6.x12/a_27_47# 0
C1460 dc_inst.x1.net4 dc_inst.x2.net17 0
C1461 dc_inst.x2.net1 _17_/a_27_93# 0
C1462 dc_inst.x6.x6/a_27_47# path_sel[2] 0
C1463 path[5] dc_inst.x8/a_750_97# 0
C1464 dc_inst.x4.x11/a_27_47# dc_inst.x2.net7 0
C1465 dc_inst.x1.net6 dc_inst.x1.net15 0
C1466 VPWR dc_inst.x3.net15 0.02944f
C1467 dc_inst.x4.net2 rst 0
C1468 dc_inst.x4.x13/a_27_47# dc_inst.x5.net3 0
C1469 dc_inst.x1.net13 dc_inst.x1.net2 0
C1470 dc_inst.x7.net13 dc_inst.x7.net14 0.0035f
C1471 dc_inst.net6 dc_inst.net5 0.42358f
C1472 dc_inst.x9/a_750_97# dc_inst.x7.net5 0
C1473 dc_inst.x7.x2/a_27_47# dc_inst.x7.x20/a_27_47# 0.02448f
C1474 dc_inst.x9/a_1478_413# dc_inst.x7.net4 0
C1475 _24_/a_193_47# delay_sel[2] 0.02948f
C1476 _24_/a_1283_21# shadow_q 0.00395f
C1477 _24_/a_27_47# dc_inst.net8 0
C1478 _24_/a_543_47# capture_d 0.00261f
C1479 tdo dc_inst.x6.net10 0
C1480 _05_ dc_inst.x3.x8/a_27_47# 0.0332f
C1481 dc_inst.x1.net10 dc_inst.x2.x10/a_27_47# 0.00149f
C1482 _25_/a_639_47# dc_inst.x7.net1 0.00136f
C1483 dc_inst.x4.net4 dc_inst.x1.net4 0
C1484 dc_inst.x7.net12 VPWR 0.14233f
C1485 dc_inst.x2.x13/a_27_47# dc_inst.x2.net14 0.00471f
C1486 dc_inst.x2.net13 dc_inst.x2.x14/a_27_47# 0.04469f
C1487 dc_inst.x2.x13/a_27_47# dc_inst.x5.net12 0.11211f
C1488 dc_inst.x2.net10 dc_inst.x2.x15/a_27_47# 0
C1489 dc_inst.x2.net16 dc_inst.x8/a_277_47# 0
C1490 dc_inst.x2.x9/a_27_47# dc_inst.x2.net15 0
C1491 dc_inst.x1.net4 _15_/a_193_47# 0
C1492 dc_inst.x5.net4 dc_inst.x2.x15/a_27_47# 0
C1493 dc_inst.x7.net12 path_sel[2] 0
C1494 dc_inst.x6.net6 dc_inst.x4.net13 0
C1495 dc_inst.x6.net7 dc_inst.x4.net12 0.00288f
C1496 dc_inst.x1.net13 dc_inst.x1.net15 0.08151f
C1497 dc_inst.x2.net17 dc_inst.x1.net9 0.06166f
C1498 dc_inst.x5.x16/a_27_47# dc_inst.x4.net19 0
C1499 dc_inst.x8/a_277_47# dc_inst.net2 0.115f
C1500 dc_inst.x6.x2/a_27_47# path_sel[1] 0
C1501 VPWR dc_inst.x1.x16/a_27_47# 0.01609f
C1502 _02_ _13_/a_470_47# 0.07199f
C1503 capture_q _13_/a_112_47# 0.05301f
C1504 dc_inst.x4.net3 dc_inst.x1.net15 0
C1505 dc_inst.x4.net11 dc_inst.x4.net19 0
C1506 dc_inst.x2.x2/a_27_47# dc_inst.x4.net19 0
C1507 dc_inst.x1.x16/a_27_47# path_sel[2] 0.0131f
C1508 path_sel[1] _15_/a_600_345# 0.00569f
C1509 dc_inst.x1.x13/a_27_47# dc_inst.x1.x14/a_27_47# 0.02448f
C1510 dc_inst.x4.net4 dc_inst.x1.net9 0
C1511 dc_inst.x4.net16 dc_inst.x5.x7/a_27_47# 0
C1512 dc_inst.x1.net12 path_sel[0] 0.00112f
C1513 dc_inst.x4.x11/a_27_47# dc_inst.x5.net3 0
C1514 dc_inst.x1.net4 dc_inst.x8/a_277_47# 0
C1515 dc_inst.net7 dc_inst.x7.net4 0
C1516 _25_/a_761_289# delay_sel[2] 0
C1517 _25_/a_1283_21# capture_d 0
C1518 dc_inst.x4.net15 dc_inst.x4.net13 0.00632f
C1519 VPWR dc_inst.x3.net6 0.38699f
C1520 clknet_1_1__leaf_clk shadow_q 0.00165f
C1521 _24_/a_1462_47# delay_sel[2] 0
C1522 dc_inst.x3.x1/a_27_47# dc_inst.x8/a_1478_413# 0
C1523 dc_inst.x2.net7 dc_inst.x5.net9 0.06031f
C1524 clk clknet_0_clk 0.00206f
C1525 dc_inst.x1.net2 dc_inst.x2.net19 0.00322f
C1526 tdo dc_inst.x7.net1 0
C1527 dc_inst.x2.net8 dc_inst.x2.net10 0
C1528 dc_inst.x5.net15 dc_inst.x6.x6/a_27_47# 0
C1529 dc_inst.in _23_/a_543_47# 0
C1530 _24_/a_27_47# _24_/a_543_47# -0.00297f
C1531 _24_/a_193_47# _24_/a_761_289# -0.01126f
C1532 dc_inst.x7.net19 dc_inst.x7.net16 0.0612f
C1533 dc_inst.x6.net7 dc_inst.x4.net1 0
C1534 dc_inst.x4.x16/a_27_47# dc_inst.x5.net6 0
C1535 dc_inst.x6.net6 dc_inst.x4.net11 0
C1536 _19_/a_205_47# _10_ 0
C1537 dc_inst.x7.net3 dc_inst.x8/a_750_97# 0
C1538 tdo dc_inst.x4.x19/a_27_47# 0
C1539 _01_ _23_/a_1270_413# 0
C1540 dc_inst.x4.x13/a_27_47# dc_inst.x6.net11 0
C1541 _19_/a_27_47# dc_inst.x1.net7 0.03117f
C1542 dc_inst.x5.net5 path_sel[1] 0.00534f
C1543 dc_inst.x1.net15 dc_inst.x2.net19 0
C1544 _02_ dc_inst.x3.net15 0
C1545 dc_inst.x4.x12/a_27_47# dc_inst.x2.net7 0
C1546 dc_inst.x6.net7 dc_inst.x7.net6 0
C1547 capture_d dc_inst.net1 0
C1548 _24_/a_1270_413# VPWR -0
C1549 dc_inst.x1.x16/a_27_47# dc_inst.x4.net5 0.01453f
C1550 dc_inst.x1.net5 _15_/a_27_47# 0
C1551 dc_inst.net7 dc_inst.net4 0.0022f
C1552 dc_inst.x3.x4/a_27_47# path[5] 0.00127f
C1553 path_sel[1] path[6] 0.06396f
C1554 dc_inst.x2.net5 dc_inst.x4.net9 0
C1555 VPWR dc_inst.x6.net17 0.31693f
C1556 dc_inst.x6.net6 dc_inst.net1 0
C1557 dc_inst.x4.x10/a_27_47# dc_inst.x2.net7 0.00511f
C1558 dc_inst.x2.net7 dc_inst.x2.x9/a_27_47# 0.00138f
C1559 dc_inst.x9/a_1478_413# _23_/a_27_47# 0.00149f
C1560 clknet_0_clk _23_/a_651_413# 0
C1561 dc_inst.x5.x6/a_27_47# dc_inst.x6.net13 0
C1562 dc_inst.x6.net2 dc_inst.x7.net5 0
C1563 dc_inst.x5.net4 dc_inst.x2.x6/a_27_47# 0.00139f
C1564 dc_inst.x5.x3/a_27_47# dc_inst.x2.net7 0
C1565 dc_inst.x5.x15/a_27_47# path_sel[1] 0.01258f
C1566 dc_inst.x2.x4/a_27_47# dc_inst.x5.net6 0.022f
C1567 dc_inst.x6.net16 dc_inst.x6.x17/a_27_47# 0.04886f
C1568 dc_inst.x6.x16/a_27_47# dc_inst.x6.net17 0.04144f
C1569 dc_inst.x7.net1 dc_inst.x9/a_277_47# 0.01263f
C1570 tdo dc_inst.x7.x18/a_27_47# 0
C1571 dc_inst.x6.net17 path_sel[2] 0.01101f
C1572 dc_inst.x7.net1 clknet_1_0__leaf_clk 0.16065f
C1573 _00_ shadow_q 0.00202f
C1574 dc_inst.x5.net13 path_sel[0] 0.00281f
C1575 dc_inst.x5.net9 dc_inst.x5.net3 0.2694f
C1576 VPWR dc_inst.x4.net6 0.04181f
C1577 dc_inst.x7.net2 dc_inst.x7.net5 0
C1578 path_sel[0] dc_inst.x2.x14/a_27_47# 0
C1579 dc_inst.x6.x8/a_27_47# dc_inst.x6.net6 0.00477f
C1580 dc_inst.x5.net14 dc_inst.x6.net7 0.01307f
C1581 _25_/a_1283_21# _24_/a_27_47# 0.00126f
C1582 dc_inst.x10/a_505_21# dc_inst.in 0.00144f
C1583 rst dc_inst.x3.net4 0
C1584 dc_inst.x7.net19 dc_inst.net9 0
C1585 dc_inst.x6.net15 dc_inst.x6.net17 0.075f
C1586 path_sel[2] dc_inst.x4.net6 0.00584f
C1587 tdo _03_ 0.00936f
C1588 rst dc_inst.x7.net18 0
C1589 clkload0/a_27_47# dc_inst.x10/a_76_199# 0
C1590 capture_d rst 0.20933f
C1591 dc_inst.x4.net2 _15_/a_27_47# 0
C1592 dc_inst.x2.net17 dc_inst.x2.net15 0.00365f
C1593 _13_/a_112_47# dc_inst.x3.x20/a_27_47# 0
C1594 VPWR dc_inst.x5.net16 0.01712f
C1595 dc_inst.x2.net7 dc_inst.x2.net9 0.0026f
C1596 dc_inst.x2.net7 dc_inst.x5.net1 0
C1597 dc_inst.x6.net3 dc_inst.net4 0
C1598 dc_inst.x4.x18/a_27_47# path_sel[0] 0.00209f
C1599 dc_inst.x3.x2/a_27_47# dc_inst.x3.net14 0
C1600 dc_inst.net3 dc_inst.x8/a_923_363# 0.00151f
C1601 dc_inst.x4.x12/a_27_47# dc_inst.x5.net3 0
C1602 _02_ dc_inst.x3.net6 0.00481f
C1603 dc_inst.x1.net12 dc_inst.x1.net7 0.03612f
C1604 _18_/a_505_21# dc_inst.x1.x6/a_27_47# 0
C1605 dc_inst.x7.net4 dc_inst.x8/a_1290_413# 0
C1606 dc_inst.x5.net16 path_sel[2] 0.00135f
C1607 dc_inst.x6.net15 dc_inst.x4.net6 0
C1608 dc_inst.x4.net9 dc_inst.x2.x3/a_27_47# 0
C1609 dc_inst.x9/a_277_47# dc_inst.x7.x18/a_27_47# 0
C1610 tdo dc_inst.x4.x15/a_27_47# 0
C1611 VPWR dc_inst.x2.net3 0.07998f
C1612 delay_sel[0] _23_/a_193_47# 0
C1613 clknet_1_0__leaf_clk dc_inst.x7.x18/a_27_47# 0
C1614 clkbuf_1_0__f_clk/a_110_47# dc_inst.x7.net18 0.01181f
C1615 dc_inst.x4.x10/a_27_47# dc_inst.x5.net3 0
C1616 _24_/a_27_47# dc_inst.net1 0
C1617 dc_inst.x2.x9/a_27_47# dc_inst.x5.net3 0
C1618 capture_q clkbuf_1_1__f_clk/a_110_47# 0.02509f
C1619 dc_inst.x6.net17 dc_inst.x4.net5 0
C1620 dc_inst.x5.x5/a_27_47# dc_inst.x2.x3/a_27_47# 0
C1621 dc_inst.net3 path[7] 0
C1622 dc_inst.x5.x3/a_27_47# dc_inst.x5.net3 0.01613f
C1623 path_sel[2] dc_inst.x2.net3 0
C1624 dc_inst.x3.x18/a_27_47# dc_inst.x3.net17 0.05293f
C1625 dc_inst.x7.x1/a_27_47# dc_inst.x6.net1 0
C1626 dc_inst.x5.x6/a_27_47# path_sel[1] 0.00283f
C1627 dc_inst.x3.net8 dc_inst.x3.net12 0.0526f
C1628 _17_/a_27_93# path_sel[1] 0.03097f
C1629 _17_/a_174_21# _08_ 0.00485f
C1630 _17_/a_478_47# path[0] 0.00332f
C1631 dc_inst.x9/a_277_47# _03_ 0
C1632 dc_inst.x6.x7/a_27_47# dc_inst.x4.net8 0
C1633 dc_inst.x6.net16 dc_inst.x7.net7 0
C1634 _25_/a_193_47# _25_/a_1283_21# -0
C1635 clknet_1_0__leaf_clk _03_ 0.05868f
C1636 dc_inst.x3.net18 dc_inst.x3.net1 0
C1637 _25_/a_27_47# clknet_1_1__leaf_clk 0
C1638 dc_inst.x4.net5 dc_inst.x4.net6 0
C1639 dc_inst.x1.x17/a_27_47# dc_inst.x1.net7 0
C1640 _24_/a_1108_47# capture_q 0.00191f
C1641 _24_/a_1270_413# _02_ -0
C1642 dc_inst.x7.x1/a_27_47# dc_inst.x6.x5/a_27_47# 0
C1643 path_sel[0] dc_inst.in 0.01291f
C1644 VPWR dc_inst.x6.net18 0.13082f
C1645 dc_inst.x2.x1/a_27_47# dc_inst.x4.x5/a_27_47# 0.08729f
C1646 clkload0/a_27_47# dc_inst.net8 0
C1647 path[6] dc_inst.x3.net16 0.03352f
C1648 dc_inst.x2.net6 dc_inst.x4.net8 0
C1649 dc_inst.x9/a_668_97# dc_inst.x7.net17 0.0023f
C1650 dc_inst.x7.net16 dc_inst.x7.net17 0.02492f
C1651 dc_inst.net3 dc_inst.x2.x16/a_27_47# 0
C1652 _09_ path[5] 0
C1653 dc_inst.x6.net18 path_sel[2] 0.00225f
C1654 dc_inst.x6.x16/a_27_47# dc_inst.x6.net18 0.01152f
C1655 dc_inst.x1.x4/a_27_47# dc_inst.x5.net11 0
C1656 dc_inst.x1.x10/a_27_47# dc_inst.x1.x15/a_27_47# 0
C1657 tdo VPWR 0.52872f
C1658 path[4] dc_inst.x3.net10 0.00282f
C1659 dc_inst.x2.net9 dc_inst.x5.net3 0.01298f
C1660 dc_inst.x7.net12 clknet_0_clk 0
C1661 dc_inst.x5.net1 dc_inst.x5.net3 0
C1662 dc_inst.x2.net15 dc_inst.x8/a_277_47# 0
C1663 path[3] dc_inst.x1.x6/a_27_47# 0.01629f
C1664 _24_/a_27_47# rst 0.00746f
C1665 dc_inst.x2.net6 dc_inst.x2.x10/a_27_47# 0
C1666 dc_inst.x5.net5 dc_inst.x2.x7/a_27_47# 0.01149f
C1667 tdo path_sel[2] 0.0443f
C1668 tdo dc_inst.x6.x16/a_27_47# 0.01039f
C1669 dc_inst.x3.net2 dc_inst.x3.net4 0.00644f
C1670 dc_inst.x6.x12/a_27_47# dc_inst.x7.net5 0
C1671 dc_inst.x1.net11 _07_ 0.00726f
C1672 tdi dc_inst.x3.x7/a_27_47# 0
C1673 dc_inst.x5.x17/a_27_47# dc_inst.x5.net17 0.00266f
C1674 dc_inst.x6.net15 dc_inst.x6.net18 0
C1675 dc_inst.x5.net10 _07_ 0
C1676 dc_inst.x2.net2 dc_inst.x4.net6 0
C1677 dc_inst.x2.net3 dc_inst.x4.net5 0
C1678 _18_/a_505_21# _17_/a_27_93# 0.00493f
C1679 _08_ dc_inst.x5.x11/a_27_47# 0
C1680 dc_inst.x4.net17 dc_inst.x4.net12 0.04896f
C1681 dc_inst.x1.x17/a_27_47# dc_inst.x1.net17 0.00217f
C1682 dc_inst.x4.net3 dc_inst.x8/a_750_97# 0
C1683 dc_inst.x2.x1/a_27_47# dc_inst.x2.x2/a_27_47# 0
C1684 _10_ _20_/a_470_297# 0.00194f
C1685 dc_inst.x3.net9 dc_inst.x3.x13/a_27_47# 0.03086f
C1686 dc_inst.x5.net15 dc_inst.x5.net16 0.25927f
C1687 tdo dc_inst.x6.net15 0.02694f
C1688 dc_inst.x5.x4/a_27_47# path_sel[1] 0.00504f
C1689 rst dc_inst.x3.x8/a_27_47# 0
C1690 _25_/a_27_47# _00_ 0.48584f
C1691 dc_inst.net3 dc_inst.x3.x1/a_27_47# 0
C1692 tdo _24_/a_448_47# 0
C1693 dc_inst.x7.x3/a_27_47# dc_inst.x10/a_505_21# 0
C1694 dc_inst.x7.net15 dc_inst.x9/a_247_21# 0
C1695 dc_inst.x6.x9/a_27_47# dc_inst.x5.net6 0
C1696 VPWR dc_inst.x9/a_277_47# -0.0319f
C1697 dc_inst.x5.net3 dc_inst.x4.net7 0
C1698 dc_inst.x2.x1/a_27_47# dc_inst.net1 0.03078f
C1699 VPWR clknet_1_0__leaf_clk 0.61327f
C1700 _23_/a_193_47# dc_inst.x8/a_750_97# 0
C1701 _23_/a_1283_21# dc_inst.x8/a_277_47# 0
C1702 dc_inst.x3.net8 shadow_q 0.00737f
C1703 dc_inst.x2.net5 path_sel[1] 0.00382f
C1704 dc_inst.x7.net13 dc_inst.x9/a_193_47# 0
C1705 dc_inst.x2.net2 dc_inst.x2.net3 0.01447f
C1706 path_sel[2] dc_inst.x9/a_277_47# 0
C1707 _15_/a_1060_369# dc_inst.x3.net14 0
C1708 dc_inst.x5.x9/a_27_47# dc_inst.x5.net10 0.01506f
C1709 dc_inst.x1.x17/a_27_47# dc_inst.x2.net14 0.0026f
C1710 dc_inst.x6.x10/a_27_47# dc_inst.x6.x12/a_27_47# 0
C1711 tdo dc_inst.x4.net5 0.01313f
C1712 dc_inst.x6.net2 dc_inst.x7.net9 0.05863f
C1713 dc_inst.x5.net6 dc_inst.x2.net13 0.00143f
C1714 dc_inst.x6.net5 dc_inst.x5.net19 0.00306f
C1715 dc_inst.x7.x12/a_27_47# dc_inst.x7.net1 0.00161f
C1716 dc_inst.x3.net4 _15_/a_27_47# 0
C1717 delay_sel[2] delay_sel[0] 0.00326f
C1718 dc_inst.x2.x5/a_27_47# dc_inst.x5.net5 0
C1719 dc_inst.x3.x19/a_27_47# dc_inst.x3.net14 0
C1720 dc_inst.x7.net2 dc_inst.x7.net9 0.00172f
C1721 path[6] _23_/a_1108_47# 0
C1722 path[2] _17_/a_574_297# 0.00116f
C1723 path[3] _17_/a_27_93# 0.00126f
C1724 dc_inst.x2.net19 dc_inst.x8/a_750_97# 0
C1725 dc_inst.x9/a_923_363# dc_inst.x6.net11 0
C1726 _25_/a_193_47# clkbuf_1_0__f_clk/a_110_47# 0.00878f
C1727 _14_/a_505_21# path[7] 0
C1728 _14_/a_535_374# path[6] 0
C1729 dc_inst.x6.x17/a_27_47# dc_inst.x9/a_750_97# 0
C1730 dc_inst.x6.net17 dc_inst.x6.x15/a_27_47# 0.04322f
C1731 dc_inst.x7.x14/a_27_47# delay_sel[1] 0.00457f
C1732 dc_inst.x1.net5 dc_inst.x1.x15/a_27_47# 0
C1733 tdo _02_ 0
C1734 dc_inst.x3.net18 dc_inst.x3.net14 0
C1735 dc_inst.x2.x20/a_27_47# dc_inst.x7.net4 0
C1736 path_sel[1] dc_inst.x5.x1/a_27_47# 0.01196f
C1737 dc_inst.x1.net1 _18_/a_439_47# 0
C1738 dc_inst.x1.net16 dc_inst.x1.net2 0
C1739 dc_inst.x2.net7 dc_inst.x5.x7/a_27_47# 0.00101f
C1740 _15_/a_27_47# dc_inst.x3.x13/a_27_47# 0
C1741 tdo dc_inst.x2.net2 0.00177f
C1742 dc_inst.x5.net13 dc_inst.x5.net12 0.01915f
C1743 _13_/a_27_297# path[6] 0.0075f
C1744 dc_inst.x1.net18 dc_inst.x5.net9 0
C1745 dc_inst.x2.x14/a_27_47# dc_inst.x2.net14 0.01467f
C1746 dc_inst.x6.net2 dc_inst.x5.net2 0
C1747 dc_inst.x5.x6/a_27_47# dc_inst.x6.net10 0.01301f
C1748 dc_inst.x3.x8/a_27_47# dc_inst.x3.net9 0
C1749 dc_inst.x2.x14/a_27_47# dc_inst.x5.net12 0
C1750 dc_inst.x4.net3 dc_inst.x1.x4/a_27_47# 0
C1751 clknet_1_1__leaf_clk dc_inst.in 0
C1752 dc_inst.x7.net13 delay_sel[1] 0.13221f
C1753 path_sel[1] dc_inst.x2.x3/a_27_47# 0.00725f
C1754 path[4] dc_inst.x3.net13 0.01642f
C1755 delay_sel[0] dc_inst.x6.x20/a_27_47# 0
C1756 _05_ dc_inst.x3.x19/a_27_47# 0
C1757 dc_inst.x2.net18 dc_inst.x8/a_757_363# 0
C1758 dc_inst.x1.net15 dc_inst.x1.net16 0.06214f
C1759 dc_inst.x3.x3/a_27_47# path[6] 0.00791f
C1760 dc_inst.x3.net5 dc_inst.x3.net17 0.07253f
C1761 dc_inst.x4.net17 dc_inst.x5.net14 0
C1762 dc_inst.x1.net17 dc_inst.in 0
C1763 dc_inst.x6.x17/a_27_47# dc_inst.x6.x14/a_27_47# 0.01224f
C1764 dc_inst.x4.net3 dc_inst.x7.net3 0
C1765 dc_inst.x4.x18/a_27_47# dc_inst.x5.net12 0
C1766 dc_inst.x4.net17 dc_inst.x5.x13/a_27_47# 0
C1767 dc_inst.x1.net13 dc_inst.x1.x9/a_27_47# 0
C1768 dc_inst.x6.net11 dc_inst.x4.net7 0
C1769 dc_inst.x7.net4 dc_inst.x7.net5 0.10962f
C1770 path_sel[0] _15_/a_872_316# -0.00688f
C1771 dc_inst.x7.x12/a_27_47# _03_ 0
C1772 _05_ dc_inst.x3.net18 0
C1773 path[6] dc_inst.x3.x16/a_27_47# 0.00662f
C1774 _25_/a_639_47# clknet_0_clk 0
C1775 _24_/a_761_289# delay_sel[0] 0
C1776 dc_inst.x4.net13 dc_inst.x4.net8 0
C1777 tdi path[7] 0.08126f
C1778 se path[5] 0.00218f
C1779 dc_inst.x4.x10/a_27_47# dc_inst.x1.net18 0
C1780 dc_inst.x3.net7 dc_inst.x3.net8 0.02663f
C1781 dc_inst.x3.x17/a_27_47# dc_inst.x7.net4 0
C1782 VPWR dc_inst.x6.x2/a_27_47# 0.04774f
C1783 dc_inst.x5.x7/a_27_47# dc_inst.x5.net3 0.03316f
C1784 dc_inst.x2.net17 dc_inst.x1.x12/a_27_47# 0
C1785 dc_inst.x7.net3 _23_/a_193_47# 0
C1786 dc_inst.x4.x5/a_27_47# dc_inst.x4.net8 0
C1787 dc_inst.x7.x8/a_27_47# dc_inst.x7.x9/a_27_47# 0.01018f
C1788 _00_ dc_inst.in 0
C1789 dc_inst.x6.x2/a_27_47# path_sel[2] 0.01302f
C1790 VPWR _15_/a_600_345# 0.00292f
C1791 dc_inst.x7.x3/a_27_47# _24_/a_1283_21# 0
C1792 dc_inst.x1.net4 dc_inst.x3.net12 0
C1793 dc_inst.x1.x18/a_27_47# dc_inst.x6.net6 0
C1794 dc_inst.net4 dc_inst.x7.net5 0.04416f
C1795 dc_inst.x9/a_750_97# dc_inst.net1 0
C1796 path_sel[2] _15_/a_600_345# 0.00186f
C1797 dc_inst.x1.net14 dc_inst.x1.x8/a_27_47# 0
C1798 dc_inst.x2.x13/a_27_47# dc_inst.x1.net9 0.00192f
C1799 _18_/a_439_47# path[2] 0.00187f
C1800 dc_inst.net6 dc_inst.x6.net19 0.01054f
C1801 dc_inst.x5.net6 path_sel[0] 0.00225f
C1802 dc_inst.x1.x10/a_27_47# dc_inst.x2.net13 0
C1803 dc_inst.x1.net1 dc_inst.x2.x13/a_27_47# 0
C1804 dc_inst.x6.net18 dc_inst.x6.x15/a_27_47# 0
C1805 dc_inst.x2.x4/a_27_47# dc_inst.x2.net8 0
C1806 dc_inst.x1.net6 _09_ 0.00221f
C1807 dc_inst.x6.net10 dc_inst.x7.x4/a_27_47# 0
C1808 dc_inst.x3.net10 dc_inst.x3.net1 0.00214f
C1809 dc_inst.x4.net12 dc_inst.x4.x9/a_27_47# 0
C1810 tdo dc_inst.x6.x15/a_27_47# 0.01775f
C1811 path_sel[0] path[7] 0.28433f
C1812 clkload0/a_27_47# rst 0.0703f
C1813 _25_/a_27_47# delay_sel[1] 0.00122f
C1814 tdo clknet_0_clk 0
C1815 dc_inst.x4.net11 dc_inst.x4.net8 0
C1816 dc_inst.x6.net2 dc_inst.x6.x17/a_27_47# 0
C1817 dc_inst.x2.x2/a_27_47# dc_inst.x4.net8 0.0022f
C1818 dc_inst.x2.net3 dc_inst.x4.x7/a_27_47# 0.0022f
C1819 capture_q dc_inst.x3.net3 0
C1820 VPWR dc_inst.x8/a_247_21# -0.03283f
C1821 dc_inst.net6 dc_inst.x6.net11 0
C1822 dc_inst.x3.net6 dc_inst.x3.x18/a_27_47# 0
C1823 dc_inst.x4.net2 dc_inst.net3 0.00417f
C1824 dc_inst.x1.net11 _06_ 0
C1825 dc_inst.x7.x12/a_27_47# VPWR 0.04011f
C1826 _04_ dc_inst.x3.net12 0
C1827 VPWR dc_inst.x5.net5 0.0253f
C1828 dc_inst.x7.x1/a_27_47# dc_inst.x6.net17 0
C1829 dc_inst.x7.net2 dc_inst.x6.x17/a_27_47# 0.02662f
C1830 path_sel[2] dc_inst.x8/a_247_21# 0
C1831 dc_inst.x4.x3/a_27_47# dc_inst.x1.x17/a_27_47# 0
C1832 rst dc_inst.x9/a_750_97# 0
C1833 VPWR path[6] 0.39785f
C1834 shadow_q dc_inst.net2 0.00255f
C1835 rst dc_inst.x7.x16/a_27_47# 0
C1836 dc_inst.x2.x4/a_27_47# dc_inst.x2.x6/a_27_47# 0
C1837 dc_inst.x6.x10/a_27_47# dc_inst.net4 0.00666f
C1838 dc_inst.x1.net13 dc_inst.x1.net6 0
C1839 dc_inst.x1.net19 dc_inst.x1.x20/a_27_47# 0.01067f
C1840 dc_inst.x2.x17/a_27_47# dc_inst.x2.x14/a_27_47# 0
C1841 path_sel[2] path[6] 0.00195f
C1842 dc_inst.x4.x16/a_27_47# dc_inst.x4.net19 0
C1843 dc_inst.x6.net4 dc_inst.x5.net19 0.00925f
C1844 VPWR dc_inst.x1.x6/a_27_47# 0.03847f
C1845 VPWR dc_inst.x5.x15/a_27_47# 0.00863f
C1846 dc_inst.x1.net3 dc_inst.x3.x2/a_27_47# 0.01318f
C1847 dc_inst.x2.x7/a_27_47# dc_inst.x2.x3/a_27_47# 0.01254f
C1848 dc_inst.in dc_inst.x7.x5/a_27_47# 0
C1849 tdo dc_inst.x4.x7/a_27_47# 0.01292f
C1850 path_sel[1] dc_inst.x4.net18 0.00612f
C1851 dc_inst.x6.x2/a_27_47# dc_inst.x5.net15 0
C1852 dc_inst.x9/a_193_413# dc_inst.x9/a_277_47# -0.00148f
C1853 _13_/a_470_47# dc_inst.x3.net5 0.00156f
C1854 clknet_0_clk dc_inst.x9/a_277_47# 0
C1855 clkbuf_1_0__f_clk/a_110_47# dc_inst.x9/a_750_97# 0
C1856 dc_inst.x4.x11/a_27_47# dc_inst.x4.net9 0.00723f
C1857 dc_inst.x4.net1 dc_inst.x4.x9/a_27_47# 0.05137f
C1858 dc_inst.x2.net5 dc_inst.x2.x5/a_27_47# 0.05029f
C1859 dc_inst.x7.net1 dc_inst.x7.x4/a_27_47# 0
C1860 dc_inst.x7.x10/a_27_47# dc_inst.x7.net5 0
C1861 dc_inst.x6.net17 dc_inst.x8/a_27_413# 0
C1862 clknet_0_clk clknet_1_0__leaf_clk 0.06645f
C1863 clkbuf_1_0__f_clk/a_110_47# dc_inst.x7.x16/a_27_47# 0.0043f
C1864 dc_inst.x5.x15/a_27_47# path_sel[2] 0
C1865 dc_inst.x1.net4 shadow_q 0
C1866 dc_inst.x2.net12 dc_inst.x2.net3 0
C1867 _25_/a_1283_21# dc_inst.x7.net2 0
C1868 path[2] dc_inst.x2.x13/a_27_47# 0
C1869 dc_inst.x4.net5 dc_inst.x8/a_247_21# 0
C1870 dc_inst.x6.net2 dc_inst.x7.net7 0.09125f
C1871 delay_sel[2] dc_inst.x3.x4/a_27_47# 0
C1872 dc_inst.x9/a_757_363# dc_inst.x7.x5/a_27_47# 0
C1873 _17_/a_27_93# path[1] 0
C1874 path[0] _16_/a_27_93# 0.01384f
C1875 _17_/a_478_47# path_sel[0] 0.01432f
C1876 _17_/a_174_21# _07_ 0.00702f
C1877 dc_inst.x7.net13 dc_inst.net5 0.00177f
C1878 dc_inst.x6.x1/a_27_47# dc_inst.x6.x20/a_27_47# 0
C1879 dc_inst.x7.x11/a_27_47# delay_sel[2] 0.00232f
C1880 dc_inst.x7.net3 delay_sel[2] 0.02515f
C1881 dc_inst.x5.net5 dc_inst.x4.net5 0
C1882 dc_inst.x5.net17 dc_inst.x5.x19/a_27_47# 0.00453f
C1883 dc_inst.x4.net13 dc_inst.x6.x13/a_27_47# 0
C1884 dc_inst.x2.net6 dc_inst.x2.net11 0.00394f
C1885 dc_inst.x7.net2 dc_inst.x7.net7 0
C1886 dc_inst.x2.net1 dc_inst.x5.net9 0
C1887 _10_ path[4] 0
C1888 dc_inst.x5.x14/a_27_47# dc_inst.x5.net18 0
C1889 dc_inst.x7.net2 dc_inst.net1 0
C1890 dc_inst.x1.x10/a_27_47# path_sel[0] 0
C1891 dc_inst.x2.net13 dc_inst.x2.x15/a_27_47# 0.01151f
C1892 dc_inst.x1.net18 dc_inst.x4.net4 0
C1893 dc_inst.x1.net14 dc_inst.x2.net10 0
C1894 path[7] dc_inst.x1.net7 0
C1895 dc_inst.x7.net9 dc_inst.x7.net4 0
C1896 dc_inst.x7.net14 dc_inst.x7.net10 0
C1897 dc_inst.x4.x1/a_27_47# dc_inst.x2.net18 0.00602f
C1898 dc_inst.x10/a_76_199# dc_inst.x7.net4 0
C1899 tdo dc_inst.x2.net12 0
C1900 dc_inst.x9/a_277_47# dc_inst.x9/a_834_97# -0.00465f
C1901 dc_inst.x9/a_1290_413# dc_inst.x9/a_1478_413# -0.00734f
C1902 dc_inst.x6.x8/a_27_47# dc_inst.x6.net2 0
C1903 VPWR dc_inst.x5.x6/a_27_47# 0.00677f
C1904 dc_inst.x7.net3 dc_inst.x7.x15/a_27_47# 0
C1905 dc_inst.x3.net5 dc_inst.x3.net15 0
C1906 dc_inst.x2.net18 dc_inst.x7.net4 0
C1907 dc_inst.x6.x7/a_27_47# dc_inst.net4 0
C1908 VPWR _17_/a_27_93# 0.03047f
C1909 dc_inst.x5.net14 dc_inst.x6.net3 0
C1910 dc_inst.x3.net13 dc_inst.x3.net1 0.18601f
C1911 dc_inst.x3.net14 dc_inst.x3.net10 0
C1912 dc_inst.x3.x2/a_27_47# dc_inst.x3.net2 0.0514f
C1913 dc_inst.x4.net15 dc_inst.x4.x16/a_27_47# 0.0185f
C1914 dc_inst.x3.net16 _23_/a_1270_413# 0
C1915 dc_inst.x3.net3 dc_inst.x3.x20/a_27_47# 0.04329f
C1916 dc_inst.x5.x6/a_27_47# path_sel[2] 0.00551f
C1917 tdo dc_inst.x7.x1/a_27_47# 0
C1918 _02_ path[6] 0.03484f
C1919 dc_inst.x5.x11/a_27_47# _07_ 0
C1920 dc_inst.x4.net14 path_sel[1] 0.00724f
C1921 dc_inst.x1.x18/a_27_47# dc_inst.x2.x1/a_27_47# 0
C1922 dc_inst.x4.x3/a_27_47# dc_inst.in 0
C1923 dc_inst.x7.net1 dc_inst.x7.net19 0.03427f
C1924 dc_inst.x2.x16/a_27_47# dc_inst.x1.net7 0
C1925 dc_inst.x5.net13 dc_inst.x5.net19 0
C1926 delay_sel[1] dc_inst.in 0.14345f
C1927 dc_inst.x5.x5/a_27_47# dc_inst.x5.net9 0.03528f
C1928 dc_inst.x5.net6 dc_inst.x5.x8/a_27_47# 0
C1929 dc_inst.x5.x15/a_27_47# dc_inst.x5.net15 0.01506f
C1930 dc_inst.x6.net9 dc_inst.x6.net4 0
C1931 dc_inst.net5 dc_inst.x6.net4 0
C1932 dc_inst.x1.net17 dc_inst.x5.net6 0.2579f
C1933 dc_inst.net1 dc_inst.x8/a_757_363# 0
C1934 dc_inst.x2.x10/a_27_47# dc_inst.x2.net10 0.05308f
C1935 _24_/a_1283_21# dc_inst.x3.x1/a_27_47# 0
C1936 tdo dc_inst.x7.x20/a_27_47# 0.00838f
C1937 _15_/a_788_316# _06_ 0.00273f
C1938 dc_inst.x7.net9 dc_inst.net4 0
C1939 dc_inst.x1.net10 _19_/a_193_297# 0
C1940 _04_ _19_/a_27_47# 0
C1941 dc_inst.x7.net2 rst 0
C1942 _13_/a_470_297# dc_inst.x3.net17 0
C1943 dc_inst.x4.x12/a_27_47# dc_inst.x4.net9 0.00135f
C1944 dc_inst.x3.x12/a_27_47# dc_inst.x3.net12 0.03379f
C1945 dc_inst.x1.net4 dc_inst.x3.net7 0
C1946 tdo dc_inst.x8/a_27_413# 0
C1947 dc_inst.x1.net2 _15_/a_397_47# 0.00352f
C1948 dc_inst.x4.x13/a_27_47# path_sel[1] 0.01316f
C1949 dc_inst.net8 dc_inst.x7.net4 0.05848f
C1950 dc_inst.x1.net11 _15_/a_788_316# 0
C1951 _25_/a_27_47# dc_inst.net5 0
C1952 dc_inst.x9/a_1290_413# dc_inst.net7 -0
C1953 dc_inst.x9/a_1478_413# delay_sel[0] 0.05607f
C1954 dc_inst.x4.x10/a_27_47# dc_inst.x4.net9 0
C1955 dc_inst.x4.x11/a_27_47# dc_inst.x6.net12 0
C1956 _19_/a_27_47# _18_/a_76_199# 0
C1957 VPWR dc_inst.x5.x4/a_27_47# -0.0102f
C1958 dc_inst.x4.net19 dc_inst.x4.x8/a_27_47# 0
C1959 dc_inst.x3.net5 dc_inst.x3.net6 0.00807f
C1960 dc_inst.x3.x2/a_27_47# _15_/a_27_47# 0
C1961 dc_inst.x1.net3 dc_inst.x3.x19/a_27_47# 0
C1962 dc_inst.x5.net6 dc_inst.x2.net14 0.01821f
C1963 dc_inst.x1.net4 dc_inst.x1.net12 0.00148f
C1964 dc_inst.x7.x19/a_27_47# dc_inst.x7.net18 0.05151f
C1965 dc_inst.x7.net19 dc_inst.x7.x18/a_27_47# 0.04258f
C1966 dc_inst.x5.net6 dc_inst.x5.net12 0.00686f
C1967 dc_inst.x2.net1 dc_inst.x5.net1 0.00118f
C1968 dc_inst.x4.net2 dc_inst.x10/a_505_21# 0
C1969 dc_inst.x6.x4/a_27_47# dc_inst.x6.net5 0.01506f
C1970 _01_ dc_inst.x8/a_277_47# 0
C1971 rst dc_inst.x3.net18 0
C1972 rst dc_inst.x8/a_757_363# 0
C1973 dc_inst.net4 dc_inst.x5.net2 0.00143f
C1974 dc_inst.x7.x20/a_27_47# dc_inst.x9/a_277_47# 0
C1975 dc_inst.x7.x20/a_27_47# clknet_1_0__leaf_clk 0
C1976 dc_inst.x4.x15/a_27_47# dc_inst.x5.x1/a_27_47# 0
C1977 dc_inst.x3.x7/a_27_47# dc_inst.x3.net8 0.00374f
C1978 VPWR dc_inst.x7.x4/a_27_47# -0.00939f
C1979 clknet_1_1__leaf_clk dc_inst.x3.x1/a_27_47# 0
C1980 dc_inst.x6.net14 dc_inst.x4.net7 0
C1981 dc_inst.x4.net17 dc_inst.x5.net7 0.00138f
C1982 VPWR dc_inst.x2.net5 0.07018f
C1983 dc_inst.x1.net3 dc_inst.x3.net18 0.0036f
C1984 dc_inst.x1.net5 path_sel[0] 0
C1985 dc_inst.x7.net19 _03_ 0
C1986 dc_inst.x1.net10 _10_ 0
C1987 dc_inst.x1.net14 _15_/a_27_47# 0
C1988 dc_inst.x9/a_247_21# dc_inst.x8/a_193_413# 0
C1989 dc_inst.x1.x10/a_27_47# dc_inst.x1.net7 0
C1990 dc_inst.x2.net5 path_sel[2] 0.00109f
C1991 dc_inst.x1.net10 dc_inst.x1.x7/a_27_47# 0.0051f
C1992 path_sel[2] dc_inst.x7.x4/a_27_47# 0.00196f
C1993 dc_inst.x10/a_76_199# _23_/a_27_47# 0
C1994 dc_inst.x1.net12 dc_inst.x1.net9 0
C1995 dc_inst.x6.x9/a_27_47# dc_inst.x4.net19 0
C1996 dc_inst.x2.net16 dc_inst.x2.x14/a_27_47# 0
C1997 dc_inst.x1.net1 dc_inst.x1.net12 0
C1998 dc_inst.x7.net11 clkbuf_1_0__f_clk/a_110_47# 0.01092f
C1999 dc_inst.x4.x11/a_27_47# path_sel[1] 0.01274f
C2000 dc_inst.x1.net2 path[4] 0
C2001 dc_inst.x5.net6 dc_inst.x2.x8/a_27_47# 0.01883f
C2002 dc_inst.x1.net15 dc_inst.x8/a_1290_413# 0
C2003 dc_inst.x5.net6 dc_inst.x5.x10/a_27_47# 0
C2004 delay_sel[0] dc_inst.net7 0.00535f
C2005 VPWR dc_inst.x3.x10/a_27_47# 0.04053f
C2006 _19_/a_27_47# path[2] 0.00693f
C2007 clknet_0_clk path[6] 0
C2008 _24_/a_27_47# dc_inst.net3 0
C2009 dc_inst.in dc_inst.x8/a_27_47# 0.01509f
C2010 VPWR dc_inst.x5.x1/a_27_47# 0.00201f
C2011 dc_inst.x3.net13 dc_inst.x3.net14 0.05916f
C2012 dc_inst.x3.x15/a_27_47# _23_/a_27_47# 0
C2013 dc_inst.x4.net2 path_sel[0] 0
C2014 dc_inst.x1.x3/a_27_47# delay_sel[1] 0
C2015 dc_inst.x6.x17/a_27_47# dc_inst.x7.net4 0
C2016 path[4] dc_inst.x3.x11/a_27_47# 0
C2017 dc_inst.x4.x3/a_27_47# dc_inst.x7.x3/a_27_47# 0
C2018 dc_inst.x1.net16 dc_inst.x1.x9/a_27_47# 0
C2019 dc_inst.x1.x17/a_27_47# dc_inst.x1.net9 0
C2020 dc_inst.x3.net2 dc_inst.x3.x19/a_27_47# 0
C2021 path_sel[2] dc_inst.x5.x1/a_27_47# 0
C2022 dc_inst.x7.x3/a_27_47# delay_sel[1] 0
C2023 dc_inst.x4.net13 dc_inst.x2.net11 0
C2024 _00_ dc_inst.x3.x1/a_27_47# 0
C2025 dc_inst.x7.net1 dc_inst.x7.net17 0.01522f
C2026 dc_inst.x1.x20/a_27_47# dc_inst.x8/a_193_413# 0
C2027 VPWR dc_inst.x2.x3/a_27_47# 0.03787f
C2028 dc_inst.x4.net17 dc_inst.x6.x1/a_27_47# 0
C2029 dc_inst.x6.net6 dc_inst.x6.x9/a_27_47# 0.01336f
C2030 dc_inst.x4.net4 dc_inst.x6.net14 0.00437f
C2031 dc_inst.x4.net9 dc_inst.x4.net7 0
C2032 dc_inst.x4.net14 dc_inst.x6.net10 0
C2033 dc_inst.x4.x19/a_27_47# dc_inst.x4.net18 0.049f
C2034 dc_inst.x4.net16 dc_inst.x4.x18/a_27_47# 0
C2035 dc_inst.x1.net19 dc_inst.x4.x4/a_27_47# 0
C2036 _23_/a_1283_21# shadow_q 0.00954f
C2037 path_sel[2] dc_inst.x2.x3/a_27_47# 0
C2038 dc_inst.x2.net8 path_sel[0] 0
C2039 capture_d _23_/a_543_47# 0.01569f
C2040 delay_sel[2] _23_/a_193_47# 0.0421f
C2041 dc_inst.net8 _23_/a_27_47# 0.00393f
C2042 dc_inst.x3.net3 dc_inst.x8/a_277_47# 0
C2043 dc_inst.x3.net2 dc_inst.x3.net18 0.01375f
C2044 VPWR dc_inst.x7.net19 0.17776f
C2045 dc_inst.x3.net19 dc_inst.x8/a_1290_413# 0.00586f
C2046 dc_inst.x3.x9/a_27_47# dc_inst.x3.net12 0.04418f
C2047 dc_inst.x6.x17/a_27_47# dc_inst.net4 0.0025f
C2048 dc_inst.x2.net16 dc_inst.in 0
C2049 dc_inst.x4.net13 dc_inst.net4 0
C2050 dc_inst.x6.x16/a_27_47# dc_inst.x7.net19 0
C2051 dc_inst.net6 dc_inst.net9 0
C2052 dc_inst.x5.net9 path_sel[1] 0.01299f
C2053 dc_inst.in dc_inst.net2 0.07593f
C2054 dc_inst.x1.x10/a_27_47# dc_inst.x2.net14 0
C2055 dc_inst.x1.x10/a_27_47# dc_inst.x5.net12 0
C2056 path[4] dc_inst.x3.net19 0
C2057 dc_inst.x4.net12 dc_inst.x6.x10/a_27_47# 0
C2058 dc_inst.x4.x13/a_27_47# dc_inst.x6.net10 0
C2059 dc_inst.x7.net17 dc_inst.x7.x18/a_27_47# 0.03735f
C2060 _13_/a_112_47# shadow_q 0.0111f
C2061 dc_inst.x7.x17/a_27_47# dc_inst.x7.net18 0.01802f
C2062 dc_inst.x2.net5 dc_inst.x2.net2 0
C2063 dc_inst.net4 dc_inst.x4.x5/a_27_47# 0
C2064 dc_inst.x1.net5 dc_inst.x1.net7 0.04787f
C2065 capture_d dc_inst.x7.x17/a_27_47# 0
C2066 dc_inst.x1.x2/a_27_47# path_sel[1] 0.0034f
C2067 dc_inst.x6.net15 dc_inst.x7.net19 0
C2068 dc_inst.x2.x6/a_27_47# path_sel[0] 0.00192f
C2069 dc_inst.x7.net5 dc_inst.x7.net6 0.22699f
C2070 dc_inst.x6.x9/a_27_47# dc_inst.x6.x11/a_27_47# 0
C2071 dc_inst.x4.x12/a_27_47# path_sel[1] 0.01137f
C2072 _02_ dc_inst.x3.x10/a_27_47# 0
C2073 dc_inst.x1.net4 dc_inst.in 0.10588f
C2074 dc_inst.x10/a_505_21# dc_inst.x3.net4 0
C2075 dc_inst.x4.x1/a_27_47# dc_inst.net1 0.00194f
C2076 dc_inst.x7.net17 _03_ 0
C2077 dc_inst.net9 dc_inst.x8/a_277_47# 0.10282f
C2078 delay_sel[0] dc_inst.x8/a_1290_413# 0
C2079 dc_inst.x2.x3/a_27_47# dc_inst.x4.net5 0
C2080 dc_inst.x5.net15 dc_inst.x5.x1/a_27_47# 0
C2081 dc_inst.x2.x15/a_27_47# dc_inst.x1.net7 0
C2082 dc_inst.net1 dc_inst.x7.net4 0.04047f
C2083 delay_sel[2] _23_/a_1462_47# 0
C2084 dc_inst.x10/a_505_21# capture_d 0
C2085 dc_inst.x3.net8 path[7] 0
C2086 dc_inst.net5 dc_inst.x9/a_757_363# 0
C2087 dc_inst.x3.x18/a_27_47# _15_/a_600_345# 0
C2088 dc_inst.x4.x1/a_27_47# dc_inst.x6.x18/a_27_47# 0
C2089 dc_inst.x4.x10/a_27_47# path_sel[1] 0.01151f
C2090 dc_inst.x2.x9/a_27_47# path_sel[1] 0.0139f
C2091 dc_inst.x1.net12 dc_inst.x2.net15 0
C2092 dc_inst.x3.x6/a_27_47# dc_inst.x3.net12 0.01151f
C2093 dc_inst.x6.x18/a_27_47# dc_inst.x7.net4 0.01831f
C2094 dc_inst.x4.net11 dc_inst.net4 0
C2095 se delay_sel[2] 0.05529f
C2096 dc_inst.x5.x3/a_27_47# path_sel[1] 0.00483f
C2097 _24_/a_193_47# _23_/a_761_289# 0.00702f
C2098 _24_/a_543_47# _23_/a_27_47# 0.00651f
C2099 _24_/a_761_289# _23_/a_193_47# 0
C2100 _24_/a_27_47# _23_/a_543_47# 0.00148f
C2101 dc_inst.x4.x15/a_27_47# dc_inst.x4.net18 0.03823f
C2102 dc_inst.x4.net14 dc_inst.x4.x19/a_27_47# 0.03058f
C2103 dc_inst.x1.net2 dc_inst.x2.x20/a_27_47# 0
C2104 VPWR dc_inst.x3.x14/a_27_47# 0.00487f
C2105 dc_inst.x2.x16/a_27_47# dc_inst.x2.x17/a_27_47# 0
C2106 _25_/a_27_47# clkbuf_0_clk/a_110_47# 0.01066f
C2107 _15_/a_372_413# path[6] 0.00151f
C2108 dc_inst.x4.x14/a_27_47# dc_inst.x5.net6 0
C2109 dc_inst.x6.net4 dc_inst.x6.x4/a_27_47# 0.12862f
C2110 dc_inst.net4 dc_inst.x7.net7 0.00159f
C2111 path_sel[0] dc_inst.x4.net19 0.00133f
C2112 dc_inst.x1.net9 dc_inst.in 0.0348f
C2113 VPWR dc_inst.x7.x8/a_27_47# 0.00149f
C2114 VPWR _23_/a_1270_413# 0
C2115 _04_ dc_inst.in 0.15991f
C2116 dc_inst.x2.net2 dc_inst.x2.x3/a_27_47# 0
C2117 dc_inst.x5.x19/a_27_47# dc_inst.x5.net19 0.01498f
C2118 dc_inst.x8/a_27_413# dc_inst.x8/a_247_21# -0
C2119 dc_inst.x3.net7 _23_/a_1283_21# 0
C2120 capture_q dc_inst.x3.net16 0.00128f
C2121 dc_inst.x1.net17 dc_inst.x2.x15/a_27_47# 0
C2122 dc_inst.x1.x17/a_27_47# dc_inst.x2.net15 0.03623f
C2123 VPWR dc_inst.x2.x18/a_27_47# 0.02005f
C2124 dc_inst.x1.net15 dc_inst.x2.x20/a_27_47# 0
C2125 dc_inst.x5.net7 dc_inst.x4.x9/a_27_47# 0.00335f
C2126 path_sel[2] dc_inst.x7.x8/a_27_47# 0.00659f
C2127 dc_inst.x4.x4/a_27_47# dc_inst.x1.x20/a_27_47# 0.00988f
C2128 dc_inst.x2.x16/a_27_47# delay_sel[1] 0
C2129 path_sel[0] dc_inst.x5.x2/a_27_47# 0.00273f
C2130 dc_inst.x2.net9 path_sel[1] 0.0223f
C2131 dc_inst.x7.net3 dc_inst.x9/a_1478_413# 0
C2132 rst dc_inst.x7.net4 0.00838f
C2133 dc_inst.x5.net1 path_sel[1] 0.09645f
C2134 dc_inst.x6.net12 dc_inst.x4.net7 0
C2135 dc_inst.x1.net13 dc_inst.x1.net16 0
C2136 dc_inst.x2.x18/a_27_47# path_sel[2] 0.00603f
C2137 dc_inst.x3.net4 path_sel[0] 0.00104f
C2138 dc_inst.x5.x5/a_27_47# dc_inst.x5.x7/a_27_47# 0
C2139 dc_inst.x6.net5 dc_inst.x6.net11 0.04375f
C2140 VPWR dc_inst.x4.net18 -0.00265f
C2141 _18_/a_76_199# dc_inst.in 0
C2142 dc_inst.x6.x1/a_27_47# dc_inst.net7 0.00124f
C2143 _14_/a_505_21# dc_inst.x3.x8/a_27_47# 0.00191f
C2144 dc_inst.x3.x18/a_27_47# path[6] 0.00127f
C2145 _16_/a_27_93# path_sel[0] 0.01196f
C2146 dc_inst.x4.net3 dc_inst.x1.net16 0.00109f
C2147 dc_inst.x4.net2 dc_inst.x1.net17 0
C2148 dc_inst.x7.x13/a_27_47# dc_inst.x7.x14/a_27_47# 0
C2149 VPWR dc_inst.x7.net17 0.00696f
C2150 _13_/a_112_47# dc_inst.x3.net7 0.00547f
C2151 dc_inst.x6.net6 path_sel[0] 0
C2152 clkbuf_1_0__f_clk/a_110_47# dc_inst.x7.net4 0
C2153 _24_/a_27_47# dc_inst.x10/a_505_21# 0
C2154 dc_inst.x7.net14 dc_inst.x7.net18 0.10102f
C2155 dc_inst.x5.net19 dc_inst.x5.net6 0
C2156 dc_inst.x1.x13/a_27_47# dc_inst.x1.net19 0
C2157 dc_inst.x6.net17 _23_/a_448_47# 0
C2158 dc_inst.x7.x3/a_27_47# dc_inst.net2 0.01004f
C2159 _15_/a_1281_47# path[7] 0.00178f
C2160 _15_/a_1279_413# path[4] 0.00249f
C2161 dc_inst.x2.x14/a_27_47# dc_inst.x2.net15 0.00116f
C2162 dc_inst.x2.net14 dc_inst.x2.x15/a_27_47# 0.02031f
C2163 dc_inst.x1.x2/a_27_47# path[3] 0
C2164 dc_inst.x1.x11/a_27_47# _09_ 0.00267f
C2165 dc_inst.x1.net14 dc_inst.x1.x15/a_27_47# 0.04524f
C2166 dc_inst.x3.x1/a_27_47# delay_sel[1] 0
C2167 dc_inst.x7.x13/a_27_47# dc_inst.x7.net13 0.01486f
C2168 dc_inst.x2.x7/a_27_47# dc_inst.x5.net9 0
C2169 dc_inst.x2.net11 dc_inst.x2.net10 0.22941f
C2170 dc_inst.x8/a_750_97# dc_inst.x8/a_1290_413# -0.00475f
C2171 dc_inst.x4.x15/a_27_47# dc_inst.x4.net14 0.02899f
C2172 path_sel[1] dc_inst.x4.net7 0.00598f
C2173 dc_inst.x1.x5/a_27_47# dc_inst.x1.net11 0.03018f
C2174 dc_inst.x5.net4 dc_inst.x2.net11 0
C2175 dc_inst.x1.x3/a_27_47# dc_inst.x1.net4 0.00201f
C2176 _19_/a_109_297# path_sel[0] 0
C2177 dc_inst.x7.net3 dc_inst.net7 0.23305f
C2178 dc_inst.x4.net15 path_sel[0] 0.00279f
C2179 clkbuf_1_1__f_clk/a_110_47# shadow_q 0.02267f
C2180 dc_inst.x2.x18/a_27_47# dc_inst.x4.net5 0
C2181 clkbuf_1_0__f_clk/a_110_47# dc_inst.net4 0
C2182 dc_inst.x3.x11/a_27_47# dc_inst.x3.net1 0.01399f
C2183 dc_inst.x2.x10/a_27_47# path[0] 0
C2184 dc_inst.x2.x18/a_27_47# dc_inst.x1.net8 0
C2185 tdi dc_inst.x3.x8/a_27_47# 0
C2186 _15_/a_872_316# dc_inst.net2 0
C2187 path[5] dc_inst.x8/a_1290_413# 0
C2188 dc_inst.net6 dc_inst.x6.net12 0
C2189 dc_inst.x4.net12 dc_inst.x5.net2 0
C2190 dc_inst.x1.x18/a_27_47# dc_inst.x6.x13/a_27_47# 0.00308f
C2191 dc_inst.x1.net19 dc_inst.x6.net1 0
C2192 _24_/a_1108_47# shadow_q 0
C2193 dc_inst.x6.net9 dc_inst.x5.x19/a_27_47# 0
C2194 _24_/a_761_289# delay_sel[2] 0.01477f
C2195 dc_inst.x3.x9/a_27_47# dc_inst.x3.net7 0.00113f
C2196 _24_/a_193_47# dc_inst.net8 0
C2197 _24_/a_1283_21# capture_d 0
C2198 dc_inst.x3.net2 dc_inst.x7.net4 0.00409f
C2199 dc_inst.x1.net17 dc_inst.x2.x6/a_27_47# 0
C2200 dc_inst.x4.x10/a_27_47# dc_inst.x2.x7/a_27_47# 0.04629f
C2201 _25_/a_805_47# dc_inst.x7.net1 0
C2202 dc_inst.x2.net17 path_sel[1] 0
C2203 dc_inst.x2.net8 dc_inst.x5.net12 0
C2204 path[5] path[4] 0.14555f
C2205 dc_inst.x4.net14 VPWR 0.00411f
C2206 dc_inst.x4.x17/a_27_47# dc_inst.x4.x20/a_27_47# 0.00817f
C2207 dc_inst.x3.net9 dc_inst.x3.net10 0.00165f
C2208 clknet_0_clk dc_inst.x7.net19 0
C2209 dc_inst.x2.net15 dc_inst.in 0
C2210 dc_inst.x7.net9 dc_inst.x7.net6 0
C2211 dc_inst.x3.x17/a_27_47# dc_inst.x3.net19 0
C2212 dc_inst.x8/a_923_363# dc_inst.net2 0
C2213 dc_inst.x4.x4/a_27_47# dc_inst.x8/a_193_413# 0
C2214 rst _23_/a_27_47# 0.0321f
C2215 dc_inst.x5.x4/a_27_47# dc_inst.x2.net12 0.00101f
C2216 dc_inst.x2.x5/a_27_47# dc_inst.x5.net9 0
C2217 dc_inst.x4.net4 path_sel[1] 0
C2218 dc_inst.x5.net14 dc_inst.x6.x7/a_27_47# 0
C2219 capture_q _13_/a_27_297# 0.02897f
C2220 dc_inst.x1.x12/a_27_47# _19_/a_27_47# 0
C2221 dc_inst.x3.net19 dc_inst.x3.net1 0
C2222 dc_inst.x6.x7/a_27_47# dc_inst.x5.x13/a_27_47# 0
C2223 dc_inst.x1.net18 dc_inst.x6.net5 0
C2224 path_sel[1] _15_/a_193_47# 0
C2225 dc_inst.x9/a_27_47# dc_inst.net4 0
C2226 dc_inst.x6.net9 dc_inst.x5.net6 0
C2227 dc_inst.x5.net17 dc_inst.x4.net19 0
C2228 VPWR dc_inst.x4.x13/a_27_47# 0.00316f
C2229 _06_ dc_inst.x3.net11 0
C2230 path[7] dc_inst.net2 0
C2231 dc_inst.x2.x6/a_27_47# dc_inst.x5.net12 0
C2232 dc_inst.x2.net8 dc_inst.x2.x8/a_27_47# 0.12504f
C2233 dc_inst.x5.net19 dc_inst.x7.net10 0.14374f
C2234 clkbuf_1_0__f_clk/a_110_47# _23_/a_27_47# 0
C2235 dc_inst.x2.net5 dc_inst.x2.net12 0.00377f
C2236 dc_inst.x4.net16 dc_inst.x5.net6 0.01059f
C2237 capture_q dc_inst.x3.x3/a_27_47# 0
C2238 clknet_1_1__leaf_clk dc_inst.x3.net4 0
C2239 tdo _23_/a_448_47# 0.00342f
C2240 dc_inst.x4.x13/a_27_47# path_sel[2] 0
C2241 delay_sel[0] dc_inst.x7.net5 0.00119f
C2242 _25_/a_543_47# delay_sel[2] 0
C2243 _25_/a_1108_47# capture_d 0
C2244 dc_inst.x4.x1/a_27_47# _15_/a_27_47# 0
C2245 _20_/a_79_21# dc_inst.x3.net14 0
C2246 dc_inst.x5.x17/a_27_47# dc_inst.x5.net3 0
C2247 dc_inst.x5.net17 dc_inst.x5.x2/a_27_47# 0
C2248 clknet_1_1__leaf_clk capture_d 0.0319f
C2249 dc_inst.x1.x17/a_27_47# dc_inst.x5.net3 0
C2250 dc_inst.x2.x16/a_27_47# dc_inst.x2.net16 0.04145f
C2251 rst dc_inst.x3.net13 0
C2252 dc_inst.x3.x6/a_27_47# dc_inst.x3.net7 0.00124f
C2253 capture_q dc_inst.x3.x16/a_27_47# 0.01158f
C2254 dc_inst.x6.x3/a_27_47# dc_inst.x6.net4 0.04368f
C2255 dc_inst.x2.x5/a_27_47# dc_inst.x2.x9/a_27_47# 0
C2256 _24_/a_193_47# _24_/a_543_47# -0.01997f
C2257 dc_inst.in _23_/a_1283_21# 0
C2258 _24_/a_27_47# _24_/a_1283_21# -0
C2259 dc_inst.x1.net4 path[7] 0
C2260 dc_inst.x5.x3/a_27_47# dc_inst.x2.x5/a_27_47# 0
C2261 _19_/a_465_47# _10_ 0.00141f
C2262 clkload0/a_27_47# _23_/a_543_47# 0
C2263 dc_inst.x1.net3 dc_inst.x3.net13 0.00914f
C2264 dc_inst.x5.x7/a_27_47# path_sel[1] 0.00228f
C2265 dc_inst.x2.x17/a_27_47# dc_inst.x2.x15/a_27_47# 0
C2266 _19_/a_109_297# dc_inst.x1.net7 0
C2267 dc_inst.x5.net17 dc_inst.x6.net6 0
C2268 dc_inst.x2.x6/a_27_47# dc_inst.x2.x8/a_27_47# 0
C2269 dc_inst.x1.net17 dc_inst.x6.net6 0
C2270 _24_/a_639_47# VPWR 0.00409f
C2271 dc_inst.x5.net12 dc_inst.x4.net19 0.002f
C2272 dc_inst.x4.net8 dc_inst.x4.x8/a_27_47# 0.04557f
C2273 dc_inst.x4.net12 dc_inst.x4.net13 0.26892f
C2274 dc_inst.x3.net5 path[6] 0.12873f
C2275 dc_inst.x1.x5/a_27_47# _15_/a_788_316# 0
C2276 dc_inst.x6.net4 dc_inst.x6.net11 0
C2277 VPWR dc_inst.x4.x11/a_27_47# -0.00819f
C2278 dc_inst.x5.net6 dc_inst.x1.net9 0
C2279 dc_inst.x1.net15 dc_inst.x2.net6 0
C2280 dc_inst.x5.net13 dc_inst.x5.net3 0.15527f
C2281 dc_inst.x5.net14 dc_inst.x5.net2 0.06817f
C2282 dc_inst.x1.net2 dc_inst.x2.net18 0
C2283 dc_inst.x6.net10 dc_inst.x4.net7 0
C2284 dc_inst.x1.x12/a_27_47# dc_inst.x1.net12 0.00238f
C2285 dc_inst.x9/a_1478_413# _23_/a_193_47# 0
C2286 dc_inst.x2.net12 dc_inst.x2.x3/a_27_47# 0
C2287 dc_inst.x5.net12 dc_inst.x5.x2/a_27_47# 0.00135f
C2288 dc_inst.x5.x13/a_27_47# dc_inst.x5.net2 0.00123f
C2289 dc_inst.x2.x5/a_27_47# dc_inst.x2.net9 0.01151f
C2290 dc_inst.x4.x11/a_27_47# path_sel[2] 0
C2291 dc_inst.x2.x20/a_27_47# dc_inst.x8/a_750_97# 0
C2292 VPWR dc_inst.x7.x6/a_27_47# 0.01131f
C2293 _00_ capture_d 0.02085f
C2294 dc_inst.net3 dc_inst.x7.net2 0
C2295 _04_ path[7] 0
C2296 dc_inst.x3.x1/a_27_47# dc_inst.net2 0.04212f
C2297 dc_inst.x3.x5/a_27_47# shadow_q 0.00455f
C2298 dc_inst.x1.net15 dc_inst.x2.net18 0
C2299 dc_inst.x4.net15 dc_inst.x5.x8/a_27_47# 0
C2300 path_sel[2] dc_inst.x7.x6/a_27_47# 0.00635f
C2301 dc_inst.x4.net2 dc_inst.x4.x3/a_27_47# 0.00297f
C2302 _25_/a_1108_47# _24_/a_27_47# 0
C2303 _25_/a_1283_21# _24_/a_193_47# 0
C2304 _24_/a_27_47# clknet_1_1__leaf_clk 0.44735f
C2305 dc_inst.x10/a_218_374# dc_inst.in 0
C2306 dc_inst.x4.net2 delay_sel[1] 0
C2307 dc_inst.x4.x18/a_27_47# dc_inst.x5.net3 0.02634f
C2308 dc_inst.x6.net6 dc_inst.x5.net12 0
C2309 dc_inst.x5.net15 dc_inst.x4.x13/a_27_47# 0
C2310 dc_inst.x2.x16/a_27_47# dc_inst.x1.net9 0.00103f
C2311 dc_inst.x3.net9 dc_inst.x3.net13 0.05324f
C2312 _01_ shadow_q 0.00259f
C2313 dc_inst.x5.net9 path[1] 0
C2314 dc_inst.x9/a_750_97# dc_inst.x7.x17/a_27_47# 0
C2315 dc_inst.x7.x16/a_27_47# dc_inst.x7.x17/a_27_47# 0
C2316 dc_inst.x6.net17 dc_inst.x6.x19/a_27_47# 0
C2317 clknet_0_clk dc_inst.x7.net17 0.01442f
C2318 dc_inst.x5.x12/a_27_47# dc_inst.x1.x9/a_27_47# 0.01013f
C2319 dc_inst.net5 dc_inst.x7.net10 0.26382f
C2320 dc_inst.x4.net1 dc_inst.x4.net13 0.0403f
C2321 dc_inst.x4.net11 dc_inst.x4.net12 0.01589f
C2322 capture_q VPWR 0.05515f
C2323 _05_ dc_inst.x3.x11/a_27_47# 0
C2324 dc_inst.net3 dc_inst.x8/a_757_363# 0.04671f
C2325 dc_inst.x3.net2 dc_inst.x3.net13 0
C2326 dc_inst.x7.x20/a_27_47# dc_inst.x7.net19 0.03125f
C2327 dc_inst.x3.net14 dc_inst.x3.net19 0
C2328 dc_inst.x7.net4 dc_inst.x8/a_1478_413# 0
C2329 dc_inst.x4.net17 dc_inst.x6.net7 0
C2330 dc_inst.x6.x19/a_27_47# dc_inst.x4.net6 0
C2331 _10_ dc_inst.x1.x8/a_27_47# 0
C2332 delay_sel[0] _23_/a_761_289# 0
C2333 dc_inst.x3.x3/a_27_47# dc_inst.x3.x20/a_27_47# 0.01191f
C2334 dc_inst.x4.net1 dc_inst.x4.x5/a_27_47# 0
C2335 dc_inst.x1.net19 dc_inst.x1.x16/a_27_47# 0
C2336 dc_inst.x4.net15 dc_inst.x5.net12 0.00119f
C2337 VPWR dc_inst.x5.net9 0.75905f
C2338 dc_inst.x5.net11 dc_inst.x5.x12/a_27_47# 0.01685f
C2339 dc_inst.x3.net16 dc_inst.x8/a_277_47# 0
C2340 dc_inst.net6 dc_inst.x6.net10 0
C2341 dc_inst.x2.net1 dc_inst.x2.x13/a_27_47# 0.01152f
C2342 _13_/a_112_47# dc_inst.x3.x7/a_27_47# 0.00283f
C2343 dc_inst.x3.x16/a_27_47# dc_inst.x3.x20/a_27_47# 0
C2344 dc_inst.x1.x4/a_27_47# dc_inst.x1.net10 0
C2345 _17_/a_27_93# _08_ 0.00193f
C2346 _25_/a_193_47# _25_/a_1108_47# -0.00207f
C2347 _25_/a_27_47# _25_/a_448_47# -0.00297f
C2348 clknet_1_0__leaf_clk dc_inst.x5.x20/a_27_47# 0
C2349 _00_ _24_/a_27_47# 0.03178f
C2350 _25_/a_193_47# clknet_1_1__leaf_clk 0
C2351 dc_inst.x6.net5 dc_inst.x6.net14 0
C2352 VPWR dc_inst.x1.x2/a_27_47# -0.0018f
C2353 _24_/a_639_47# _02_ 0
C2354 _24_/a_448_47# capture_q 0
C2355 dc_inst.x7.x3/a_27_47# _23_/a_1283_21# 0
C2356 dc_inst.x6.net2 dc_inst.x6.x9/a_27_47# 0
C2357 dc_inst.x2.net6 dc_inst.x2.x12/a_27_47# 0.00546f
C2358 dc_inst.x9/a_834_97# dc_inst.x7.net17 0.00178f
C2359 _15_/a_788_316# dc_inst.x3.net11 0.0107f
C2360 dc_inst.x1.x2/a_27_47# path_sel[2] 0.03035f
C2361 tdo dc_inst.x7.net15 0
C2362 dc_inst.x5.net14 dc_inst.x4.net13 0
C2363 dc_inst.x4.net1 dc_inst.x4.net11 0.03134f
C2364 VPWR dc_inst.x4.x12/a_27_47# -0.01014f
C2365 dc_inst.x3.x15/a_27_47# dc_inst.x3.net19 0
C2366 path[5] dc_inst.x3.net1 0.04512f
C2367 dc_inst.x7.net12 dc_inst.x9/a_247_21# 0.00341f
C2368 _15_/a_27_47# dc_inst.x3.net13 0.00711f
C2369 dc_inst.x1.x3/a_27_47# _13_/a_112_47# 0
C2370 dc_inst.x1.net6 path[4] 0
C2371 dc_inst.x4.x10/a_27_47# VPWR 0.01915f
C2372 dc_inst.x4.x12/a_27_47# path_sel[2] 0
C2373 _24_/a_193_47# rst 0.00278f
C2374 dc_inst.x5.net7 dc_inst.x6.x10/a_27_47# 0
C2375 VPWR dc_inst.x2.x9/a_27_47# 0
C2376 dc_inst.x1.net10 dc_inst.x1.x9/a_27_47# 0.0032f
C2377 delay_sel[0] dc_inst.x7.net9 0
C2378 _00_ dc_inst.x3.x8/a_27_47# 0
C2379 dc_inst.x5.net7 dc_inst.x2.net4 0.00194f
C2380 dc_inst.x2.x18/a_27_47# dc_inst.x2.net12 0
C2381 dc_inst.x1.x10/a_27_47# dc_inst.x1.net1 0.04368f
C2382 dc_inst.x1.net13 dc_inst.x8/a_1290_413# 0
C2383 dc_inst.net8 dc_inst.x9/a_1290_413# 0
C2384 dc_inst.x3.x5/a_27_47# dc_inst.x3.net7 0.03566f
C2385 dc_inst.x10/a_76_199# delay_sel[0] 0
C2386 VPWR dc_inst.x5.x3/a_27_47# -0.0056f
C2387 dc_inst.x5.net6 dc_inst.x2.net15 0
C2388 dc_inst.x3.net3 shadow_q 0
C2389 dc_inst.x4.x10/a_27_47# path_sel[2] 0
C2390 dc_inst.x3.x2/a_27_47# path_sel[0] 0
C2391 dc_inst.net8 dc_inst.x3.net19 0
C2392 dc_inst.x4.net1 dc_inst.net1 0
C2393 dc_inst.x6.net18 dc_inst.x6.x19/a_27_47# 0.0184f
C2394 dc_inst.x7.net6 dc_inst.x7.net7 0.01747f
C2395 dc_inst.net6 dc_inst.x7.net1 0
C2396 dc_inst.in dc_inst.x6.net19 0
C2397 _01_ dc_inst.x3.net7 0
C2398 dc_inst.x5.net9 dc_inst.x4.net5 0
C2399 dc_inst.x6.x13/a_27_47# dc_inst.x4.x8/a_27_47# 0
C2400 _25_/a_193_47# _00_ 0.54288f
C2401 dc_inst.x1.net17 dc_inst.x2.x1/a_27_47# 0.00206f
C2402 dc_inst.x7.net14 dc_inst.x7.x16/a_27_47# 0
C2403 dc_inst.x5.x14/a_27_47# dc_inst.x5.net16 0.00106f
C2404 dc_inst.x5.net14 dc_inst.x5.x16/a_27_47# 0.00348f
C2405 dc_inst.x1.net10 dc_inst.x5.net11 0.09748f
C2406 _02_ capture_q 0.18622f
C2407 tdo dc_inst.x6.x19/a_27_47# 0.00775f
C2408 VPWR dc_inst.x7.net8 0.01786f
C2409 dc_inst.x2.net19 _15_/a_397_47# 0
C2410 dc_inst.x7.net15 clknet_1_0__leaf_clk 0.00157f
C2411 path[7] dc_inst.x3.x12/a_27_47# 0.00118f
C2412 VPWR dc_inst.x9/a_923_363# -0
C2413 dc_inst.x5.net14 dc_inst.x4.net11 0
C2414 VPWR dc_inst.x2.net9 0.03041f
C2415 dc_inst.x1.net18 dc_inst.x1.x17/a_27_47# 0.01682f
C2416 dc_inst.x1.x19/a_27_47# dc_inst.x1.net16 0
C2417 dc_inst.x1.net3 _10_ 0.01525f
C2418 VPWR dc_inst.x5.net1 0.58831f
C2419 dc_inst.x2.net16 dc_inst.x2.x15/a_27_47# 0.01151f
C2420 dc_inst.x2.x16/a_27_47# dc_inst.x2.net15 0.03309f
C2421 dc_inst.x1.net14 path_sel[0] 0.00102f
C2422 dc_inst.x6.net4 dc_inst.x9/a_27_413# 0
C2423 dc_inst.x6.net16 dc_inst.x7.x7/a_27_47# 0
C2424 _23_/a_1108_47# dc_inst.x8/a_277_47# 0
C2425 VPWR dc_inst.x3.x20/a_27_47# 0.02924f
C2426 path_sel[2] dc_inst.x7.net8 0.00506f
C2427 path_sel[2] dc_inst.x9/a_923_363# 0
C2428 dc_inst.x1.net19 dc_inst.x4.net6 0
C2429 dc_inst.x7.net13 dc_inst.x9/a_668_97# 0
C2430 path_sel[2] dc_inst.x2.net9 0
C2431 path_sel[2] dc_inst.x5.net1 0
C2432 dc_inst.x1.x20/a_27_47# dc_inst.x1.x16/a_27_47# 0.03129f
C2433 path_sel[2] dc_inst.x3.x20/a_27_47# 0.00136f
C2434 dc_inst.x6.x1/a_27_47# dc_inst.x6.x10/a_27_47# 0
C2435 delay_sel[1] dc_inst.x7.net18 0
C2436 dc_inst.x1.net4 dc_inst.x1.net5 0.00445f
C2437 capture_d delay_sel[1] 0
C2438 dc_inst.x5.net9 dc_inst.x2.net2 0
C2439 delay_sel[2] dc_inst.net7 0
C2440 dc_inst.net8 delay_sel[0] 0.01212f
C2441 dc_inst.x4.x10/a_27_47# dc_inst.x4.net5 0
C2442 dc_inst.x1.net2 dc_inst.x1.x8/a_27_47# 0
C2443 dc_inst.net6 dc_inst.x7.x18/a_27_47# 0
C2444 dc_inst.x7.net3 dc_inst.x3.x17/a_27_47# 0
C2445 dc_inst.x5.net18 dc_inst.x6.net8 0.00794f
C2446 dc_inst.x2.net14 dc_inst.x2.x1/a_27_47# 0
C2447 path[2] _17_/a_478_47# 0.00468f
C2448 _18_/a_218_47# _08_ 0
C2449 dc_inst.x3.net8 dc_inst.x3.x13/a_27_47# 0.11245f
C2450 dc_inst.x2.net19 dc_inst.x8/a_1290_413# 0
C2451 dc_inst.x4.net2 dc_inst.net2 0
C2452 dc_inst.x9/a_757_363# dc_inst.x6.net11 0
C2453 dc_inst.x4.x2/a_27_47# dc_inst.x4.x4/a_27_47# 0.08729f
C2454 _25_/a_761_289# clkbuf_1_0__f_clk/a_110_47# 0.00956f
C2455 dc_inst.x2.x10/a_27_47# path_sel[0] 0
C2456 dc_inst.x4.net2 dc_inst.net5 0
C2457 _14_/a_218_47# path[6] 0.00108f
C2458 _14_/a_76_199# path[5] 0
C2459 dc_inst.x6.x8/a_27_47# dc_inst.x5.net14 0
C2460 dc_inst.x3.net14 dc_inst.x8/a_750_97# 0
C2461 dc_inst.x1.net10 _09_ 0
C2462 dc_inst.x1.x10/a_27_47# path[2] 0
C2463 VPWR dc_inst.x4.net7 0.32286f
C2464 dc_inst.x1.net19 dc_inst.x2.net3 0
C2465 dc_inst.x2.net6 dc_inst.x5.net7 0
C2466 dc_inst.x1.net15 dc_inst.x1.x8/a_27_47# 0
C2467 dc_inst.x7.x15/a_27_47# dc_inst.net7 0
C2468 dc_inst.x6.x8/a_27_47# dc_inst.x5.x13/a_27_47# 0
C2469 dc_inst.x1.net5 dc_inst.x1.net9 0.00487f
C2470 dc_inst.x5.net6 dc_inst.x2.net7 0.17246f
C2471 _13_/a_470_297# path[6] 0.0246f
C2472 clkbuf_1_0__f_clk/a_110_47# dc_inst.x7.net6 0
C2473 dc_inst.x4.net1 dc_inst.x2.net10 -0
C2474 path_sel[2] dc_inst.x4.net7 0.00478f
C2475 dc_inst.x1.net5 _04_ 0.06555f
C2476 dc_inst.x4.net2 dc_inst.x1.net4 0.00241f
C2477 dc_inst.x4.x10/a_27_47# dc_inst.x2.net2 0.00182f
C2478 tdo dc_inst.x5.net8 0.0347f
C2479 dc_inst.net7 dc_inst.x6.x20/a_27_47# 0
C2480 clknet_1_1__leaf_clk clkload0/a_27_47# 0.02666f
C2481 path[5] dc_inst.x3.net14 0.40006f
C2482 dc_inst.x4.x17/a_27_47# tdo 0.00128f
C2483 dc_inst.x1.x1/a_27_47# dc_inst.x3.net17 0
C2484 dc_inst.x2.net18 dc_inst.x8/a_750_97# 0
C2485 dc_inst.x6.net7 dc_inst.x4.x9/a_27_47# 0
C2486 dc_inst.x5.x19/a_27_47# dc_inst.x5.net3 0
C2487 dc_inst.x2.x15/a_27_47# dc_inst.x1.net9 0.00362f
C2488 dc_inst.x4.x1/a_27_47# dc_inst.net3 0.01798f
C2489 dc_inst.x1.net8 dc_inst.x3.x20/a_27_47# 0
C2490 dc_inst.net3 dc_inst.x7.net4 0.20697f
C2491 dc_inst.x1.net15 dc_inst.net1 0
C2492 dc_inst.x4.x14/a_27_47# dc_inst.x4.net15 0.00148f
C2493 dc_inst.x6.net5 dc_inst.x6.net13 0.0039f
C2494 VPWR dc_inst.x2.net17 0.17118f
C2495 dc_inst.x5.net19 dc_inst.x7.net18 0.00164f
C2496 dc_inst.x1.net19 tdo 0
C2497 _25_/a_805_47# clknet_0_clk 0
C2498 _25_/a_1283_21# dc_inst.x9/a_1290_413# 0
C2499 _24_/a_27_47# delay_sel[1] 0
C2500 _24_/a_543_47# delay_sel[0] 0
C2501 dc_inst.x4.net13 dc_inst.x2.x12/a_27_47# 0
C2502 dc_inst.x3.x1/a_27_47# _23_/a_1283_21# 0.00964f
C2503 dc_inst.x4.net2 dc_inst.x1.net9 0
C2504 dc_inst.x2.net17 path_sel[2] 0.02078f
C2505 dc_inst.x1.net3 _20_/a_79_21# 0.00976f
C2506 dc_inst.x6.x17/a_27_47# delay_sel[0] 0
C2507 dc_inst.x6.net4 dc_inst.x6.net14 0
C2508 dc_inst.x6.x4/a_27_47# dc_inst.x7.net10 0
C2509 dc_inst.x5.net19 dc_inst.x6.net6 0.02419f
C2510 dc_inst.x1.net14 dc_inst.x1.net7 0
C2511 dc_inst.x4.net4 VPWR 0.04813f
C2512 dc_inst.x6.net5 dc_inst.x6.net12 0
C2513 dc_inst.x1.net18 dc_inst.in 0
C2514 dc_inst.x3.net8 dc_inst.x3.x8/a_27_47# 0.01443f
C2515 path[5] dc_inst.x3.x15/a_27_47# 0
C2516 _05_ path[5] 0.01081f
C2517 dc_inst.x7.net3 _23_/a_761_289# 0
C2518 dc_inst.x4.net5 dc_inst.x4.net7 0.00467f
C2519 dc_inst.x5.net6 dc_inst.x5.net3 0.2731f
C2520 path_sel[1] dc_inst.x2.x13/a_27_47# 0.00682f
C2521 dc_inst.x9/a_27_47# dc_inst.x7.net6 0
C2522 dc_inst.x1.net2 dc_inst.x1.net3 0.08036f
C2523 dc_inst.x4.net4 path_sel[2] 0.00475f
C2524 capture_d dc_inst.x8/a_27_47# 0
C2525 dc_inst.x3.x9/a_27_47# path[7] 0
C2526 dc_inst.net8 dc_inst.x8/a_750_97# 0.02676f
C2527 dc_inst.x7.x3/a_27_47# _24_/a_1108_47# 0
C2528 VPWR dc_inst.net6 0.13831f
C2529 _00_ clkload0/a_27_47# 0
C2530 dc_inst.x6.net16 delay_sel[1] 0
C2531 dc_inst.x3.net6 _15_/a_788_316# 0
C2532 dc_inst.x6.x1/a_27_47# dc_inst.x7.net9 0
C2533 dc_inst.x9/a_1290_413# dc_inst.net1 0.00312f
C2534 path_sel[2] _15_/a_193_47# 0
C2535 _10_ _15_/a_27_47# 0.00162f
C2536 rst dc_inst.x3.x11/a_27_47# 0.01185f
C2537 _18_/a_439_47# path[3] 0
C2538 dc_inst.net6 path_sel[2] 0.00706f
C2539 _15_/a_27_47# dc_inst.x1.x7/a_27_47# 0
C2540 dc_inst.x4.net4 dc_inst.x6.net15 0.00654f
C2541 _01_ dc_inst.in 0.00794f
C2542 dc_inst.x1.net15 dc_inst.x1.net3 0
C2543 dc_inst.x1.x12/a_27_47# _15_/a_872_316# 0
C2544 dc_inst.x1.x20/a_27_47# dc_inst.x2.net3 0
C2545 _25_/a_193_47# delay_sel[1] 0.00176f
C2546 dc_inst.x3.x4/a_27_47# dc_inst.x3.net14 0
C2547 dc_inst.x2.net17 dc_inst.x4.net5 0.01647f
C2548 VPWR dc_inst.x8/a_277_47# -0.01878f
C2549 dc_inst.x2.net2 dc_inst.x4.net7 0.32816f
C2550 dc_inst.x6.net5 path_sel[1] 0
C2551 VPWR dc_inst.x5.x7/a_27_47# 0.00856f
C2552 dc_inst.x2.net17 dc_inst.x1.net8 0.02697f
C2553 dc_inst.x5.net19 dc_inst.x6.x11/a_27_47# 0
C2554 dc_inst.x5.x19/a_27_47# dc_inst.x6.net11 0
C2555 dc_inst.x4.net16 dc_inst.x4.net19 0.00407f
C2556 path_sel[2] dc_inst.x8/a_277_47# 0
C2557 dc_inst.x3.net4 dc_inst.net2 0
C2558 dc_inst.net4 dc_inst.x4.x8/a_27_47# 0
C2559 dc_inst.x6.x9/a_27_47# dc_inst.x7.net4 0
C2560 dc_inst.x7.net3 dc_inst.x10/a_76_199# 0.06622f
C2561 rst dc_inst.x9/a_1290_413# 0.00117f
C2562 dc_inst.x2.net19 dc_inst.x2.x20/a_27_47# 0.12175f
C2563 dc_inst.x4.net4 dc_inst.x4.net5 0.04173f
C2564 dc_inst.x7.net3 dc_inst.x2.net18 0
C2565 dc_inst.x5.net6 dc_inst.x6.net19 0
C2566 dc_inst.x5.net5 dc_inst.x5.x9/a_27_47# 0
C2567 dc_inst.x7.x1/a_27_47# dc_inst.x7.x6/a_27_47# 0.03162f
C2568 dc_inst.net5 dc_inst.x7.net18 0
C2569 dc_inst.x4.net4 dc_inst.x1.net8 0
C2570 delay_sel[0] dc_inst.net1 0.07283f
C2571 dc_inst.net6 dc_inst.x4.net5 0
C2572 _10_ _15_/a_1064_47# 0
C2573 dc_inst.net3 _23_/a_27_47# 0
C2574 dc_inst.x6.x18/a_27_47# delay_sel[0] 0
C2575 _24_/a_27_47# dc_inst.x8/a_27_47# 0
C2576 dc_inst.x5.net19 dc_inst.x6.net16 0
C2577 dc_inst.x1.net14 dc_inst.x5.net12 0
C2578 dc_inst.x6.net9 dc_inst.x6.net6 0.00853f
C2579 dc_inst.x1.net3 dc_inst.x3.net19 0.01514f
C2580 dc_inst.net5 dc_inst.x6.net6 0
C2581 dc_inst.x2.x15/a_27_47# dc_inst.x2.net15 0.00377f
C2582 dc_inst.x9/a_247_21# dc_inst.x9/a_277_47# -0.00594f
C2583 dc_inst.x7.x14/a_27_47# dc_inst.x7.x9/a_27_47# 0
C2584 clkload0/X dc_inst.in 0
C2585 dc_inst.x3.x4/a_27_47# dc_inst.x3.x15/a_27_47# 0
C2586 dc_inst.x1.net4 dc_inst.x3.net4 0.00146f
C2587 clknet_1_0__leaf_clk dc_inst.x9/a_247_21# 0
C2588 dc_inst.x1.x12/a_27_47# path[7] 0
C2589 dc_inst.x3.x5/a_27_47# dc_inst.x3.x7/a_27_47# 0
C2590 dc_inst.x2.net11 dc_inst.x2.net13 0
C2591 dc_inst.x5.net6 dc_inst.x6.net11 0
C2592 dc_inst.x3.net9 dc_inst.x3.x11/a_27_47# 0.12033f
C2593 dc_inst.x4.net16 dc_inst.x6.net6 0
C2594 dc_inst.x4.net13 dc_inst.x5.net7 0
C2595 dc_inst.x5.net12 dc_inst.x4.net8 0
C2596 _25_/a_1108_47# dc_inst.x7.net2 0
C2597 dc_inst.x6.net2 dc_inst.x5.net17 0
C2598 dc_inst.x7.net13 dc_inst.x7.x9/a_27_47# 0
C2599 dc_inst.x5.net9 dc_inst.x2.net12 0
C2600 dc_inst.x4.net5 dc_inst.x8/a_277_47# 0
C2601 dc_inst.in dc_inst.x7.net16 0
C2602 dc_inst.x5.net7 dc_inst.x4.x5/a_27_47# 0
C2603 dc_inst.x3.net3 dc_inst.in 0
C2604 dc_inst.x2.x10/a_27_47# dc_inst.x5.net12 0.02061f
C2605 dc_inst.x4.x5/a_27_47# dc_inst.x4.x6/a_27_47# 0.02448f
C2606 _15_/a_27_47# _20_/a_79_21# 0
C2607 dc_inst.x9/a_750_97# dc_inst.x7.x5/a_27_47# 0
C2608 dc_inst.x7.net3 dc_inst.net8 0.14814f
C2609 _17_/a_574_297# path[1] 0
C2610 _17_/a_27_93# _07_ 0.0128f
C2611 rst delay_sel[0] 0.00178f
C2612 dc_inst.x3.net11 dc_inst.x3.net17 0
C2613 dc_inst.x5.net16 dc_inst.x5.net18 0.01044f
C2614 dc_inst.x3.net12 dc_inst.x3.net16 0
C2615 dc_inst.x4.net16 dc_inst.x4.net15 0.00317f
C2616 dc_inst.net3 _23_/a_1217_47# 0
C2617 _24_/a_27_47# dc_inst.net2 0
C2618 _02_ dc_inst.x8/a_277_47# 0
C2619 dc_inst.x1.net2 _15_/a_27_47# 0.10067f
C2620 dc_inst.x10/a_505_21# dc_inst.x7.net4 0.00146f
C2621 dc_inst.x9/a_923_363# dc_inst.x9/a_834_97# -0
C2622 dc_inst.x6.net9 dc_inst.x6.x11/a_27_47# 0.00144f
C2623 dc_inst.x7.x3/a_27_47# _01_ 0.01368f
C2624 clkbuf_1_0__f_clk/a_110_47# delay_sel[0] 0.00435f
C2625 dc_inst.x4.net11 dc_inst.x5.net7 0
C2626 dc_inst.x4.x10/a_27_47# dc_inst.x2.net12 0
C2627 VPWR _17_/a_574_297# 0
C2628 dc_inst.x3.x1/a_27_47# clkbuf_1_1__f_clk/a_110_47# 0
C2629 dc_inst.in dc_inst.x6.net14 0.00437f
C2630 dc_inst.x2.net12 dc_inst.x2.x9/a_27_47# 0.00124f
C2631 dc_inst.x5.net7 dc_inst.x2.x2/a_27_47# 0.03645f
C2632 dc_inst.x2.x12/a_27_47# dc_inst.x2.net10 0.14817f
C2633 dc_inst.x6.x1/a_27_47# dc_inst.x6.x17/a_27_47# 0.08729f
C2634 dc_inst.x3.net2 dc_inst.x3.net19 0.2219f
C2635 dc_inst.net4 dc_inst.x7.x17/a_27_47# 0
C2636 _00_ dc_inst.x7.net2 0
C2637 dc_inst.x6.x5/a_27_47# dc_inst.x6.net1 0
C2638 dc_inst.x5.net4 dc_inst.x2.x12/a_27_47# 0.01151f
C2639 dc_inst.x6.x3/a_27_47# dc_inst.x7.net10 0
C2640 _19_/a_27_47# path_sel[1] 0.03996f
C2641 dc_inst.x6.net4 dc_inst.x6.net12 0
C2642 dc_inst.net9 dc_inst.in 0.09911f
C2643 dc_inst.x5.net5 dc_inst.x5.net8 0
C2644 _24_/a_1108_47# dc_inst.x3.x1/a_27_47# 0
C2645 dc_inst.net1 dc_inst.x8/a_750_97# 0
C2646 _15_/a_600_345# _06_ 0
C2647 _15_/a_288_47# dc_inst.in 0
C2648 dc_inst.x5.net7 dc_inst.net1 0
C2649 dc_inst.net5 dc_inst.x6.net16 0.09517f
C2650 dc_inst.x4.x20/a_27_47# dc_inst.x6.net1 0.01122f
C2651 tdi dc_inst.x3.net10 0.00224f
C2652 dc_inst.x4.x7/a_27_47# dc_inst.x4.net7 0.01872f
C2653 dc_inst.x6.net2 dc_inst.x7.x7/a_27_47# 0.02903f
C2654 tdo dc_inst.x4.net10 0.02572f
C2655 dc_inst.x2.net9 dc_inst.x2.net12 0.00466f
C2656 dc_inst.x6.x5/a_27_47# dc_inst.x4.x20/a_27_47# 0
C2657 dc_inst.x4.net4 dc_inst.x6.x15/a_27_47# 0
C2658 dc_inst.x4.x1/a_27_47# path_sel[0] 0
C2659 dc_inst.x6.x8/a_27_47# dc_inst.x5.net7 0
C2660 dc_inst.x1.net18 dc_inst.x5.net6 0.00481f
C2661 dc_inst.x2.net12 dc_inst.x5.net1 0
C2662 dc_inst.x1.net17 dc_inst.x6.x13/a_27_47# 0
C2663 dc_inst.x1.net2 _15_/a_1064_47# 0
C2664 _25_/a_193_47# dc_inst.net5 0
C2665 dc_inst.x9/a_27_47# delay_sel[0] 0
C2666 dc_inst.x9/a_750_97# delay_sel[1] 0.04375f
C2667 _00_ dc_inst.x7.net11 0.00169f
C2668 dc_inst.x1.net11 _15_/a_600_345# 0
C2669 dc_inst.x7.net2 dc_inst.x7.x7/a_27_47# 0
C2670 dc_inst.x4.x4/a_27_47# dc_inst.x6.net17 0
C2671 dc_inst.x3.net2 delay_sel[0] 0
C2672 dc_inst.x3.x2/a_27_47# delay_sel[1] 0
C2673 dc_inst.x2.net11 path_sel[0] 0
C2674 _19_/a_109_297# _18_/a_76_199# 0
C2675 _19_/a_27_47# _18_/a_505_21# 0
C2676 dc_inst.x2.x17/a_27_47# dc_inst.x1.net14 0
C2677 dc_inst.x2.net17 dc_inst.x1.x14/a_27_47# 0.1093f
C2678 dc_inst.net6 clknet_0_clk 0
C2679 dc_inst.x3.net16 shadow_q 0.06733f
C2680 dc_inst.x3.net7 path_sel[1] 0
C2681 delay_sel[2] dc_inst.x3.x17/a_27_47# 0
C2682 dc_inst.x6.net4 path_sel[1] 0
C2683 _15_/a_27_47# dc_inst.x3.net19 0
C2684 rst dc_inst.x8/a_750_97# 0
C2685 dc_inst.x6.net8 dc_inst.x6.net1 0
C2686 _18_/a_218_47# _07_ 0.0015f
C2687 path[2] _16_/a_27_93# 0.00562f
C2688 dc_inst.x1.x3/a_27_47# dc_inst.x3.net3 0
C2689 dc_inst.x4.net3 dc_inst.x2.net18 0.02096f
C2690 dc_inst.x6.x1/a_27_47# dc_inst.x7.net7 0
C2691 dc_inst.x1.x4/a_27_47# dc_inst.x1.x8/a_27_47# 0.08729f
C2692 dc_inst.x6.net2 dc_inst.x7.x5/a_27_47# 0
C2693 dc_inst.x3.x5/a_27_47# path[7] 0
C2694 dc_inst.x2.net7 dc_inst.x2.net8 0.09584f
C2695 dc_inst.x1.x15/a_27_47# dc_inst.x1.x7/a_27_47# 0
C2696 dc_inst.x3.net14 _23_/a_193_47# 0
C2697 path[4] _20_/a_470_297# 0.00114f
C2698 dc_inst.x1.net3 dc_inst.x8/a_750_97# 0
C2699 dc_inst.x1.net12 path_sel[1] 0.02839f
C2700 dc_inst.x5.x20/a_27_47# dc_inst.x7.net19 0
C2701 path_sel[0] dc_inst.net4 0
C2702 dc_inst.x7.net2 dc_inst.x7.x5/a_27_47# 0
C2703 delay_sel[1] dc_inst.x6.x14/a_27_47# 0
C2704 rst path[5] 0.00319f
C2705 dc_inst.x2.net12 dc_inst.x4.net7 0
C2706 dc_inst.x9/a_247_21# dc_inst.x8/a_247_21# 0
C2707 _06_ dc_inst.x1.x6/a_27_47# 0.00206f
C2708 dc_inst.x6.x20/a_27_47# dc_inst.x7.net5 0.02481f
C2709 dc_inst.x3.net15 dc_inst.x3.net17 0
C2710 dc_inst.x10/a_76_199# _23_/a_193_47# 0
C2711 dc_inst.x7.net3 _25_/a_1283_21# 0
C2712 dc_inst.x10/a_505_21# _23_/a_27_47# 0
C2713 dc_inst.x1.net15 dc_inst.x1.x18/a_27_47# 0
C2714 VPWR _18_/a_439_47# -0
C2715 dc_inst.x1.net3 path[5] 0.20499f
C2716 dc_inst.x5.net5 dc_inst.x5.net10 0
C2717 dc_inst.x4.x20/a_27_47# dc_inst.x6.net8 0
C2718 dc_inst.x7.net14 dc_inst.net4 0.01011f
C2719 dc_inst.x1.x9/a_27_47# dc_inst.x1.x8/a_27_47# 0
C2720 dc_inst.x1.net13 dc_inst.net8 0
C2721 dc_inst.x5.x17/a_27_47# path_sel[1] 0.00658f
C2722 _24_/a_193_47# dc_inst.net3 0
C2723 dc_inst.x4.x17/a_27_47# dc_inst.x5.x6/a_27_47# 0
C2724 dc_inst.x4.x4/a_27_47# dc_inst.x2.net3 0
C2725 _19_/a_27_47# path[3] 0.02078f
C2726 dc_inst.net6 dc_inst.x9/a_834_97# 0.00326f
C2727 dc_inst.x2.x6/a_27_47# dc_inst.x2.net7 0.00257f
C2728 dc_inst.x1.x17/a_27_47# path_sel[1] 0
C2729 dc_inst.in dc_inst.x8/a_193_47# 0
C2730 dc_inst.x1.net11 dc_inst.x1.x6/a_27_47# 0.03045f
C2731 dc_inst.x4.net3 dc_inst.net8 0
C2732 _14_/a_76_199# se 0.04044f
C2733 dc_inst.x3.x15/a_27_47# _23_/a_193_47# 0
C2734 dc_inst.x2.net18 dc_inst.x2.net19 0.12779f
C2735 dc_inst.x7.net3 dc_inst.net1 0
C2736 dc_inst.x2.net8 dc_inst.x5.net3 0
C2737 dc_inst.x1.net16 dc_inst.x1.net10 0
C2738 dc_inst.x1.net19 dc_inst.x5.x6/a_27_47# 0
C2739 dc_inst.x7.net3 dc_inst.x6.x18/a_27_47# 0
C2740 dc_inst.x1.net5 dc_inst.x1.x12/a_27_47# 0.00126f
C2741 dc_inst.x1.x4/a_27_47# _20_/a_384_47# 0
C2742 se dc_inst.x3.net14 0
C2743 capture_q dc_inst.x3.net5 0
C2744 dc_inst.x7.net12 clk 0
C2745 dc_inst.x6.x4/a_27_47# dc_inst.x6.net6 0.00331f
C2746 dc_inst.x7.net15 dc_inst.x7.net19 0.06094f
C2747 dc_inst.x7.x2/a_27_47# tdo 0.00141f
C2748 _23_/a_1108_47# shadow_q 0
C2749 delay_sel[2] _23_/a_761_289# 0.0158f
C2750 dc_inst.net8 _23_/a_193_47# 0.00436f
C2751 dc_inst.x3.net2 dc_inst.x8/a_750_97# 0
C2752 dc_inst.x3.net11 dc_inst.x3.net15 0
C2753 dc_inst.x5.net13 path_sel[1] 0.0054f
C2754 dc_inst.x3.net19 dc_inst.x8/a_1478_413# 0
C2755 path_sel[1] dc_inst.x2.x14/a_27_47# 0.00593f
C2756 dc_inst.x3.net7 dc_inst.x3.net16 0
C2757 dc_inst.x3.net6 dc_inst.x3.net17 0.0137f
C2758 dc_inst.x3.x1/a_27_47# _01_ 0.00297f
C2759 dc_inst.x3.net9 path[5] 0.03503f
C2760 dc_inst.x4.x3/a_27_47# dc_inst.x7.net2 0
C2761 dc_inst.x4.net2 dc_inst.x6.net19 0.00188f
C2762 dc_inst.x7.net2 delay_sel[1] 0.12681f
C2763 _23_/a_639_47# _03_ 0
C2764 dc_inst.x3.net3 path[7] 0.002f
C2765 dc_inst.x3.net2 path[5] 0.00302f
C2766 dc_inst.x2.x6/a_27_47# dc_inst.x5.net3 0.03903f
C2767 dc_inst.x7.net3 rst 0.41672f
C2768 _13_/a_112_47# dc_inst.x3.net4 0
C2769 dc_inst.x7.x1/a_27_47# dc_inst.net6 0.04097f
C2770 _13_/a_27_297# shadow_q 0.00283f
C2771 dc_inst.x4.x18/a_27_47# path_sel[1] 0.00361f
C2772 dc_inst.x1.net12 path[3] 0
C2773 VPWR dc_inst.x2.x13/a_27_47# 0
C2774 dc_inst.x1.net17 dc_inst.x4.x1/a_27_47# 0
C2775 dc_inst.x6.net7 dc_inst.x6.x7/a_27_47# 0.01976f
C2776 dc_inst.x1.net2 dc_inst.x1.x15/a_27_47# 0.00173f
C2777 dc_inst.x6.x2/a_27_47# dc_inst.x5.net18 0
C2778 dc_inst.x6.x19/a_27_47# dc_inst.x7.net19 0
C2779 path_sel[0] dc_inst.x3.net13 0.00214f
C2780 se _05_ 0.0466f
C2781 se dc_inst.x3.x15/a_27_47# 0
C2782 dc_inst.x5.net6 dc_inst.x6.net14 0
C2783 dc_inst.x4.x2/a_27_47# dc_inst.x6.net17 0
C2784 dc_inst.x4.net3 dc_inst.x6.x17/a_27_47# 0
C2785 dc_inst.x4.x3/a_27_47# dc_inst.x8/a_757_363# 0
C2786 path_sel[2] dc_inst.x2.x13/a_27_47# 0.00224f
C2787 dc_inst.x7.x11/a_27_47# clkbuf_1_0__f_clk/a_110_47# 0
C2788 dc_inst.x3.x3/a_27_47# shadow_q 0.00146f
C2789 dc_inst.x7.x2/a_27_47# clknet_1_0__leaf_clk 0
C2790 dc_inst.x7.x2/a_27_47# dc_inst.x9/a_277_47# 0
C2791 dc_inst.x2.x11/a_27_47# dc_inst.x5.net9 0
C2792 dc_inst.x7.net13 dc_inst.x7.net1 0
C2793 delay_sel[0] dc_inst.x8/a_1478_413# 0
C2794 delay_sel[1] dc_inst.x8/a_757_363# 0.00836f
C2795 dc_inst.x10/a_218_374# capture_d 0.00289f
C2796 dc_inst.x10/a_76_199# delay_sel[2] 0.00322f
C2797 dc_inst.x1.net10 dc_inst.x1.x11/a_27_47# 0
C2798 dc_inst.net5 dc_inst.x9/a_750_97# 0
C2799 dc_inst.x7.net11 delay_sel[1] 0.03196f
C2800 VPWR dc_inst.x3.net12 0.23912f
C2801 dc_inst.x1.net15 dc_inst.x1.x15/a_27_47# 0.0021f
C2802 dc_inst.x3.x16/a_27_47# shadow_q 0.03509f
C2803 dc_inst.x3.net6 dc_inst.x3.net11 0
C2804 dc_inst.x5.net3 dc_inst.x4.net19 0.07137f
C2805 _24_/a_27_47# _23_/a_1283_21# 0.00302f
C2806 _24_/a_543_47# _23_/a_193_47# 0.00153f
C2807 _24_/a_193_47# _23_/a_543_47# 0
C2808 path_sel[1] dc_inst.in 0.0228f
C2809 dc_inst.x4.net1 dc_inst.x4.x8/a_27_47# 0.01151f
C2810 dc_inst.x6.net2 dc_inst.x5.net19 0.08566f
C2811 dc_inst.x2.net10 dc_inst.x1.x9/a_27_47# 0
C2812 VPWR dc_inst.x6.net5 0.06342f
C2813 dc_inst.x2.net16 dc_inst.x1.net14 0
C2814 _25_/a_193_47# clkbuf_0_clk/a_110_47# 0.01729f
C2815 _15_/a_27_47# path[5] 0.02633f
C2816 _15_/a_288_47# path[7] 0.03458f
C2817 dc_inst.x5.x2/a_27_47# dc_inst.x5.net3 0.00211f
C2818 dc_inst.x1.net15 dc_inst.x2.x4/a_27_47# 0.00122f
C2819 dc_inst.x1.net4 dc_inst.x3.x2/a_27_47# 0.135f
C2820 dc_inst.x1.net13 dc_inst.x1.x8/a_27_47# 0
C2821 delay_sel[2] dc_inst.x3.x15/a_27_47# 0
C2822 dc_inst.x7.net2 dc_inst.x5.net19 0
C2823 dc_inst.x6.net5 path_sel[2] 0.02221f
C2824 VPWR _23_/a_639_47# 0.00524f
C2825 dc_inst.x2.net11 dc_inst.x2.net14 0.00141f
C2826 _15_/a_788_316# dc_inst.x1.x6/a_27_47# 0
C2827 dc_inst.x3.x1/a_27_47# dc_inst.x3.net3 0
C2828 dc_inst.x2.net11 dc_inst.x5.net12 0.00539f
C2829 dc_inst.x3.net7 _23_/a_1108_47# 0
C2830 dc_inst.x8/a_193_413# dc_inst.x8/a_247_21# -0.0024f
C2831 dc_inst.x8/a_27_413# dc_inst.x8/a_277_47# -0.00157f
C2832 dc_inst.x4.net3 dc_inst.x1.x8/a_27_47# 0
C2833 _24_/a_27_47# _13_/a_112_47# 0
C2834 dc_inst.x6.net4 dc_inst.x7.net1 0
C2835 dc_inst.x3.net2 dc_inst.x3.x4/a_27_47# 0
C2836 dc_inst.x5.net6 dc_inst.x4.net9 0
C2837 dc_inst.x2.net10 dc_inst.x5.net11 0.0419f
C2838 dc_inst.x5.net1 _08_ 0
C2839 dc_inst.x7.net3 dc_inst.x3.net2 0
C2840 dc_inst.x5.x4/a_27_47# dc_inst.x5.net10 0.00267f
C2841 dc_inst.x6.net6 dc_inst.x5.net3 0
C2842 dc_inst.x6.net7 dc_inst.x5.net2 0.0356f
C2843 dc_inst.x4.net16 dc_inst.x6.x14/a_27_47# 0
C2844 dc_inst.net3 dc_inst.x1.net2 0
C2845 dc_inst.x3.x9/a_27_47# dc_inst.x3.x13/a_27_47# 0
C2846 delay_sel[2] dc_inst.net8 0.00578f
C2847 dc_inst.x5.x5/a_27_47# dc_inst.x5.net6 0.02967f
C2848 dc_inst.x1.net4 dc_inst.x1.net14 0
C2849 _16_/a_229_47# path_sel[0] 0.02224f
C2850 dc_inst.x7.net15 dc_inst.x7.net17 0.00128f
C2851 dc_inst.x4.net16 dc_inst.x4.net8 0.04513f
C2852 _06_ dc_inst.x3.x10/a_27_47# 0
C2853 dc_inst.x5.net12 dc_inst.net4 0
C2854 dc_inst.x9/a_247_21# dc_inst.x7.x4/a_27_47# 0
C2855 dc_inst.x6.x9/a_27_47# dc_inst.x7.net6 0
C2856 _24_/a_193_47# dc_inst.x10/a_505_21# 0
C2857 clknet_1_1__leaf_clk _23_/a_27_47# 0
C2858 dc_inst.x1.x19/a_27_47# dc_inst.x2.net4 0
C2859 dc_inst.x1.net19 dc_inst.x2.x3/a_27_47# 0
C2860 dc_inst.x4.net3 dc_inst.net1 0
C2861 _25_/a_27_47# dc_inst.x7.net1 0.04335f
C2862 _13_/a_112_47# dc_inst.x3.x8/a_27_47# 0.00108f
C2863 dc_inst.x1.net15 dc_inst.net3 0
C2864 dc_inst.x2.x13/a_27_47# dc_inst.x2.net2 0
C2865 dc_inst.x1.x4/a_27_47# _15_/a_27_47# 0.01132f
C2866 dc_inst.x4.net15 dc_inst.x5.net3 0.19062f
C2867 dc_inst.x4.net2 dc_inst.x1.net18 0
C2868 VPWR shadow_q 0.06848f
C2869 dc_inst.x3.x7/a_27_47# path_sel[1] 0
C2870 dc_inst.x1.net6 dc_inst.x1.net3 0.00893f
C2871 dc_inst.x8/a_750_97# dc_inst.x8/a_1478_413# -0.00487f
C2872 dc_inst.x8/a_277_47# dc_inst.x8/a_668_97# -0.01493f
C2873 dc_inst.x1.x17/a_27_47# dc_inst.x2.x5/a_27_47# 0
C2874 dc_inst.x1.net14 dc_inst.x1.net9 0.03965f
C2875 dc_inst.x7.net4 dc_inst.x7.x5/a_27_47# 0.02511f
C2876 dc_inst.x3.net4 clkbuf_1_1__f_clk/a_110_47# 0
C2877 _02_ dc_inst.x3.net12 0
C2878 dc_inst.x3.net7 dc_inst.x3.x16/a_27_47# 0
C2879 _19_/a_193_297# path_sel[0] 0
C2880 dc_inst.net4 dc_inst.x7.x7/a_27_47# 0.00138f
C2881 dc_inst.net1 _23_/a_193_47# 0
C2882 dc_inst.x3.x4/a_27_47# _15_/a_27_47# 0.00123f
C2883 dc_inst.x4.x18/a_27_47# dc_inst.x6.net10 0
C2884 dc_inst.x4.net17 dc_inst.x6.x10/a_27_47# 0
C2885 dc_inst.x6.net9 dc_inst.x6.net2 0
C2886 dc_inst.x6.x3/a_27_47# dc_inst.x6.net6 0
C2887 dc_inst.in dc_inst.x3.net16 0
C2888 dc_inst.net5 dc_inst.x6.net2 0
C2889 dc_inst.x7.x14/a_27_47# VPWR 0.04276f
C2890 dc_inst.x1.net18 dc_inst.x2.net8 0
C2891 dc_inst.x2.net1 _17_/a_478_47# 0
C2892 _15_/a_1060_369# dc_inst.net2 0
C2893 dc_inst.x3.x6/a_27_47# dc_inst.x3.x13/a_27_47# 0
C2894 dc_inst.x1.x3/a_27_47# path_sel[1] 0.013f
C2895 dc_inst.net3 dc_inst.x9/a_1290_413# 0
C2896 dc_inst.x7.net2 dc_inst.net5 0.14286f
C2897 dc_inst.x1.net13 dc_inst.x1.net3 0
C2898 dc_inst.x3.net6 dc_inst.x3.net15 0
C2899 _00_ _23_/a_27_47# 0
C2900 _24_/a_543_47# delay_sel[2] 0.01209f
C2901 _24_/a_1108_47# capture_d 0
C2902 dc_inst.net3 dc_inst.x3.net19 0
C2903 dc_inst.x2.net19 dc_inst.net1 0
C2904 dc_inst.x2.x10/a_27_47# dc_inst.x1.net9 0
C2905 dc_inst.x1.net16 dc_inst.x2.net6 0.00272f
C2906 tdo dc_inst.x6.net1 0
C2907 _25_/a_1217_47# dc_inst.x7.net1 0
C2908 VPWR _19_/a_27_47# 0.04418f
C2909 dc_inst.x7.net13 VPWR 0.10338f
C2910 dc_inst.x2.x19/a_27_47# dc_inst.x6.net18 0
C2911 dc_inst.x2.net19 dc_inst.x6.x18/a_27_47# 0
C2912 dc_inst.x2.x5/a_27_47# dc_inst.x2.x14/a_27_47# 0.04629f
C2913 dc_inst.x6.net6 dc_inst.x6.net11 0.00118f
C2914 dc_inst.net4 dc_inst.x7.x5/a_27_47# 0.01302f
C2915 dc_inst.x4.net12 path_sel[0] 0
C2916 dc_inst.x5.net6 dc_inst.x6.net13 0.01358f
C2917 dc_inst.x7.net19 dc_inst.x9/a_247_21# 0
C2918 dc_inst.x7.net13 path_sel[2] 0
C2919 tdo dc_inst.x6.x5/a_27_47# 0
C2920 _25_/a_27_47# _03_ -0
C2921 _19_/a_27_47# path_sel[2] 0.00871f
C2922 dc_inst.x6.net7 dc_inst.x4.net13 0
C2923 dc_inst.x1.net13 dc_inst.x2.net10 0
C2924 rst _23_/a_193_47# 0.00584f
C2925 dc_inst.x8/a_757_363# dc_inst.net2 0.00318f
C2926 dc_inst.x5.net16 dc_inst.x6.net8 0.01238f
C2927 dc_inst.x1.x1/a_27_47# _15_/a_600_345# 0
C2928 dc_inst.x1.net16 dc_inst.x2.net18 0
C2929 dc_inst.x5.net13 dc_inst.x4.x19/a_27_47# 0.00106f
C2930 capture_q _13_/a_470_297# 0
C2931 clkbuf_0_clk/a_110_47# clkload0/a_27_47# 0.00947f
C2932 _10_ path_sel[0] 0.08546f
C2933 dc_inst.x9/a_193_47# dc_inst.net4 0
C2934 tdo dc_inst.x4.x20/a_27_47# 0
C2935 dc_inst.x5.net6 dc_inst.x6.net12 0
C2936 path_sel[0] dc_inst.x1.x7/a_27_47# 0
C2937 dc_inst.x5.x19/a_27_47# path_sel[1] 0.00295f
C2938 dc_inst.x1.x20/a_27_47# dc_inst.x2.x3/a_27_47# 0
C2939 clkbuf_1_0__f_clk/a_110_47# _23_/a_193_47# 0
C2940 _24_/a_27_47# clkbuf_1_1__f_clk/a_110_47# 0.01268f
C2941 dc_inst.net3 delay_sel[0] 0.0075f
C2942 dc_inst.x2.x16/a_27_47# dc_inst.x6.net13 0
C2943 dc_inst.x2.net16 dc_inst.x6.x13/a_27_47# 0
C2944 dc_inst.x4.x3/a_27_47# dc_inst.x7.net4 0
C2945 dc_inst.x1.net4 dc_inst.x8/a_757_363# 0
C2946 dc_inst.x6.x17/a_27_47# dc_inst.x6.x20/a_27_47# 0
C2947 _25_/a_1283_21# delay_sel[2] 0
C2948 delay_sel[1] dc_inst.x7.net4 0.02068f
C2949 dc_inst.net7 dc_inst.x7.net5 0
C2950 _02_ shadow_q 0.21563f
C2951 dc_inst.x3.x7/a_27_47# dc_inst.x3.net16 0
C2952 dc_inst.x1.net3 dc_inst.x2.net19 0
C2953 dc_inst.x4.net17 dc_inst.x6.x7/a_27_47# 0
C2954 VPWR dc_inst.x6.net4 0.03129f
C2955 clk clknet_1_0__leaf_clk 0
C2956 VPWR dc_inst.x3.net7 0.12389f
C2957 dc_inst.x4.net1 path_sel[0] 0
C2958 dc_inst.x1.net13 dc_inst.x3.net2 0
C2959 dc_inst.x3.net8 dc_inst.x3.net10 0
C2960 dc_inst.x6.x11/a_27_47# dc_inst.x6.net11 0.00263f
C2961 dc_inst.in _23_/a_1108_47# 0
C2962 dc_inst.x3.x6/a_27_47# dc_inst.x3.x8/a_27_47# 0
C2963 dc_inst.x6.net4 path_sel[2] 0.01816f
C2964 dc_inst.x7.x19/a_27_47# delay_sel[0] 0
C2965 dc_inst.x6.net7 dc_inst.x4.net11 0
C2966 dc_inst.x6.net16 dc_inst.x6.net19 0.01057f
C2967 VPWR dc_inst.x1.net12 0.32959f
C2968 _19_/a_27_47# dc_inst.x1.net8 0
C2969 dc_inst.x1.x14/a_27_47# dc_inst.x2.x13/a_27_47# 0
C2970 dc_inst.x1.x1/a_27_47# path[6] 0
C2971 dc_inst.x5.net6 path_sel[1] 0.0409f
C2972 dc_inst.x1.net14 dc_inst.x2.net15 0
C2973 _25_/a_27_47# VPWR 0.00359f
C2974 _15_/a_788_316# dc_inst.x3.x10/a_27_47# 0
C2975 dc_inst.net5 dc_inst.x6.x12/a_27_47# 0.0115f
C2976 dc_inst.x1.net12 path_sel[2] 0.06975f
C2977 delay_sel[2] dc_inst.net1 0.00623f
C2978 _24_/a_805_47# VPWR 0
C2979 dc_inst.x1.net5 _15_/a_288_47# 0
C2980 dc_inst.x1.net6 _15_/a_27_47# 0
C2981 delay_sel[1] dc_inst.net4 0.04274f
C2982 se rst 0.66191f
C2983 dc_inst.x1.x5/a_27_47# _15_/a_600_345# 0
C2984 path_sel[1] path[7] 0.13747f
C2985 dc_inst.x7.x3/a_27_47# dc_inst.x3.net16 0.0025f
C2986 delay_sel[2] dc_inst.x6.x18/a_27_47# 0
C2987 dc_inst.x7.net12 _25_/a_639_47# 0
C2988 dc_inst.x2.x4/a_27_47# dc_inst.x5.net7 0
C2989 dc_inst.x4.x15/a_27_47# dc_inst.x5.net13 0
C2990 VPWR dc_inst.x5.x17/a_27_47# 0.03257f
C2991 dc_inst.x7.x15/a_27_47# dc_inst.x7.net7 0
C2992 dc_inst.x2.x20/a_27_47# dc_inst.x8/a_1290_413# 0.01118f
C2993 dc_inst.x1.x17/a_27_47# VPWR 0.02165f
C2994 dc_inst.x7.net1 dc_inst.x9/a_757_363# 0
C2995 dc_inst.x4.net2 dc_inst.x6.net14 0
C2996 dc_inst.x1.net18 dc_inst.x6.net6 0
C2997 dc_inst.x5.net14 path_sel[0] 0.002f
C2998 dc_inst.x5.x17/a_27_47# path_sel[2] 0.00228f
C2999 dc_inst.x6.x8/a_27_47# dc_inst.x6.net7 0.01149f
C3000 dc_inst.x1.x17/a_27_47# path_sel[2] 0
C3001 dc_inst.x2.x16/a_27_47# path_sel[1] 0
C3002 path_sel[0] dc_inst.x5.x13/a_27_47# 0.0025f
C3003 dc_inst.x4.net14 dc_inst.x5.net8 0.00709f
C3004 _16_/a_229_47# dc_inst.x5.net12 0
C3005 dc_inst.x5.net19 dc_inst.x7.net4 0.00625f
C3006 _25_/a_1108_47# _24_/a_193_47# 0
C3007 _25_/a_27_47# _24_/a_448_47# 0
C3008 dc_inst.x4.x17/a_27_47# dc_inst.x4.net14 0
C3009 dc_inst.x7.x9/a_27_47# dc_inst.x7.net10 0.00882f
C3010 dc_inst.x10/a_535_374# dc_inst.in 0
C3011 _24_/a_193_47# clknet_1_1__leaf_clk 0.42586f
C3012 dc_inst.x4.net17 dc_inst.x5.net2 0.00181f
C3013 tdi dc_inst.x3.x11/a_27_47# 0
C3014 path_sel[0] _20_/a_79_21# 0.0122f
C3015 _01_ dc_inst.x3.net4 0
C3016 dc_inst.x4.x18/a_27_47# dc_inst.x4.x15/a_27_47# 0.02448f
C3017 dc_inst.x4.net2 _15_/a_288_47# 0
C3018 dc_inst.x9/a_247_21# dc_inst.x7.net17 0.00204f
C3019 capture_d _01_ 0.0038f
C3020 delay_sel[2] rst 0.32284f
C3021 dc_inst.x5.net9 _07_ 0
C3022 _10_ dc_inst.x1.net7 0.03764f
C3023 dc_inst.x1.net10 dc_inst.x5.x12/a_27_47# 0.04222f
C3024 dc_inst.x1.x7/a_27_47# dc_inst.x1.net7 0.03123f
C3025 dc_inst.x3.x7/a_27_47# _23_/a_1108_47# 0
C3026 _25_/a_1217_47# VPWR 0
C3027 dc_inst.in _03_ 0
C3028 dc_inst.net3 dc_inst.x8/a_750_97# 0.34763f
C3029 VPWR dc_inst.x5.net13 -0.00634f
C3030 dc_inst.x1.net12 dc_inst.x1.net8 0.01725f
C3031 _02_ dc_inst.x3.net7 0
C3032 VPWR dc_inst.x2.x14/a_27_47# 0.00765f
C3033 dc_inst.x1.net2 path_sel[0] 0.11522f
C3034 dc_inst.x7.net4 dc_inst.x8/a_27_47# 0
C3035 dc_inst.x2.x12/a_27_47# dc_inst.x2.net13 0.01152f
C3036 dc_inst.x2.net12 dc_inst.x2.x13/a_27_47# 0.05855f
C3037 dc_inst.x9/a_757_363# dc_inst.x7.x18/a_27_47# 0
C3038 delay_sel[0] _23_/a_543_47# 0.00163f
C3039 delay_sel[1] _23_/a_27_47# 0
C3040 dc_inst.x6.net11 dc_inst.x2.x1/a_27_47# 0
C3041 dc_inst.x1.x4/a_27_47# dc_inst.x1.x15/a_27_47# 0.01013f
C3042 dc_inst.x5.net19 dc_inst.net4 0.04396f
C3043 dc_inst.x6.net17 dc_inst.x4.net6 0
C3044 path_sel[2] dc_inst.x2.x14/a_27_47# 0.00201f
C3045 dc_inst.x7.x15/a_27_47# rst 0
C3046 dc_inst.x3.x17/a_27_47# dc_inst.x8/a_1290_413# 0
C3047 dc_inst.x5.x20/a_27_47# dc_inst.x7.net8 0
C3048 dc_inst.x1.net15 path_sel[0] 0
C3049 dc_inst.x4.x18/a_27_47# VPWR -0.00892f
C3050 dc_inst.x5.x19/a_27_47# dc_inst.x6.net10 0
C3051 dc_inst.x1.x17/a_27_47# dc_inst.x4.net5 0.00333f
C3052 clkbuf_0_clk/a_110_47# dc_inst.x7.net2 0
C3053 _17_/a_478_47# path_sel[1] 0
C3054 _25_/a_193_47# _25_/a_448_47# -0.00297f
C3055 dc_inst.x5.net9 dc_inst.x5.x9/a_27_47# 0.05201f
C3056 _00_ _24_/a_193_47# 0.54768f
C3057 _25_/a_761_289# clknet_1_1__leaf_clk 0
C3058 dc_inst.x1.net17 dc_inst.x1.x7/a_27_47# 0
C3059 _24_/a_805_47# _02_ 0
C3060 dc_inst.x3.net8 dc_inst.x3.net13 0
C3061 dc_inst.x7.x3/a_27_47# _23_/a_1108_47# 0.00104f
C3062 path[6] dc_inst.x3.net17 0.03175f
C3063 clkload0/X capture_d 0
C3064 dc_inst.x7.x15/a_27_47# clkbuf_1_0__f_clk/a_110_47# 0.00506f
C3065 dc_inst.x2.net19 _15_/a_27_47# 0
C3066 delay_sel[0] dc_inst.x7.x17/a_27_47# 0
C3067 path[3] path[7] 0.00296f
C3068 dc_inst.x5.net15 dc_inst.x5.x17/a_27_47# 0.01154f
C3069 dc_inst.x1.x10/a_27_47# path_sel[1] 0.02615f
C3070 dc_inst.x6.net2 dc_inst.x6.x4/a_27_47# 0
C3071 dc_inst.x5.net7 dc_inst.x4.x8/a_27_47# 0.03002f
C3072 path[4] dc_inst.x3.net1 0.0013f
C3073 dc_inst.x4.x6/a_27_47# dc_inst.x4.x8/a_27_47# 0.01224f
C3074 dc_inst.x4.net12 dc_inst.x5.net12 0
C3075 dc_inst.x7.net12 dc_inst.x9/a_277_47# 0
C3076 dc_inst.x4.x1/a_27_47# dc_inst.net2 0
C3077 dc_inst.x2.net16 dc_inst.x2.net11 0
C3078 dc_inst.x7.net12 clknet_1_0__leaf_clk 0.3185f
C3079 _15_/a_788_316# dc_inst.x3.x14/a_27_47# 0
C3080 clkbuf_1_0__f_clk/a_110_47# dc_inst.x6.x20/a_27_47# 0
C3081 _24_/a_761_289# rst 0
C3082 _24_/a_27_47# _01_ 0
C3083 dc_inst.x5.net6 dc_inst.x2.x7/a_27_47# 0.00663f
C3084 dc_inst.x2.net7 dc_inst.x2.x10/a_27_47# 0
C3085 dc_inst.x7.x1/a_27_47# dc_inst.x6.net5 0
C3086 dc_inst.x7.net4 dc_inst.net2 0.02595f
C3087 dc_inst.x4.net1 dc_inst.x5.x8/a_27_47# 0
C3088 dc_inst.x7.net16 dc_inst.x7.net18 0.02038f
C3089 dc_inst.x3.net3 dc_inst.x3.net4 0.01777f
C3090 dc_inst.x6.net9 dc_inst.x7.net4 0
C3091 dc_inst.x1.net13 dc_inst.x8/a_1478_413# 0
C3092 dc_inst.net5 dc_inst.x7.net4 0.20582f
C3093 dc_inst.x10/a_76_199# dc_inst.net7 0
C3094 capture_d dc_inst.x7.net16 0
C3095 dc_inst.x10/a_505_21# delay_sel[0] 0.02087f
C3096 dc_inst.x5.net6 dc_inst.x6.net10 0.09476f
C3097 delay_sel[2] dc_inst.x3.net2 0
C3098 VPWR dc_inst.in 0.81369f
C3099 clkbuf_0_clk/a_110_47# dc_inst.x7.net11 0.00154f
C3100 clk dc_inst.x7.x12/a_27_47# 0
C3101 dc_inst.x5.net1 _07_ 0.02988f
C3102 path[0] dc_inst.x5.net11 0
C3103 dc_inst.x4.net17 dc_inst.x4.net13 0.05658f
C3104 dc_inst.x2.net14 dc_inst.x1.x7/a_27_47# 0.00114f
C3105 _18_/a_505_21# _17_/a_478_47# 0
C3106 path_sel[0] dc_inst.x3.net19 0
C3107 path_sel[2] dc_inst.in 0.03765f
C3108 dc_inst.x6.net17 dc_inst.x6.net18 0.01281f
C3109 dc_inst.x1.net4 dc_inst.x4.x1/a_27_47# 0
C3110 _20_/a_79_21# dc_inst.x1.net7 0
C3111 dc_inst.x5.net19 dc_inst.x7.x10/a_27_47# 0.00625f
C3112 _25_/a_761_289# _00_ 0.04549f
C3113 dc_inst.x5.net13 dc_inst.x5.net15 0
C3114 dc_inst.x6.x9/a_27_47# dc_inst.x5.net7 0
C3115 dc_inst.x1.net16 dc_inst.net1 0
C3116 clkload0/a_27_47# clkbuf_1_1__f_clk/a_110_47# 0.02166f
C3117 dc_inst.x7.x15/a_27_47# dc_inst.x9/a_27_47# 0
C3118 tdo dc_inst.x6.net17 0.14197f
C3119 dc_inst.x5.x5/a_27_47# dc_inst.x2.x6/a_27_47# 0
C3120 dc_inst.x5.net18 dc_inst.x7.x8/a_27_47# 0
C3121 path[6] dc_inst.x3.net11 0.00212f
C3122 VPWR dc_inst.x9/a_757_363# -0.01426f
C3123 dc_inst.x6.net9 dc_inst.net4 0
C3124 dc_inst.x5.net3 dc_inst.x4.net8 0
C3125 capture_d dc_inst.x6.net14 0
C3126 dc_inst.net5 dc_inst.net4 0.04243f
C3127 dc_inst.x7.net3 dc_inst.net3 0
C3128 dc_inst.x6.net18 dc_inst.x4.net6 0
C3129 dc_inst.x2.x14/a_27_47# dc_inst.x2.net2 0
C3130 dc_inst.x6.net4 dc_inst.x9/a_193_413# 0
C3131 dc_inst.x1.net2 dc_inst.x1.net7 0.00106f
C3132 _23_/a_543_47# dc_inst.x8/a_750_97# 0
C3133 _23_/a_1283_21# dc_inst.x8/a_757_363# 0
C3134 dc_inst.x7.net13 dc_inst.x9/a_834_97# 0
C3135 dc_inst.x3.x1/a_27_47# dc_inst.x3.net16 0.03591f
C3136 path_sel[2] dc_inst.x9/a_757_363# 0
C3137 dc_inst.x9/a_750_97# dc_inst.x6.net19 0
C3138 _24_/a_27_47# clkload0/X 0
C3139 dc_inst.x4.net16 dc_inst.net4 0.01325f
C3140 dc_inst.x1.net18 dc_inst.x2.x1/a_27_47# 0.0073f
C3141 dc_inst.x5.net7 dc_inst.x2.net13 0
C3142 dc_inst.x6.net6 dc_inst.x6.net14 0
C3143 dc_inst.x5.x9/a_27_47# dc_inst.x5.net1 0.02523f
C3144 dc_inst.x2.x12/a_27_47# path_sel[0] 0
C3145 tdo dc_inst.x4.net6 0.02102f
C3146 dc_inst.x4.x4/a_27_47# dc_inst.x2.x3/a_27_47# 0
C3147 dc_inst.x2.x5/a_27_47# dc_inst.x5.net6 0.00722f
C3148 dc_inst.x3.net4 _15_/a_288_47# 0
C3149 capture_d dc_inst.net9 0.00337f
C3150 dc_inst.net8 dc_inst.net7 0
C3151 dc_inst.x7.x2/a_27_47# dc_inst.x7.net19 0.0428f
C3152 dc_inst.x4.net17 dc_inst.x4.net11 0
C3153 dc_inst.x1.net15 dc_inst.x1.net7 0
C3154 dc_inst.in dc_inst.x4.net5 0
C3155 dc_inst.x5.net8 dc_inst.x5.net9 0.23256f
C3156 dc_inst.x4.net9 dc_inst.x4.net19 0
C3157 dc_inst.x9/a_750_97# dc_inst.x6.net11 0
C3158 _25_/a_543_47# clkbuf_1_0__f_clk/a_110_47# 0.00856f
C3159 _25_/a_27_47# clknet_0_clk 0.01994f
C3160 _13_/a_112_47# dc_inst.x3.net18 0
C3161 dc_inst.x1.net5 path_sel[1] 0.04464f
C3162 dc_inst.in dc_inst.x1.net8 0.02782f
C3163 dc_inst.x1.net6 path[0] 0
C3164 VPWR dc_inst.x3.x7/a_27_47# -0.01106f
C3165 dc_inst.x5.x18/a_27_47# dc_inst.x5.net2 0
C3166 _14_/a_439_47# path[6] 0
C3167 _14_/a_505_21# path[5] 0.00215f
C3168 _14_/a_535_374# path[7] 0
C3169 _25_/a_639_47# tdo 0
C3170 dc_inst.x3.net14 dc_inst.x8/a_1290_413# 0
C3171 dc_inst.x1.x10/a_27_47# path[3] 0
C3172 dc_inst.x6.net19 dc_inst.x6.x14/a_27_47# 0
C3173 dc_inst.x7.net6 dc_inst.x7.x7/a_27_47# 0.0033f
C3174 dc_inst.x5.net14 dc_inst.x5.net12 0.00373f
C3175 dc_inst.x2.x16/a_27_47# dc_inst.x2.x5/a_27_47# 0
C3176 dc_inst.x1.net12 dc_inst.x1.x14/a_27_47# 0
C3177 dc_inst.x9/a_247_21# dc_inst.x7.x6/a_27_47# 0
C3178 _13_/a_470_47# path[6] 0.01322f
C3179 dc_inst.x7.x13/a_27_47# dc_inst.x6.net2 -0
C3180 dc_inst.x5.x13/a_27_47# dc_inst.x5.net12 0.01693f
C3181 path_sel[1] dc_inst.x2.x15/a_27_47# 0.00273f
C3182 dc_inst.x4.x17/a_27_47# dc_inst.x4.x12/a_27_47# 0
C3183 path[4] dc_inst.x3.net14 0
C3184 dc_inst.x5.x15/a_27_47# dc_inst.x6.net8 0
C3185 dc_inst.x1.net15 dc_inst.x1.net17 0
C3186 dc_inst.x4.x10/a_27_47# dc_inst.x5.net8 0
C3187 dc_inst.x6.net11 dc_inst.x6.x14/a_27_47# 0.00332f
C3188 dc_inst.x1.x3/a_27_47# VPWR -0.00292f
C3189 dc_inst.x1.net13 dc_inst.x1.x15/a_27_47# 0.00124f
C3190 _20_/a_470_297# _20_/a_384_47# -0
C3191 dc_inst.net5 dc_inst.x7.x10/a_27_47# 0.03054f
C3192 dc_inst.x5.x3/a_27_47# dc_inst.x5.net8 0
C3193 dc_inst.x7.x3/a_27_47# VPWR 0.01783f
C3194 tdo dc_inst.x6.net18 0.04837f
C3195 path_sel[0] _15_/a_1279_413# 0.00102f
C3196 dc_inst.x7.x5/a_27_47# dc_inst.x7.net6 0.00216f
C3197 _25_/a_1108_47# dc_inst.x9/a_1290_413# 0
C3198 _25_/a_1283_21# dc_inst.x9/a_1478_413# 0
C3199 _25_/a_193_47# dc_inst.x9/a_668_97# 0
C3200 _24_/a_27_47# dc_inst.net9 0.00101f
C3201 _25_/a_1217_47# clknet_0_clk 0
C3202 tdi path[5] 0.00172f
C3203 dc_inst.x6.net16 dc_inst.x6.net14 0
C3204 dc_inst.x5.x15/a_27_47# dc_inst.x6.x6/a_27_47# 0
C3205 dc_inst.x1.net15 dc_inst.x2.net14 0
C3206 dc_inst.x2.net8 path_sel[1] 0.02668f
C3207 dc_inst.x6.net2 dc_inst.x6.x3/a_27_47# 0
C3208 dc_inst.x1.net15 dc_inst.x5.net12 0
C3209 path[6] dc_inst.x3.net15 0.01335f
C3210 dc_inst.x7.net3 _23_/a_543_47# 0
C3211 dc_inst.x7.net12 dc_inst.x7.x12/a_27_47# 0.00377f
C3212 VPWR _15_/a_872_316# 0
C3213 dc_inst.x5.net9 dc_inst.x5.net10 0.16917f
C3214 dc_inst.net8 dc_inst.x8/a_1290_413# 0.04316f
C3215 capture_d dc_inst.x8/a_193_47# 0
C3216 VPWR dc_inst.x5.x19/a_27_47# 0.01014f
C3217 dc_inst.x1.x2/a_27_47# dc_inst.x1.net11 0
C3218 dc_inst.x1.net3 dc_inst.x1.x11/a_27_47# 0
C3219 dc_inst.x7.net1 dc_inst.x7.net10 0.02482f
C3220 dc_inst.x1.x16/a_27_47# dc_inst.x8/a_247_21# 0
C3221 dc_inst.x9/a_1478_413# dc_inst.net1 0.0228f
C3222 dc_inst.x5.net7 path_sel[0] 0.00188f
C3223 dc_inst.x1.net4 dc_inst.x3.net13 0
C3224 dc_inst.x7.net2 dc_inst.x6.net19 0.04865f
C3225 dc_inst.x3.net17 dc_inst.x3.x10/a_27_47# 0
C3226 _02_ dc_inst.x3.x7/a_27_47# 0
C3227 clknet_1_0__leaf_clk dc_inst.x6.net18 0
C3228 dc_inst.x6.net8 dc_inst.x5.x6/a_27_47# 0
C3229 dc_inst.x5.x19/a_27_47# path_sel[2] 0.00585f
C3230 dc_inst.x1.net5 path[3] 0
C3231 dc_inst.net8 path[4] 0
C3232 dc_inst.x6.net2 dc_inst.x6.net11 0.00264f
C3233 path_sel[0] path[5] 0.1188f
C3234 dc_inst.x4.net13 dc_inst.x4.x9/a_27_47# 0.00514f
C3235 dc_inst.x2.x11/a_27_47# dc_inst.x2.x13/a_27_47# 0
C3236 dc_inst.x1.net13 dc_inst.net3 0
C3237 _25_/a_1283_21# dc_inst.net7 0
C3238 tdo dc_inst.x9/a_277_47# 0.00354f
C3239 _25_/a_761_289# delay_sel[1] 0
C3240 dc_inst.x2.net11 dc_inst.x2.net15 0
C3241 tdo clknet_1_0__leaf_clk 0.00744f
C3242 clknet_1_1__leaf_clk delay_sel[0] 0
C3243 dc_inst.x7.net3 dc_inst.x7.x17/a_27_47# 0
C3244 dc_inst.x7.x2/a_27_47# dc_inst.x7.net17 0.00184f
C3245 dc_inst.x2.x6/a_27_47# path_sel[1] 0.00338f
C3246 VPWR dc_inst.x8/a_923_363# -0
C3247 dc_inst.x1.net15 dc_inst.x2.x8/a_27_47# 0
C3248 dc_inst.x7.net2 dc_inst.x6.net11 0
C3249 dc_inst.net6 dc_inst.x6.x19/a_27_47# 0
C3250 dc_inst.x6.x5/a_27_47# dc_inst.x7.x4/a_27_47# 0
C3251 dc_inst.x3.net7 dc_inst.x3.x18/a_27_47# 0.12258f
C3252 dc_inst.x3.x6/a_27_47# dc_inst.x3.net18 0.00149f
C3253 dc_inst.x4.net3 dc_inst.net3 0
C3254 dc_inst.x2.net13 dc_inst.x5.net11 0.00116f
C3255 dc_inst.x3.x2/a_27_47# dc_inst.x3.x5/a_27_47# 0
C3256 dc_inst.in dc_inst.x6.x15/a_27_47# 0
C3257 dc_inst.x4.x9/a_27_47# dc_inst.x4.x5/a_27_47# 0
C3258 dc_inst.x5.net8 dc_inst.x4.net7 0
C3259 VPWR dc_inst.x5.net6 0.69274f
C3260 path_sel[2] dc_inst.x8/a_923_363# 0
C3261 clknet_0_clk dc_inst.in 0
C3262 dc_inst.x1.net10 dc_inst.x2.net6 0
C3263 dc_inst.x6.net6 dc_inst.x6.net13 0.00286f
C3264 dc_inst.x1.net17 delay_sel[0] 0
C3265 delay_sel[1] dc_inst.x7.net6 0
C3266 dc_inst.x7.net3 dc_inst.x10/a_505_21# 0.0459f
C3267 VPWR path[7] 0.20276f
C3268 rst dc_inst.x9/a_1478_413# 0
C3269 dc_inst.x4.x14/a_27_47# dc_inst.x4.net1 0
C3270 dc_inst.x5.net6 path_sel[2] 0.00829f
C3271 dc_inst.x1.net18 dc_inst.x6.x14/a_27_47# 0
C3272 dc_inst.x6.x4/a_27_47# dc_inst.x7.net4 0
C3273 dc_inst.x3.net6 path[6] 0.00232f
C3274 path_sel[2] path[7] 0.00128f
C3275 dc_inst.net3 _23_/a_193_47# 0.00125f
C3276 dc_inst.x6.net6 dc_inst.x6.net12 0
C3277 dc_inst.x1.net19 dc_inst.x4.net7 0
C3278 dc_inst.x3.net11 dc_inst.x3.x10/a_27_47# 0.01938f
C3279 dc_inst.x3.x12/a_27_47# dc_inst.x3.net10 0.00194f
C3280 dc_inst.x7.net4 _23_/a_1283_21# 0.00196f
C3281 path_sel[1] dc_inst.x4.net19 0.04138f
C3282 dc_inst.x9/a_27_413# dc_inst.x9/a_750_97# -0
C3283 dc_inst.x4.net11 dc_inst.x4.x9/a_27_47# 0.00152f
C3284 dc_inst.x4.x11/a_27_47# dc_inst.x4.net10 0.0022f
C3285 clknet_0_clk dc_inst.x9/a_757_363# 0
C3286 dc_inst.x1.x14/a_27_47# dc_inst.in 0.00178f
C3287 VPWR dc_inst.x2.x16/a_27_47# 0.00253f
C3288 clkload0/a_27_47# clkload0/X 0
C3289 dc_inst.x5.net10 dc_inst.x5.net1 0.23149f
C3290 dc_inst.x2.net12 dc_inst.x2.x14/a_27_47# 0.03467f
C3291 dc_inst.x2.x12/a_27_47# dc_inst.x5.net12 0.0029f
C3292 dc_inst.x1.x4/a_27_47# path_sel[0] 0
C3293 dc_inst.net3 dc_inst.x2.net19 0.00532f
C3294 path_sel[1] dc_inst.x5.x2/a_27_47# 0.00491f
C3295 dc_inst.x2.x16/a_27_47# path_sel[2] 0.01151f
C3296 dc_inst.x2.net18 dc_inst.x2.x20/a_27_47# 0.04326f
C3297 dc_inst.x4.x20/a_27_47# dc_inst.x5.x1/a_27_47# 0.01191f
C3298 dc_inst.x5.net15 dc_inst.x5.x19/a_27_47# 0
C3299 dc_inst.x6.x4/a_27_47# dc_inst.net4 0.00584f
C3300 dc_inst.x6.net3 dc_inst.x7.net7 0.01044f
C3301 dc_inst.x3.net5 shadow_q 0.0057f
C3302 dc_inst.x6.net11 dc_inst.x6.x13/a_27_47# 0.00135f
C3303 dc_inst.x1.net19 dc_inst.x2.net17 0
C3304 dc_inst.x3.x4/a_27_47# path_sel[0] 0
C3305 _17_/a_478_47# path[1] 0
C3306 rst dc_inst.net7 0.00734f
C3307 dc_inst.x5.net6 dc_inst.x4.net5 0.27167f
C3308 dc_inst.x2.net7 dc_inst.x2.net11 0
C3309 dc_inst.x2.x7/a_27_47# dc_inst.x2.net8 0.04368f
C3310 dc_inst.x6.net6 path_sel[1] 0.03384f
C3311 dc_inst.x1.net15 dc_inst.x2.x17/a_27_47# 0.04722f
C3312 dc_inst.x5.net19 dc_inst.x7.net6 0.04343f
C3313 VPWR dc_inst.x3.x1/a_27_47# 0.00992f
C3314 clknet_1_1__leaf_clk dc_inst.x8/a_750_97# 0
C3315 dc_inst.x6.net11 dc_inst.x6.x12/a_27_47# 0.01776f
C3316 dc_inst.x1.net19 dc_inst.x4.net4 0.01113f
C3317 dc_inst.x7.net3 dc_inst.x7.net14 0
C3318 dc_inst.x9/a_750_97# dc_inst.x7.net16 0
C3319 dc_inst.x9/a_757_363# dc_inst.x9/a_834_97# -0.00174f
C3320 dc_inst.x7.x16/a_27_47# dc_inst.x7.net16 0.03582f
C3321 clkbuf_1_0__f_clk/a_110_47# dc_inst.net7 0.00179f
C3322 VPWR _17_/a_478_47# -0
C3323 dc_inst.x6.net16 dc_inst.x6.net13 0.01298f
C3324 dc_inst.x1.net13 dc_inst.x2.net13 0
C3325 dc_inst.x3.net14 dc_inst.x3.net1 0.02442f
C3326 dc_inst.x3.x2/a_27_47# dc_inst.x3.net3 0.00213f
C3327 dc_inst.net8 dc_inst.x2.x20/a_27_47# 0
C3328 dc_inst.x4.x3/a_27_47# dc_inst.x1.net15 0
C3329 VPWR dc_inst.x7.net10 0.10272f
C3330 dc_inst.x1.net15 delay_sel[1] 0
C3331 dc_inst.x2.x16/a_27_47# dc_inst.x4.net5 0.00377f
C3332 _02_ path[7] 0.01765f
C3333 dc_inst.x5.net9 dc_inst.x4.net10 0
C3334 dc_inst.x5.net6 dc_inst.x2.net2 0.13789f
C3335 dc_inst.x5.net7 dc_inst.x5.x8/a_27_47# 0.00331f
C3336 dc_inst.x5.x7/a_27_47# dc_inst.x5.net8 0.01298f
C3337 dc_inst.x4.net15 path_sel[1] 0.00602f
C3338 dc_inst.x5.net11 path_sel[0] 0
C3339 dc_inst.x1.net17 dc_inst.x5.net7 0
C3340 _19_/a_109_297# path_sel[1] 0.00916f
C3341 _19_/a_27_47# _08_ 0.02116f
C3342 dc_inst.x4.net16 dc_inst.x4.net12 0.02276f
C3343 _18_/a_76_199# _16_/a_229_47# 0
C3344 _18_/a_505_21# _16_/a_27_93# 0
C3345 path_sel[2] dc_inst.x7.net10 0.00341f
C3346 dc_inst.x5.net14 dc_inst.x5.net19 0
C3347 VPWR dc_inst.x1.x10/a_27_47# 0.01655f
C3348 dc_inst.x2.net17 dc_inst.x1.net11 0
C3349 dc_inst.x5.x15/a_27_47# dc_inst.x5.net16 0.00356f
C3350 dc_inst.x6.net16 dc_inst.x6.net12 0
C3351 delay_sel[0] dc_inst.x7.x5/a_27_47# 0.00932f
C3352 clkload0/a_27_47# dc_inst.net9 0
C3353 _15_/a_372_413# dc_inst.in 0
C3354 dc_inst.x3.x5/a_27_47# dc_inst.x3.x19/a_27_47# 0
C3355 dc_inst.x2.net6 dc_inst.x2.net4 0
C3356 dc_inst.x1.x10/a_27_47# path_sel[2] 0.00221f
C3357 path_sel[1] dc_inst.x6.x11/a_27_47# 0.00188f
C3358 dc_inst.x4.x12/a_27_47# dc_inst.x4.net10 0
C3359 _23_/a_193_47# _23_/a_543_47# 0
C3360 dc_inst.x6.x6/a_27_47# dc_inst.x5.x1/a_27_47# 0
C3361 dc_inst.x7.net3 _24_/a_1283_21# 0
C3362 tdo dc_inst.x8/a_247_21# 0
C3363 dc_inst.x1.net2 _15_/a_1281_47# 0
C3364 _01_ dc_inst.x3.x19/a_27_47# 0
C3365 _24_/a_1462_47# dc_inst.net2 0
C3366 dc_inst.x1.net4 _10_ 0
C3367 dc_inst.x3.x15/a_27_47# dc_inst.x3.net1 0
C3368 _05_ dc_inst.x3.net1 0
C3369 dc_inst.x9/a_1290_413# delay_sel[1] 0.08669f
C3370 dc_inst.x9/a_27_47# dc_inst.net7 0
C3371 dc_inst.x3.x12/a_27_47# dc_inst.x3.net13 0.03413f
C3372 dc_inst.x9/a_750_97# dc_inst.net9 0
C3373 dc_inst.x4.x10/a_27_47# dc_inst.x4.net10 0.05174f
C3374 dc_inst.x3.x9/a_27_47# dc_inst.x3.net10 0.0127f
C3375 dc_inst.x3.x5/a_27_47# dc_inst.x3.net18 0.01149f
C3376 tdo dc_inst.x5.net5 0
C3377 dc_inst.x1.x16/a_27_47# dc_inst.x2.net5 0
C3378 dc_inst.x1.net4 dc_inst.x1.x7/a_27_47# 0
C3379 dc_inst.x1.x4/a_27_47# dc_inst.x1.net7 0
C3380 dc_inst.x5.net7 dc_inst.x2.net14 0.0018f
C3381 _19_/a_193_297# _18_/a_76_199# 0
C3382 dc_inst.x7.x1/a_27_47# dc_inst.x9/a_757_363# 0
C3383 dc_inst.net6 dc_inst.x9/a_247_21# -0
C3384 dc_inst.x3.net4 dc_inst.x3.net16 0.00242f
C3385 delay_sel[1] dc_inst.x3.net19 0.00109f
C3386 dc_inst.x5.net7 dc_inst.x5.net12 0
C3387 dc_inst.in dc_inst.x8/a_27_413# 0.01008f
C3388 dc_inst.x3.net5 dc_inst.x3.net7 0.01651f
C3389 dc_inst.x3.x2/a_27_47# _15_/a_288_47# 0
C3390 capture_d dc_inst.x3.net16 0
C3391 dc_inst.x5.x6/a_27_47# dc_inst.x4.net6 0.03013f
C3392 dc_inst.net8 dc_inst.x3.x17/a_27_47# 0
C3393 dc_inst.x2.net17 dc_inst.x1.x20/a_27_47# 0
C3394 _01_ dc_inst.x3.net18 0
C3395 dc_inst.net4 dc_inst.x5.net3 0
C3396 dc_inst.x6.net10 dc_inst.x4.net19 0.00304f
C3397 dc_inst.x4.net16 dc_inst.x4.net1 0.00321f
C3398 dc_inst.x6.x14/a_27_47# dc_inst.x6.net14 0.00201f
C3399 _09_ path_sel[0] 0.00685f
C3400 path[2] _16_/a_229_47# 0
C3401 path[3] _16_/a_27_93# 0
C3402 dc_inst.x6.net9 dc_inst.x7.net6 0
C3403 dc_inst.x1.net18 dc_inst.x6.x13/a_27_47# 0
C3404 dc_inst.x7.x13/a_27_47# dc_inst.net4 0
C3405 dc_inst.net5 dc_inst.x7.net6 0.14064f
C3406 _02_ dc_inst.x3.x1/a_27_47# 0
C3407 dc_inst.x5.net18 dc_inst.x7.net8 0
C3408 dc_inst.x1.net6 path_sel[0] 0.03547f
C3409 path[4] _20_/a_384_47# 0.00137f
C3410 dc_inst.x1.net3 dc_inst.x8/a_1290_413# 0
C3411 _10_ dc_inst.x1.net9 0
C3412 dc_inst.x4.x1/a_27_47# dc_inst.x6.net19 0
C3413 dc_inst.x3.x13/a_27_47# dc_inst.x3.net16 0
C3414 dc_inst.x1.x9/a_27_47# dc_inst.x1.net7 0.00182f
C3415 dc_inst.x1.net9 dc_inst.x1.x7/a_27_47# 0.00205f
C3416 _04_ _10_ 0.0666f
C3417 dc_inst.x4.net4 dc_inst.x1.x20/a_27_47# 0
C3418 dc_inst.x1.net14 _15_/a_288_47# 0
C3419 dc_inst.x9/a_277_47# dc_inst.x8/a_247_21# 0
C3420 dc_inst.x7.x15/a_27_47# dc_inst.x7.x19/a_27_47# 0
C3421 dc_inst.x6.net19 dc_inst.x7.net4 0.05767f
C3422 dc_inst.x1.net18 dc_inst.x6.x12/a_27_47# 0
C3423 dc_inst.x10/a_505_21# _23_/a_193_47# 0
C3424 dc_inst.x5.net7 dc_inst.x2.x8/a_27_47# 0
C3425 dc_inst.x7.net3 clknet_1_1__leaf_clk 0
C3426 dc_inst.x7.x12/a_27_47# clknet_1_0__leaf_clk 0.03745f
C3427 dc_inst.x5.net6 dc_inst.x6.x15/a_27_47# 0
C3428 dc_inst.x1.net3 path[4] 0.00606f
C3429 dc_inst.x4.x20/a_27_47# dc_inst.x4.net18 0
C3430 delay_sel[0] delay_sel[1] 0.48709f
C3431 dc_inst.x7.net12 dc_inst.x7.net19 0.00567f
C3432 _19_/a_193_297# path[2] 0.00103f
C3433 dc_inst.x6.net6 dc_inst.x6.net10 0.03245f
C3434 dc_inst.x1.net5 VPWR 0.51133f
C3435 _10_ _18_/a_76_199# 0
C3436 dc_inst.x3.net6 dc_inst.x3.x10/a_27_47# 0.03054f
C3437 _24_/a_761_289# dc_inst.net3 0
C3438 dc_inst.x7.net2 dc_inst.x7.net16 0
C3439 dc_inst.in dc_inst.x8/a_668_97# 0
C3440 dc_inst.x6.net11 dc_inst.x7.net4 0
C3441 dc_inst.x1.net16 dc_inst.x1.x15/a_27_47# 0
C3442 _14_/a_505_21# se 0.00766f
C3443 dc_inst.x1.net5 path_sel[2] 0.09056f
C3444 dc_inst.x6.x3/a_27_47# dc_inst.net4 0.00318f
C3445 path_sel[1] dc_inst.x2.x1/a_27_47# 0.00186f
C3446 dc_inst.x1.net17 dc_inst.x1.x9/a_27_47# 0
C3447 dc_inst.x3.net3 dc_inst.x3.x19/a_27_47# 0
C3448 dc_inst.x2.x10/a_27_47# dc_inst.x2.net1 0.04368f
C3449 dc_inst.x6.net19 dc_inst.net4 0
C3450 VPWR dc_inst.x2.x15/a_27_47# 0.02173f
C3451 dc_inst.x3.x7/a_27_47# dc_inst.x3.x18/a_27_47# 0
C3452 dc_inst.x1.x20/a_27_47# dc_inst.x8/a_277_47# 0
C3453 _14_/a_76_199# _05_ 0.01254f
C3454 dc_inst.x1.net2 dc_inst.net2 0
C3455 dc_inst.x6.net7 dc_inst.x6.x9/a_27_47# 0.0017f
C3456 dc_inst.x1.net16 dc_inst.x2.x4/a_27_47# 0
C3457 dc_inst.x6.net2 dc_inst.x6.net14 0
C3458 dc_inst.x4.net9 dc_inst.x4.net8 0.12312f
C3459 dc_inst.x4.net10 dc_inst.x4.net7 0
C3460 tdo dc_inst.x5.x6/a_27_47# 0.00331f
C3461 dc_inst.x4.x19/a_27_47# dc_inst.x4.net19 0.00318f
C3462 dc_inst.x4.net15 dc_inst.x6.net10 0
C3463 path_sel[2] dc_inst.x2.x15/a_27_47# 0.00525f
C3464 dc_inst.x9/a_1290_413# dc_inst.x8/a_27_47# 0
C3465 _23_/a_448_47# shadow_q 0
C3466 delay_sel[2] _23_/a_543_47# 0.00856f
C3467 capture_d _23_/a_1108_47# 0
C3468 dc_inst.x3.net2 dc_inst.x8/a_1290_413# 0.00282f
C3469 dc_inst.x3.net3 dc_inst.x3.net18 0
C3470 dc_inst.x5.net6 dc_inst.x4.x7/a_27_47# 0
C3471 dc_inst.x7.net2 dc_inst.x6.net14 0
C3472 dc_inst.x1.net15 dc_inst.x2.net16 0.10728f
C3473 dc_inst.x6.net11 dc_inst.net4 0.11222f
C3474 dc_inst.x7.net1 dc_inst.x7.net18 0.02798f
C3475 dc_inst.x4.net2 VPWR 0.15434f
C3476 dc_inst.x3.net9 path[4] 0
C3477 dc_inst.x1.net15 dc_inst.net2 0
C3478 dc_inst.x2.net10 dc_inst.x5.x12/a_27_47# 0.01152f
C3479 dc_inst.x6.x7/a_27_47# dc_inst.x5.net2 0
C3480 dc_inst.x2.x20/a_27_47# dc_inst.net1 0
C3481 _05_ dc_inst.x3.net14 0
C3482 dc_inst.x3.net14 dc_inst.x3.x15/a_27_47# 0.02209f
C3483 dc_inst.x4.net2 path_sel[2] 0.00485f
C3484 dc_inst.x3.x9/a_27_47# dc_inst.x3.net13 0.12068f
C3485 dc_inst.x1.x3/a_27_47# dc_inst.x3.x18/a_27_47# 0.01254f
C3486 dc_inst.x1.net4 dc_inst.x1.net2 0.03375f
C3487 _10_ path[2] 0.00151f
C3488 dc_inst.x7.net2 dc_inst.net9 0
C3489 dc_inst.x6.net10 dc_inst.x6.x11/a_27_47# 0.1338f
C3490 dc_inst.x2.net14 dc_inst.x1.x9/a_27_47# 0.00484f
C3491 _23_/a_805_47# _03_ 0
C3492 dc_inst.x4.net17 dc_inst.x4.x16/a_27_47# 0.00669f
C3493 dc_inst.x5.net12 dc_inst.x1.x9/a_27_47# 0
C3494 dc_inst.x3.net2 path[4] 0
C3495 _13_/a_27_297# dc_inst.x3.net4 0
C3496 _09_ dc_inst.x1.net7 0.00208f
C3497 dc_inst.x5.net19 delay_sel[0] 0
C3498 dc_inst.x2.net19 path_sel[0] 0.00107f
C3499 se tdi 0.08567f
C3500 dc_inst.x4.net14 dc_inst.x4.x20/a_27_47# 0
C3501 VPWR dc_inst.x2.net8 0.00856f
C3502 delay_sel[2] dc_inst.x7.x17/a_27_47# 0
C3503 dc_inst.x1.net5 dc_inst.x1.net8 0.00402f
C3504 dc_inst.x1.net6 dc_inst.x1.net7 0.08005f
C3505 _04_ _20_/a_79_21# 0.05999f
C3506 dc_inst.x6.x6/a_27_47# dc_inst.x4.net18 0.01151f
C3507 dc_inst.x6.net6 dc_inst.x4.x19/a_27_47# 0.01149f
C3508 dc_inst.x4.net2 dc_inst.x6.net15 0
C3509 dc_inst.x1.net16 dc_inst.net3 0.00215f
C3510 dc_inst.x1.net4 dc_inst.x1.net15 0
C3511 dc_inst.x2.net8 path_sel[2] 0
C3512 dc_inst.x7.net12 dc_inst.x7.x8/a_27_47# 0
C3513 dc_inst.x3.x3/a_27_47# dc_inst.x3.net4 0.03666f
C3514 dc_inst.x1.net2 dc_inst.x1.net9 0
C3515 dc_inst.x2.x15/a_27_47# dc_inst.x4.net5 0
C3516 dc_inst.x5.net11 dc_inst.x2.net14 0
C3517 dc_inst.x4.x3/a_27_47# dc_inst.x8/a_750_97# 0
C3518 dc_inst.x9/a_193_413# dc_inst.x7.net10 0
C3519 dc_inst.x5.net1 _17_/a_174_21# 0
C3520 dc_inst.x5.net11 dc_inst.x5.net12 0.07593f
C3521 dc_inst.x7.x18/a_27_47# dc_inst.x7.net18 0.00204f
C3522 dc_inst.x7.x10/a_27_47# dc_inst.x6.net19 0
C3523 delay_sel[1] dc_inst.x8/a_750_97# 0.22633f
C3524 dc_inst.x1.net2 dc_inst.x1.net1 0
C3525 capture_d dc_inst.x7.x18/a_27_47# 0
C3526 tdo dc_inst.x5.x4/a_27_47# 0
C3527 dc_inst.x5.net6 dc_inst.x2.net12 0.01534f
C3528 dc_inst.x2.x15/a_27_47# dc_inst.x1.net8 0
C3529 dc_inst.x1.net2 _04_ 0.00119f
C3530 dc_inst.x10/a_535_374# capture_d 0
C3531 dc_inst.x10/a_505_21# delay_sel[2] 0.0535f
C3532 dc_inst.x10/a_76_199# dc_inst.net8 0.00299f
C3533 _18_/a_76_199# _20_/a_79_21# 0
C3534 dc_inst.x3.net8 path[5] 0.0178f
C3535 dc_inst.x3.net19 dc_inst.net2 0
C3536 dc_inst.net8 dc_inst.x2.net18 0
C3537 dc_inst.x1.net13 dc_inst.x1.net7 0.00382f
C3538 dc_inst.x1.net18 dc_inst.x7.net4 0
C3539 dc_inst.x4.net2 dc_inst.x4.net5 0.02578f
C3540 VPWR dc_inst.x2.x6/a_27_47# -0.00287f
C3541 dc_inst.x6.net13 dc_inst.x6.x14/a_27_47# 0.03794f
C3542 dc_inst.x6.x13/a_27_47# dc_inst.x6.net14 0.02478f
C3543 _24_/a_193_47# _23_/a_1283_21# 0.0064f
C3544 _24_/a_761_289# _23_/a_543_47# 0.00631f
C3545 _24_/a_27_47# _23_/a_1108_47# 0
C3546 _24_/a_543_47# _23_/a_761_289# 0
C3547 dc_inst.x4.x15/a_27_47# dc_inst.x4.net19 0.11159f
C3548 dc_inst.x4.net15 dc_inst.x4.x19/a_27_47# 0.00119f
C3549 dc_inst.x1.net15 dc_inst.x1.net9 0.02472f
C3550 path[5] delay_sel[1] 0
C3551 dc_inst.x7.net12 dc_inst.x7.net17 0
C3552 dc_inst.x4.net2 dc_inst.x1.net8 0
C3553 capture_d _03_ 0.00374f
C3554 dc_inst.x3.x6/a_27_47# dc_inst.x3.net13 0.00878f
C3555 dc_inst.x3.net6 dc_inst.x3.x14/a_27_47# 0.00155f
C3556 dc_inst.x1.net10 dc_inst.x2.net10 0
C3557 _25_/a_761_289# clkbuf_0_clk/a_110_47# 0.00994f
C3558 _15_/a_27_47# path[4] 0.01483f
C3559 _15_/a_600_345# path[6] 0.00143f
C3560 VPWR _23_/a_805_47# 0.00258f
C3561 dc_inst.x1.net4 dc_inst.x3.net19 0.07622f
C3562 dc_inst.x2.net3 dc_inst.x2.x3/a_27_47# 0.12862f
C3563 dc_inst.x1.x5/a_27_47# dc_inst.x1.x2/a_27_47# 0
C3564 dc_inst.x5.net1 dc_inst.x5.x11/a_27_47# 0.02031f
C3565 dc_inst.x6.x12/a_27_47# dc_inst.x6.net14 0
C3566 dc_inst.x6.net12 dc_inst.x6.x14/a_27_47# 0.14849f
C3567 capture_q dc_inst.x3.net17 0
C3568 dc_inst.x8/a_193_413# dc_inst.x8/a_277_47# -0.00148f
C3569 dc_inst.x2.net8 dc_inst.x4.net5 0
C3570 dc_inst.x5.x7/a_27_47# dc_inst.x4.net10 0.01107f
C3571 _24_/a_193_47# _13_/a_112_47# 0
C3572 _01_ dc_inst.x7.net4 0.06485f
C3573 dc_inst.x6.net12 dc_inst.x4.net8 0
C3574 dc_inst.x3.x2/a_27_47# path_sel[1] 0.00432f
C3575 dc_inst.x1.net18 dc_inst.net4 0
C3576 delay_sel[0] dc_inst.net2 0
C3577 dc_inst.x6.net10 dc_inst.x2.x1/a_27_47# 0
C3578 _09_ dc_inst.x5.net12 0
C3579 dc_inst.x4.x15/a_27_47# dc_inst.x6.net6 0.0015f
C3580 VPWR dc_inst.x4.net19 0.17011f
C3581 path[2] _20_/a_79_21# 0
C3582 dc_inst.x6.x1/a_27_47# delay_sel[1] 0
C3583 dc_inst.net5 delay_sel[0] 0.08056f
C3584 dc_inst.x4.net13 dc_inst.x2.net6 0
C3585 _16_/a_27_93# path[1] 0.02047f
C3586 dc_inst.x4.net12 dc_inst.x2.net7 0
C3587 rst dc_inst.x3.x17/a_27_47# 0
C3588 _20_/a_384_47# dc_inst.x3.net1 0
C3589 _13_/a_470_297# dc_inst.x3.net7 0
C3590 dc_inst.x5.net19 dc_inst.x5.net7 0
C3591 dc_inst.x6.net7 path_sel[0] 0
C3592 path_sel[2] dc_inst.x4.net19 0.00128f
C3593 clkbuf_1_0__f_clk/a_110_47# dc_inst.x7.net5 0
C3594 clknet_1_1__leaf_clk _23_/a_193_47# 0
C3595 rst dc_inst.x3.net1 0.01237f
C3596 _13_/a_27_297# dc_inst.x3.x8/a_27_47# 0
C3597 VPWR dc_inst.x5.x2/a_27_47# 0.07214f
C3598 _25_/a_193_47# dc_inst.x7.net1 0.03814f
C3599 dc_inst.x1.net4 delay_sel[0] 0
C3600 dc_inst.x6.x4/a_27_47# dc_inst.x7.net6 0.00132f
C3601 dc_inst.x1.net14 path_sel[1] 0.03436f
C3602 dc_inst.x6.net18 dc_inst.x7.net19 0
C3603 VPWR dc_inst.x3.net4 0.00211f
C3604 path_sel[1] dc_inst.x6.x14/a_27_47# 0
C3605 dc_inst.x2.x18/a_27_47# dc_inst.x6.net17 0
C3606 dc_inst.x4.x4/a_27_47# dc_inst.x2.net17 0
C3607 dc_inst.x3.net5 dc_inst.x3.x7/a_27_47# 0.00171f
C3608 VPWR dc_inst.x7.net18 0.6854f
C3609 VPWR capture_d 0.39776f
C3610 VPWR _16_/a_27_93# 0.04319f
C3611 _24_/a_27_47# _03_ 0.0033f
C3612 dc_inst.x4.x15/a_27_47# dc_inst.x4.net15 0.00786f
C3613 dc_inst.x1.net13 dc_inst.x5.net12 0
C3614 tdo dc_inst.x7.net19 0.00598f
C3615 dc_inst.x8/a_1290_413# dc_inst.x8/a_1478_413# -0.00478f
C3616 dc_inst.x8/a_277_47# dc_inst.x8/a_834_97# -0.00465f
C3617 path_sel[1] dc_inst.x4.net8 0.00666f
C3618 dc_inst.x7.net2 dc_inst.x6.net13 0
C3619 dc_inst.x4.net17 dc_inst.x4.x8/a_27_47# 0
C3620 VPWR dc_inst.x6.net6 0.10599f
C3621 dc_inst.x6.net2 dc_inst.x7.x9/a_27_47# 0
C3622 _19_/a_27_47# _07_ 0.00871f
C3623 dc_inst.x7.net3 delay_sel[1] 0.00408f
C3624 dc_inst.x4.net4 dc_inst.x4.x4/a_27_47# 0.02193f
C3625 dc_inst.x7.net14 dc_inst.x7.x15/a_27_47# 0.02816f
C3626 dc_inst.x9/a_27_413# dc_inst.net4 0.00212f
C3627 dc_inst.x6.net6 path_sel[2] 0.01359f
C3628 VPWR dc_inst.x3.x13/a_27_47# -0.01042f
C3629 dc_inst.x2.x10/a_27_47# path_sel[1] 0.01183f
C3630 path[4] dc_inst.x8/a_1478_413# 0
C3631 dc_inst.x4.net1 dc_inst.x2.net7 0.01355f
C3632 dc_inst.x7.net2 dc_inst.x6.net12 0
C3633 dc_inst.net3 dc_inst.x9/a_1478_413# 0
C3634 dc_inst.x6.x7/a_27_47# dc_inst.x7.net7 0
C3635 dc_inst.x2.net6 dc_inst.x2.x2/a_27_47# 0
C3636 dc_inst.x5.net16 dc_inst.x7.x8/a_27_47# 0
C3637 dc_inst.x4.net13 dc_inst.x5.net2 0.00455f
C3638 dc_inst.x4.net12 dc_inst.x5.net3 0
C3639 _00_ _23_/a_193_47# 0
C3640 dc_inst.x7.x3/a_27_47# dc_inst.x3.net5 0
C3641 _24_/a_1283_21# delay_sel[2] 0.00602f
C3642 _24_/a_448_47# capture_d 0.00574f
C3643 dc_inst.x3.net3 dc_inst.x7.net4 0
C3644 VPWR _19_/a_109_297# 0
C3645 dc_inst.x3.x5/a_27_47# _23_/a_27_47# 0
C3646 dc_inst.x4.net15 VPWR 0.02106f
C3647 dc_inst.x1.net15 dc_inst.x2.net15 0.11039f
C3648 dc_inst.x1.x13/a_27_47# dc_inst.x3.x20/a_27_47# 0
C3649 dc_inst.x2.net16 dc_inst.x8/a_750_97# 0
C3650 clknet_1_1__leaf_clk se 0.1203f
C3651 dc_inst.x7.net19 dc_inst.x9/a_277_47# 0
C3652 clknet_1_0__leaf_clk dc_inst.x7.net19 0.00151f
C3653 _25_/a_193_47# _03_ -0.00248f
C3654 dc_inst.x2.x20/a_27_47# _15_/a_27_47# 0
C3655 dc_inst.x3.net9 dc_inst.x3.net1 0.31174f
C3656 dc_inst.x3.net2 dc_inst.x3.x17/a_27_47# 0.1359f
C3657 dc_inst.x7.net9 dc_inst.x7.net7 0
C3658 dc_inst.x3.net17 dc_inst.x3.x20/a_27_47# 0
C3659 dc_inst.x5.net15 dc_inst.x4.net19 0
C3660 rst _23_/a_761_289# 0.00118f
C3661 _01_ _23_/a_27_47# 0.00913f
C3662 dc_inst.x8/a_750_97# dc_inst.net2 0.03874f
C3663 dc_inst.x6.x8/a_27_47# dc_inst.x6.x7/a_27_47# 0
C3664 dc_inst.x6.net2 path_sel[1] 0
C3665 VPWR dc_inst.x6.x11/a_27_47# -0.01017f
C3666 dc_inst.x1.x12/a_27_47# _19_/a_193_297# 0
C3667 dc_inst.x6.net9 dc_inst.x5.net7 0
C3668 _24_/a_27_47# VPWR 0.07211f
C3669 dc_inst.x10/a_76_199# dc_inst.net1 0
C3670 dc_inst.x2.net2 dc_inst.x4.net19 0
C3671 dc_inst.x6.net14 dc_inst.x7.net4 0
C3672 dc_inst.x9/a_668_97# dc_inst.net4 0
C3673 _14_/a_76_199# rst 0.03506f
C3674 dc_inst.x5.x16/a_27_47# dc_inst.x5.net2 0.02896f
C3675 dc_inst.x6.x13/a_27_47# dc_inst.x6.net13 0.01506f
C3676 dc_inst.x10/a_76_199# dc_inst.x6.x18/a_27_47# 0.00121f
C3677 dc_inst.x2.net18 dc_inst.net1 0.00328f
C3678 dc_inst.x1.net11 dc_inst.x2.x13/a_27_47# 0
C3679 _06_ dc_inst.x3.net12 0
C3680 path[5] dc_inst.net2 0
C3681 dc_inst.x4.net16 dc_inst.x5.net7 0.00155f
C3682 path_sel[2] dc_inst.x6.x11/a_27_47# 0.00379f
C3683 dc_inst.x4.net1 dc_inst.x5.net3 0
C3684 dc_inst.x4.net11 dc_inst.x5.net2 0
C3685 dc_inst.x1.net12 _07_ 0.0031f
C3686 dc_inst.x2.net18 dc_inst.x6.x18/a_27_47# 0
C3687 _24_/a_193_47# clkbuf_1_1__f_clk/a_110_47# 0.01452f
C3688 _02_ dc_inst.x3.net4 0
C3689 dc_inst.x3.x19/a_27_47# path_sel[1] 0
C3690 dc_inst.x7.x10/a_27_47# dc_inst.x9/a_27_413# 0
C3691 dc_inst.x1.net4 dc_inst.x8/a_750_97# 0
C3692 _25_/a_1108_47# delay_sel[2] 0
C3693 dc_inst.net9 dc_inst.x7.net4 0.00513f
C3694 clknet_1_1__leaf_clk delay_sel[2] 0.32535f
C3695 _02_ capture_d 0.00491f
C3696 dc_inst.x1.x5/a_27_47# dc_inst.x2.net17 0
C3697 dc_inst.x5.net15 dc_inst.x6.net6 0
C3698 dc_inst.x6.net12 dc_inst.x6.x13/a_27_47# 0.05072f
C3699 dc_inst.x6.x12/a_27_47# dc_inst.x6.net13 0.03174f
C3700 VPWR dc_inst.x6.net16 0.03455f
C3701 VPWR dc_inst.x3.x8/a_27_47# 0.00706f
C3702 rst dc_inst.x3.net14 0
C3703 dc_inst.x3.x6/a_27_47# _10_ 0
C3704 _00_ se 0.33191f
C3705 dc_inst.in _23_/a_448_47# 0.0151f
C3706 dc_inst.x2.net1 dc_inst.x2.net11 0.03371f
C3707 _24_/a_27_47# _24_/a_448_47# -0.00297f
C3708 _24_/a_193_47# _24_/a_1108_47# -0.00656f
C3709 _25_/a_1462_47# _03_ 0
C3710 dc_inst.x1.net4 path[5] 0.0152f
C3711 dc_inst.x3.net18 path_sel[1] 0
C3712 dc_inst.net4 dc_inst.x6.net14 0.00117f
C3713 dc_inst.x6.net16 path_sel[2] 0.00752f
C3714 dc_inst.x6.x16/a_27_47# dc_inst.x6.net16 0.01506f
C3715 dc_inst.x1.net3 dc_inst.x3.net14 0.03769f
C3716 clkload0/X _23_/a_27_47# 0
C3717 tdo dc_inst.x4.net18 0
C3718 dc_inst.x4.net12 dc_inst.x6.net11 0
C3719 _02_ dc_inst.x3.x13/a_27_47# 0.00182f
C3720 dc_inst.x10/a_76_199# rst 0.04748f
C3721 _19_/a_205_47# dc_inst.x1.net7 0
C3722 dc_inst.x3.x12/a_27_47# dc_inst.x3.net19 0
C3723 dc_inst.x5.x4/a_27_47# dc_inst.x5.net5 0.0087f
C3724 dc_inst.x6.x12/a_27_47# dc_inst.x6.net12 0.00883f
C3725 tdo dc_inst.x7.net17 0
C3726 capture_q dc_inst.x3.net15 0.01111f
C3727 dc_inst.x1.x12/a_27_47# _10_ 0.01787f
C3728 _25_/a_193_47# VPWR 0.00104f
C3729 _15_/a_27_47# dc_inst.x3.net1 0
C3730 dc_inst.x3.net5 path[7] 0
C3731 dc_inst.x1.x13/a_27_47# dc_inst.x2.net17 0
C3732 dc_inst.x1.net13 dc_inst.x2.x17/a_27_47# 0.03174f
C3733 dc_inst.x6.x1/a_27_47# dc_inst.net5 0.00956f
C3734 dc_inst.x6.x8/a_27_47# dc_inst.x5.net2 0
C3735 dc_inst.x6.net15 dc_inst.x6.net16 0.03371f
C3736 dc_inst.x7.net12 _25_/a_805_47# 0
C3737 dc_inst.x2.net12 dc_inst.x2.x15/a_27_47# 0.00104f
C3738 dc_inst.x2.x12/a_27_47# dc_inst.x2.net15 0
C3739 dc_inst.x5.net14 dc_inst.x5.net3 0.15253f
C3740 dc_inst.x2.net6 dc_inst.x2.net10 0.00757f
C3741 clkbuf_1_0__f_clk/a_110_47# dc_inst.x7.net9 0
C3742 dc_inst.x4.x2/a_27_47# dc_inst.x2.net17 0
C3743 dc_inst.x5.x13/a_27_47# dc_inst.x5.net3 0.03896f
C3744 dc_inst.x5.net4 dc_inst.x2.net6 0.00332f
C3745 dc_inst.x2.net5 dc_inst.x5.net5 0
C3746 dc_inst.x7.net1 dc_inst.x9/a_750_97# 0
C3747 _05_ rst 0.09197f
C3748 dc_inst.x2.x20/a_27_47# dc_inst.x8/a_1478_413# 0
C3749 path_sel[1] dc_inst.x6.x13/a_27_47# 0
C3750 _00_ delay_sel[2] 0.03686f
C3751 dc_inst.x7.net1 dc_inst.x7.x16/a_27_47# 0.00896f
C3752 _04_ path[5] 0
C3753 _17_/a_174_21# _17_/a_574_297# -0
C3754 VPWR dc_inst.x2.x1/a_27_47# -0
C3755 dc_inst.x1.net3 _05_ 0
C3756 dc_inst.x4.net3 dc_inst.x4.x3/a_27_47# 0.05171f
C3757 dc_inst.x4.x2/a_27_47# dc_inst.x4.net4 0.04972f
C3758 dc_inst.x6.net19 dc_inst.x7.net6 0
C3759 dc_inst.x10/a_218_47# dc_inst.in 0.00162f
C3760 dc_inst.x4.net3 delay_sel[1] 0
C3761 _24_/a_761_289# clknet_1_1__leaf_clk 0.02999f
C3762 _24_/a_27_47# _02_ -0
C3763 dc_inst.x7.net3 dc_inst.net2 0.04682f
C3764 dc_inst.x6.net16 dc_inst.x4.net5 0
C3765 path_sel[0] _20_/a_470_297# 0.00206f
C3766 dc_inst.x6.net7 dc_inst.x5.net12 0
C3767 path_sel[1] dc_inst.x6.x12/a_27_47# 0
C3768 dc_inst.x3.net9 dc_inst.x3.net14 0
C3769 dc_inst.x4.net9 dc_inst.net4 0
C3770 path_sel[2] dc_inst.x2.x1/a_27_47# 0.0041f
C3771 dc_inst.net8 rst 0.0851f
C3772 dc_inst.x1.x4/a_27_47# dc_inst.x1.net4 0.01573f
C3773 dc_inst.x9/a_277_47# dc_inst.x7.net17 0.00111f
C3774 clknet_1_0__leaf_clk dc_inst.x7.net17 0
C3775 dc_inst.x4.net11 dc_inst.x4.net13 0.074f
C3776 _25_/a_1462_47# VPWR 0
C3777 dc_inst.x4.net17 path_sel[0] 0.00142f
C3778 dc_inst.x6.x4/a_27_47# delay_sel[0] 0
C3779 dc_inst.x3.net2 dc_inst.x3.net14 0
C3780 dc_inst.net3 dc_inst.x8/a_1290_413# 0.05491f
C3781 dc_inst.x2.net8 dc_inst.x2.net12 0
C3782 dc_inst.x3.x9/a_27_47# dc_inst.x3.x11/a_27_47# 0.01254f
C3783 dc_inst.x5.net14 dc_inst.x6.x3/a_27_47# 0
C3784 dc_inst.x1.x11/a_27_47# path_sel[0] 0.00436f
C3785 dc_inst.x9/a_750_97# dc_inst.x7.x18/a_27_47# 0
C3786 dc_inst.x1.net4 dc_inst.x3.x4/a_27_47# 0
C3787 tdo dc_inst.x4.net14 0.00238f
C3788 dc_inst.x6.x17/a_27_47# dc_inst.x7.net7 0
C3789 capture_d dc_inst.x6.x15/a_27_47# 0
C3790 _02_ dc_inst.x3.x8/a_27_47# 0.04407f
C3791 delay_sel[1] _23_/a_193_47# 0
C3792 dc_inst.net9 _23_/a_27_47# 0
C3793 clknet_0_clk dc_inst.x7.net18 0.00144f
C3794 capture_d clknet_0_clk 0
C3795 dc_inst.x3.x1/a_27_47# dc_inst.x3.net5 0
C3796 dc_inst.x4.x11/a_27_47# dc_inst.x4.net6 0
C3797 dc_inst.net3 path[4] 0
C3798 dc_inst.x3.x17/a_27_47# dc_inst.x8/a_1478_413# 0.0126f
C3799 dc_inst.net6 dc_inst.x6.net1 0
C3800 dc_inst.x1.x4/a_27_47# dc_inst.x1.net9 0
C3801 _19_/a_27_47# _06_ 0.00135f
C3802 _13_/a_470_297# dc_inst.x3.x7/a_27_47# 0
C3803 dc_inst.x4.net19 dc_inst.x4.x7/a_27_47# 0
C3804 _17_/a_478_47# _08_ 0.00129f
C3805 dc_inst.x1.x4/a_27_47# _04_ 0
C3806 dc_inst.x9/a_750_97# _03_ 0
C3807 _05_ dc_inst.x3.net9 0
C3808 dc_inst.x2.net19 delay_sel[1] 0.00436f
C3809 _00_ _24_/a_761_289# 0.01877f
C3810 _25_/a_543_47# clknet_1_1__leaf_clk 0
C3811 dc_inst.x1.net16 dc_inst.x1.net7 0
C3812 _24_/a_1217_47# _02_ 0
C3813 dc_inst.net6 dc_inst.x6.x5/a_27_47# 0
C3814 dc_inst.x1.x12/a_27_47# _20_/a_79_21# 0
C3815 dc_inst.x2.net7 dc_inst.x2.x12/a_27_47# 0
C3816 dc_inst.x2.x1/a_27_47# dc_inst.x4.net5 0.03312f
C3817 dc_inst.net1 dc_inst.x4.x5/a_27_47# 0.00371f
C3818 dc_inst.net7 dc_inst.x7.x17/a_27_47# 0
C3819 _15_/a_788_316# dc_inst.x3.net12 0
C3820 dc_inst.x3.net2 dc_inst.x3.x15/a_27_47# 0
C3821 dc_inst.x3.net15 dc_inst.x3.x20/a_27_47# 0
C3822 dc_inst.x7.net12 dc_inst.x7.net8 0
C3823 dc_inst.x1.net11 _19_/a_27_47# 0.02914f
C3824 dc_inst.x1.net10 dc_inst.x1.x15/a_27_47# 0
C3825 dc_inst.x1.net4 dc_inst.x5.net11 0
C3826 dc_inst.x5.x14/a_27_47# dc_inst.x5.x17/a_27_47# 0
C3827 dc_inst.x7.net13 dc_inst.x9/a_247_21# 0
C3828 dc_inst.x2.net15 dc_inst.x8/a_750_97# 0
C3829 dc_inst.x7.x9/a_27_47# dc_inst.x7.net4 0
C3830 _15_/a_27_47# dc_inst.x3.net14 0
C3831 dc_inst.x6.x2/a_27_47# dc_inst.x7.x8/a_27_47# 0.01013f
C3832 dc_inst.x1.x9/a_27_47# dc_inst.x1.net9 0.0173f
C3833 _24_/a_543_47# rst 0
C3834 _24_/a_193_47# _01_ 0.00202f
C3835 dc_inst.x1.x19/a_27_47# dc_inst.x1.net7 0
C3836 se dc_inst.x3.net8 0.00148f
C3837 dc_inst.x6.net2 dc_inst.x7.net1 0
C3838 dc_inst.net8 dc_inst.x3.net2 0.13313f
C3839 dc_inst.x1.net10 dc_inst.x2.x4/a_27_47# 0
C3840 dc_inst.x1.x16/a_27_47# dc_inst.x2.net9 0
C3841 clkload0/a_27_47# VPWR 0.09376f
C3842 dc_inst.x2.x19/a_27_47# dc_inst.x8/a_277_47# 0
C3843 dc_inst.x4.net2 dc_inst.x8/a_668_97# 0
C3844 dc_inst.x1.net16 dc_inst.x1.net17 0.04556f
C3845 dc_inst.x2.x1/a_27_47# dc_inst.x2.net2 0.01547f
C3846 dc_inst.net1 dc_inst.x2.x2/a_27_47# 0
C3847 dc_inst.x6.net13 dc_inst.net4 0.00139f
C3848 dc_inst.x2.net18 _15_/a_27_47# 0
C3849 dc_inst.x7.net2 dc_inst.x7.net1 0
C3850 _24_/a_27_47# clknet_0_clk 0
C3851 _25_/a_543_47# _00_ 0.03451f
C3852 dc_inst.x6.x20/a_27_47# dc_inst.x7.x5/a_27_47# 0
C3853 tdo _24_/a_639_47# 0
C3854 dc_inst.x1.net1 dc_inst.x5.net11 0.00128f
C3855 dc_inst.x5.x14/a_27_47# dc_inst.x5.net13 0.04698f
C3856 tdo dc_inst.x4.x11/a_27_47# 0.00384f
C3857 VPWR dc_inst.x9/a_750_97# -0.2198f
C3858 dc_inst.x6.net12 dc_inst.net4 0.00335f
C3859 dc_inst.x1.x19/a_27_47# dc_inst.x1.net17 0.08076f
C3860 dc_inst.x1.net19 dc_inst.x1.x17/a_27_47# 0
C3861 path[5] dc_inst.x3.x12/a_27_47# 0.00345f
C3862 VPWR dc_inst.x7.x16/a_27_47# -0.00656f
C3863 VPWR dc_inst.x3.x2/a_27_47# -0
C3864 dc_inst.x6.net4 dc_inst.x9/a_247_21# 0
C3865 dc_inst.x6.x19/a_27_47# dc_inst.in 0
C3866 _23_/a_1283_21# dc_inst.x8/a_750_97# 0
C3867 dc_inst.x4.net13 dc_inst.x2.net10 0
C3868 dc_inst.x6.x8/a_27_47# dc_inst.x7.net7 0
C3869 path_sel[2] dc_inst.x9/a_750_97# 0.0012f
C3870 dc_inst.x7.x13/a_27_47# delay_sel[0] 0.04267f
C3871 dc_inst.x6.x18/a_27_47# dc_inst.net1 0.00843f
C3872 _24_/a_448_47# clkload0/a_27_47# 0
C3873 _25_/a_1283_21# rst 0.03099f
C3874 _15_/a_1064_47# dc_inst.x3.net14 0
C3875 dc_inst.x3.x6/a_27_47# dc_inst.x3.net19 0
C3876 dc_inst.x9/a_1290_413# dc_inst.x6.net19 0
C3877 dc_inst.x2.net11 path_sel[1] 0.03421f
C3878 dc_inst.x1.net13 dc_inst.x2.net16 0.01826f
C3879 dc_inst.x3.x2/a_27_47# path_sel[2] 0
C3880 dc_inst.x1.net16 dc_inst.x2.net14 0.01113f
C3881 dc_inst.x6.net10 dc_inst.x6.x12/a_27_47# 0.01151f
C3882 dc_inst.x1.net11 dc_inst.x1.net12 0.03659f
C3883 dc_inst.x7.net11 dc_inst.x7.net1 0.03395f
C3884 delay_sel[2] delay_sel[1] 0.05854f
C3885 path[5] _23_/a_1283_21# 0
C3886 dc_inst.x7.net2 dc_inst.x7.x18/a_27_47# 0.00339f
C3887 dc_inst.x4.net3 dc_inst.net2 0
C3888 VPWR dc_inst.x1.net14 0.06779f
C3889 _25_/a_27_47# dc_inst.x9/a_247_21# 0
C3890 VPWR dc_inst.x6.x14/a_27_47# -0.00196f
C3891 _25_/a_1283_21# clkbuf_1_0__f_clk/a_110_47# 0
C3892 _25_/a_193_47# clknet_0_clk 0.01581f
C3893 dc_inst.x4.net17 dc_inst.x5.net17 0
C3894 dc_inst.net3 dc_inst.x2.x20/a_27_47# 0.00212f
C3895 dc_inst.x7.x1/a_27_47# dc_inst.x6.net6 0.00104f
C3896 dc_inst.x7.x20/a_27_47# dc_inst.x7.net18 0
C3897 _25_/a_805_47# tdo 0
C3898 dc_inst.x4.x18/a_27_47# dc_inst.x5.net8 0
C3899 dc_inst.x1.x19/a_27_47# dc_inst.x2.net14 0
C3900 capture_d dc_inst.x7.x20/a_27_47# 0.00687f
C3901 dc_inst.x1.net14 path_sel[2] 0.03358f
C3902 path_sel[1] dc_inst.net4 0.03984f
C3903 dc_inst.x1.net1 _09_ 0.00143f
C3904 rst dc_inst.net1 0
C3905 _04_ _09_ 0
C3906 dc_inst.x2.net7 dc_inst.x5.net7 0.03005f
C3907 VPWR dc_inst.x4.net8 0.09796f
C3908 path_sel[2] dc_inst.x6.x14/a_27_47# 0.01199f
C3909 dc_inst.x7.x15/a_27_47# delay_sel[1] 0
C3910 dc_inst.x7.net2 _03_ 0
C3911 dc_inst.x5.x19/a_27_47# dc_inst.x5.x20/a_27_47# 0
C3912 _13_/a_112_47# path[5] 0.00326f
C3913 dc_inst.x2.net17 dc_inst.x1.x16/a_27_47# 0
C3914 dc_inst.x2.net13 dc_inst.x5.x12/a_27_47# 0.00131f
C3915 path_sel[2] dc_inst.x4.net8 0.00182f
C3916 dc_inst.x4.net3 dc_inst.x1.net4 0
C3917 dc_inst.x1.net6 _04_ 0
C3918 tdo dc_inst.x5.net9 0.00904f
C3919 path_sel[0] dc_inst.x4.x9/a_27_47# 0
C3920 VPWR dc_inst.x2.x10/a_27_47# -0.00264f
C3921 delay_sel[0] dc_inst.x6.net19 0
C3922 delay_sel[1] dc_inst.x6.x20/a_27_47# 0.00214f
C3923 dc_inst.x7.net3 clkbuf_0_clk/a_110_47# 0
C3924 clkbuf_0_clk/a_110_47# dc_inst.x7.x11/a_27_47# 0.01702f
C3925 path[2] dc_inst.x5.net11 0
C3926 _19_/a_27_47# _15_/a_788_316# 0
C3927 _18_/a_76_199# _09_ 0.01793f
C3928 dc_inst.x2.net15 dc_inst.x1.x9/a_27_47# 0
C3929 dc_inst.x2.net16 dc_inst.x2.net19 0
C3930 dc_inst.x2.x10/a_27_47# path_sel[2] 0
C3931 dc_inst.x4.net4 dc_inst.x1.x16/a_27_47# 0
C3932 dc_inst.x4.net17 dc_inst.x5.net12 0.00443f
C3933 dc_inst.x1.net6 _18_/a_76_199# 0
C3934 dc_inst.x5.net16 dc_inst.x7.net8 0
C3935 dc_inst.x1.net13 dc_inst.x1.net9 0.0454f
C3936 _07_ _15_/a_872_316# 0
C3937 path_sel[0] _15_/a_397_47# -0.0014f
C3938 dc_inst.x2.net19 dc_inst.net2 0.00842f
C3939 dc_inst.x2.x4/a_27_47# dc_inst.x2.net4 0.12862f
C3940 dc_inst.x7.net11 _03_ 0
C3941 _25_/a_193_47# dc_inst.x9/a_834_97# 0
C3942 dc_inst.x1.x11/a_27_47# dc_inst.x2.net14 0
C3943 delay_sel[0] dc_inst.x6.net11 0
C3944 _25_/a_1462_47# clknet_0_clk 0
C3945 _24_/a_193_47# dc_inst.net9 0
C3946 dc_inst.x6.net17 dc_inst.x4.net7 0.00226f
C3947 tdo dc_inst.x4.x12/a_27_47# 0
C3948 dc_inst.x1.x11/a_27_47# dc_inst.x5.net12 0
C3949 dc_inst.x1.net18 dc_inst.x1.net15 0
C3950 dc_inst.x4.net3 dc_inst.x1.net9 0
C3951 dc_inst.x3.net2 dc_inst.x1.x8/a_27_47# 0
C3952 dc_inst.x1.net3 _20_/a_384_47# 0.00142f
C3953 dc_inst.net3 dc_inst.x3.x17/a_27_47# 0
C3954 dc_inst.x7.x1/a_27_47# dc_inst.x6.x11/a_27_47# 0.00102f
C3955 dc_inst.x1.net14 dc_inst.x4.net5 0
C3956 dc_inst.x3.net16 dc_inst.x7.net4 0
C3957 dc_inst.x4.x10/a_27_47# tdo 0.00606f
C3958 VPWR dc_inst.x6.net2 0.89378f
C3959 dc_inst.x1.net14 dc_inst.x1.net8 0.03259f
C3960 dc_inst.x5.net7 dc_inst.x5.net3 0.14017f
C3961 dc_inst.x7.net3 _23_/a_1283_21# 0
C3962 tdo dc_inst.x5.x3/a_27_47# 0
C3963 dc_inst.x9/a_27_47# dc_inst.x7.net7 0
C3964 dc_inst.x4.net6 dc_inst.x4.net7 0.2766f
C3965 dc_inst.x1.net4 dc_inst.x2.net19 0
C3966 dc_inst.x6.net2 dc_inst.x6.x16/a_27_47# 0
C3967 dc_inst.x6.net2 path_sel[2] 0.06325f
C3968 dc_inst.x3.x9/a_27_47# path[5] 0.01013f
C3969 rst clkbuf_1_0__f_clk/a_110_47# 0.00671f
C3970 VPWR dc_inst.x7.net2 0.12296f
C3971 dc_inst.net8 dc_inst.x8/a_1478_413# 0.04548f
C3972 delay_sel[2] dc_inst.x8/a_27_47# 0
C3973 _09_ path[2] 0.00166f
C3974 dc_inst.x2.net17 dc_inst.x6.net17 0
C3975 dc_inst.x7.net2 path_sel[2] 0.00557f
C3976 dc_inst.x7.net2 dc_inst.x6.x16/a_27_47# 0
C3977 dc_inst.x7.x1/a_27_47# dc_inst.x6.net16 0
C3978 VPWR dc_inst.x3.x19/a_27_47# -0.00377f
C3979 dc_inst.x1.net10 dc_inst.x2.net13 0.00245f
C3980 _06_ dc_inst.in 0
C3981 dc_inst.x5.net19 dc_inst.x6.x20/a_27_47# 0
C3982 dc_inst.x6.net2 dc_inst.x6.net15 0
C3983 _07_ path[7] 0
C3984 dc_inst.x3.x19/a_27_47# path_sel[2] 0
C3985 dc_inst.x1.net6 path[2] 0
C3986 path_sel[0] path[4] 0.15543f
C3987 dc_inst.x4.net12 dc_inst.x4.net9 0
C3988 dc_inst.x1.net16 dc_inst.x2.x17/a_27_47# 0
C3989 _00_ dc_inst.x9/a_1478_413# 0
C3990 _25_/a_1108_47# dc_inst.net7 0
C3991 _25_/a_543_47# delay_sel[1] 0
C3992 dc_inst.x2.net2 dc_inst.x4.net8 0
C3993 dc_inst.x2.net3 dc_inst.x4.net7 0
C3994 dc_inst.x4.net4 dc_inst.x6.net17 0
C3995 dc_inst.x7.net2 dc_inst.x6.net15 0
C3996 VPWR dc_inst.x3.net18 0
C3997 VPWR dc_inst.x8/a_757_363# -0.00962f
C3998 dc_inst.x1.net11 dc_inst.in 0
C3999 dc_inst.x7.net11 VPWR 0.30887f
C4000 dc_inst.net6 dc_inst.x6.net17 0
C4001 path_sel[2] dc_inst.x8/a_757_363# 0
C4002 dc_inst.x4.x3/a_27_47# dc_inst.x1.net16 0
C4003 rst dc_inst.x3.net9 0
C4004 dc_inst.x5.net7 dc_inst.x6.net19 0
C4005 clkload0/a_27_47# clknet_0_clk 0.11171f
C4006 path_sel[0] dc_inst.x5.x12/a_27_47# 0
C4007 dc_inst.x6.net2 dc_inst.x4.net5 0
C4008 dc_inst.x2.x4/a_27_47# dc_inst.x2.net6 0.00331f
C4009 dc_inst.x3.net2 rst 0
C4010 delay_sel[2] dc_inst.net2 0
C4011 dc_inst.x5.net6 dc_inst.x5.x9/a_27_47# 0
C4012 dc_inst.x3.x6/a_27_47# path[5] 0.00457f
C4013 dc_inst.x6.net10 dc_inst.net4 0.02571f
C4014 dc_inst.x5.net4 dc_inst.x2.net10 0
C4015 _01_ dc_inst.x3.net19 0
C4016 dc_inst.x7.net2 dc_inst.x4.net5 0
C4017 VPWR dc_inst.x6.x13/a_27_47# 0.05573f
C4018 dc_inst.x5.x20/a_27_47# dc_inst.x7.net10 0.15487f
C4019 _24_/a_1283_21# dc_inst.x8/a_1290_413# 0
C4020 dc_inst.x1.net3 dc_inst.x3.net2 0.05073f
C4021 dc_inst.x1.net2 dc_inst.x3.net3 0.00271f
C4022 dc_inst.x6.net9 dc_inst.x6.net7 0.00114f
C4023 dc_inst.x2.net7 dc_inst.x5.net11 0
C4024 dc_inst.x5.net7 dc_inst.x6.net11 0
C4025 dc_inst.x1.net18 delay_sel[0] 0
C4026 dc_inst.x6.net11 dc_inst.x4.x6/a_27_47# 0
C4027 tdo dc_inst.x4.net7 0.14328f
C4028 dc_inst.x9/a_193_413# dc_inst.x9/a_750_97# -0
C4029 dc_inst.x9/a_247_21# dc_inst.x9/a_757_363# -0.0033f
C4030 clknet_0_clk dc_inst.x9/a_750_97# 0
C4031 clkbuf_1_0__f_clk/a_110_47# dc_inst.x9/a_27_47# 0
C4032 dc_inst.x4.net1 dc_inst.x4.net9 0.14755f
C4033 dc_inst.x7.net1 dc_inst.x7.net4 0.02152f
C4034 dc_inst.x5.net17 dc_inst.x5.x18/a_27_47# 0.02051f
C4035 dc_inst.x5.x17/a_27_47# dc_inst.x5.net18 0
C4036 path_sel[2] dc_inst.x6.x13/a_27_47# 0.01189f
C4037 dc_inst.x6.x16/a_27_47# dc_inst.x6.x13/a_27_47# 0.01224f
C4038 _00_ dc_inst.net7 0
C4039 dc_inst.x5.net6 dc_inst.x6.x19/a_27_47# 0
C4040 dc_inst.x4.net16 dc_inst.x6.net7 0
C4041 dc_inst.x1.net13 dc_inst.x2.net15 0.00144f
C4042 dc_inst.x1.x20/a_27_47# dc_inst.in 0
C4043 dc_inst.x3.net16 _23_/a_27_47# 0
C4044 dc_inst.x5.x8/a_27_47# dc_inst.x4.x9/a_27_47# 0
C4045 VPWR dc_inst.x6.x12/a_27_47# 0.01172f
C4046 dc_inst.x1.x1/a_27_47# shadow_q 0
C4047 dc_inst.x1.net15 dc_inst.x3.net3 0
C4048 _19_/a_27_47# _17_/a_174_21# 0
C4049 dc_inst.x4.net3 dc_inst.x2.net15 0.00114f
C4050 dc_inst.x3.net4 dc_inst.x3.net5 0.00504f
C4051 dc_inst.x4.net5 dc_inst.x8/a_757_363# 0
C4052 dc_inst.x5.x14/a_27_47# dc_inst.x5.x19/a_27_47# 0
C4053 path_sel[2] dc_inst.x6.x12/a_27_47# 0.01367f
C4054 dc_inst.x6.net15 dc_inst.x6.x13/a_27_47# 0
C4055 dc_inst.net3 dc_inst.x3.net14 0
C4056 _02_ dc_inst.x3.x19/a_27_47# 0
C4057 _08_ _16_/a_27_93# 0
C4058 _17_/a_478_47# _07_ 0
C4059 _15_/a_27_47# _20_/a_384_47# 0
C4060 dc_inst.net5 dc_inst.x6.x20/a_27_47# 0.03857f
C4061 _01_ delay_sel[0] 0
C4062 _14_/a_505_21# dc_inst.x3.net1 0.00143f
C4063 dc_inst.x3.net12 dc_inst.x3.net17 0
C4064 dc_inst.x7.net1 dc_inst.net4 0.05963f
C4065 dc_inst.x1.x10/a_27_47# _07_ 0.00139f
C4066 dc_inst.x1.net10 path_sel[0] 0
C4067 path[4] dc_inst.x1.net7 0
C4068 dc_inst.x1.net3 _15_/a_27_47# 0.02437f
C4069 dc_inst.x1.net2 _15_/a_288_47# 0.02478f
C4070 _02_ dc_inst.x3.net18 0
C4071 dc_inst.net3 dc_inst.x2.net18 0.11773f
C4072 dc_inst.x6.x1/a_27_47# dc_inst.x6.net11 0.01149f
C4073 dc_inst.x9/a_27_413# delay_sel[0] 0.04291f
C4074 dc_inst.x9/a_750_97# dc_inst.x9/a_834_97# -0
C4075 dc_inst.x4.net4 tdo 0
C4076 dc_inst.x4.net17 dc_inst.x4.x14/a_27_47# 0.00146f
C4077 dc_inst.net6 dc_inst.x6.net18 0
C4078 dc_inst.x5.x1/a_27_47# dc_inst.x4.net18 0
C4079 dc_inst.x2.x20/a_27_47# path_sel[0] 0
C4080 dc_inst.x3.net3 dc_inst.x3.net19 0.05306f
C4081 tdo dc_inst.net6 0
C4082 dc_inst.x1.x14/a_27_47# dc_inst.x1.net14 0.00742f
C4083 dc_inst.x7.net4 _03_ 0
C4084 capture_q path[6] 0.01666f
C4085 dc_inst.x2.net19 dc_inst.x2.net15 0
C4086 _19_/a_193_297# path_sel[1] 0
C4087 dc_inst.x1.x18/a_27_47# dc_inst.net1 0.02637f
C4088 dc_inst.x7.net3 dc_inst.x6.net19 0
C4089 dc_inst.x3.x4/a_27_47# clkbuf_1_1__f_clk/a_110_47# 0
C4090 dc_inst.x5.net6 dc_inst.x5.net8 0.00884f
C4091 dc_inst.x5.net5 dc_inst.x5.net9 0.38595f
C4092 dc_inst.net7 dc_inst.x7.x5/a_27_47# 0.00159f
C4093 dc_inst.x4.x17/a_27_47# dc_inst.x5.net6 0
C4094 _15_/a_872_316# _06_ 0
C4095 _15_/a_788_316# dc_inst.in 0
C4096 dc_inst.x6.net5 dc_inst.x6.net1 0.01066f
C4097 tdi dc_inst.x3.net1 0
C4098 dc_inst.x9/a_1290_413# dc_inst.x6.net14 0
C4099 dc_inst.x4.x7/a_27_47# dc_inst.x4.net8 0.01543f
C4100 _23_/a_193_47# _23_/a_1283_21# -0
C4101 dc_inst.x4.x16/a_27_47# dc_inst.x4.net13 0.003f
C4102 dc_inst.x3.net11 dc_inst.x3.net12 0.21131f
C4103 dc_inst.x1.net18 dc_inst.x5.net7 0.00645f
C4104 dc_inst.x6.net2 dc_inst.x6.x15/a_27_47# 0
C4105 dc_inst.x6.net3 dc_inst.x7.x7/a_27_47# 0
C4106 dc_inst.x7.net19 dc_inst.x7.net17 0.144f
C4107 tdo dc_inst.x8/a_277_47# 0
C4108 dc_inst.net3 dc_inst.net8 0.05004f
C4109 dc_inst.x6.net5 dc_inst.x6.x5/a_27_47# 0.04936f
C4110 dc_inst.x1.net3 _15_/a_1064_47# 0
C4111 tdo dc_inst.x5.x7/a_27_47# 0.00385f
C4112 dc_inst.x4.net12 path_sel[1] 0.03333f
C4113 dc_inst.x1.net19 dc_inst.x5.net6 0.02091f
C4114 dc_inst.net4 _03_ 0
C4115 dc_inst.x1.net11 _15_/a_872_316# 0
C4116 delay_sel[0] dc_inst.x7.net16 0.01385f
C4117 dc_inst.x9/a_668_97# delay_sel[0] 0
C4118 dc_inst.x9/a_1478_413# delay_sel[1] 0.08285f
C4119 dc_inst.x9/a_1290_413# dc_inst.net9 -0
C4120 dc_inst.x9/a_193_47# dc_inst.net7 0
C4121 dc_inst.x7.x10/a_27_47# dc_inst.x7.net1 0.00318f
C4122 dc_inst.x3.net3 delay_sel[0] 0
C4123 dc_inst.x7.net2 dc_inst.x6.x15/a_27_47# 0
C4124 dc_inst.x4.net1 dc_inst.x6.net12 0
C4125 dc_inst.x1.net16 dc_inst.x2.net16 0.00932f
C4126 dc_inst.net6 dc_inst.x9/a_277_47# 0.03243f
C4127 dc_inst.net6 clknet_1_0__leaf_clk 0
C4128 dc_inst.in dc_inst.x8/a_193_413# 0.00118f
C4129 dc_inst.x7.net2 clknet_0_clk 0.00158f
C4130 dc_inst.x3.net2 _15_/a_27_47# 0
C4131 dc_inst.x3.net17 shadow_q 0
C4132 dc_inst.x5.net5 dc_inst.x2.x9/a_27_47# 0
C4133 dc_inst.x7.x9/a_27_47# dc_inst.x7.net6 0
C4134 _15_/a_288_47# dc_inst.x3.net19 0
C4135 dc_inst.x6.net5 dc_inst.x4.x20/a_27_47# 0
C4136 dc_inst.x1.x5/a_27_47# _19_/a_27_47# 0
C4137 _10_ path_sel[1] 0
C4138 _01_ dc_inst.x8/a_750_97# 0
C4139 dc_inst.x5.x3/a_27_47# dc_inst.x5.net5 0.04132f
C4140 path[3] _16_/a_229_47# 0
C4141 dc_inst.x3.x5/a_27_47# path[5] 0.00505f
C4142 dc_inst.x4.net14 dc_inst.x5.x1/a_27_47# 0.01151f
C4143 dc_inst.x4.x15/a_27_47# dc_inst.net4 0.0122f
C4144 path_sel[1] dc_inst.x1.x7/a_27_47# 0.01867f
C4145 dc_inst.x4.x1/a_27_47# VPWR 0.01817f
C4146 dc_inst.x1.net14 dc_inst.x2.net12 0
C4147 path_sel[0] dc_inst.x3.net1 0
C4148 dc_inst.x2.net6 dc_inst.x2.net13 0.00394f
C4149 VPWR dc_inst.x7.net4 1.74164f
C4150 dc_inst.x1.net19 dc_inst.x2.x16/a_27_47# 0
C4151 path[7] _06_ 0.08671f
C4152 VPWR dc_inst.x2.net11 0
C4153 dc_inst.x4.x1/a_27_47# path_sel[2] 0.00249f
C4154 delay_sel[0] dc_inst.x6.net14 0
C4155 _14_/a_505_21# dc_inst.x3.net14 0
C4156 dc_inst.x9/a_750_97# dc_inst.x8/a_27_413# 0
C4157 dc_inst.x4.x16/a_27_47# dc_inst.x4.net11 0.01149f
C4158 dc_inst.x2.net12 dc_inst.x4.net8 0
C4159 dc_inst.x1.net10 dc_inst.x1.net7 0.00336f
C4160 path_sel[2] dc_inst.x7.net4 0.00324f
C4161 dc_inst.x10/a_505_21# _23_/a_761_289# 0.00669f
C4162 dc_inst.x2.net11 path_sel[2] 0
C4163 dc_inst.x3.x7/a_27_47# _15_/a_788_316# 0
C4164 dc_inst.x3.x20/a_27_47# dc_inst.x8/a_247_21# 0
C4165 dc_inst.x7.net11 clknet_0_clk 0
C4166 dc_inst.x4.net1 path_sel[1] 0.02473f
C4167 dc_inst.x2.net14 dc_inst.x5.x12/a_27_47# 0
C4168 dc_inst.x3.x16/a_27_47# _23_/a_27_47# 0
C4169 dc_inst.x5.net5 dc_inst.x2.net9 0
C4170 dc_inst.x5.x12/a_27_47# dc_inst.x5.net12 0.00338f
C4171 dc_inst.x5.net6 dc_inst.x5.net10 0
C4172 dc_inst.x5.net5 dc_inst.x5.net1 0
C4173 dc_inst.x1.net11 path[7] 0
C4174 dc_inst.net7 delay_sel[1] 0.10244f
C4175 clkbuf_0_clk/a_110_47# delay_sel[2] 0.02098f
C4176 VPWR dc_inst.x3.net10 0.19681f
C4177 delay_sel[0] dc_inst.net9 0.02947f
C4178 dc_inst.x4.x13/a_27_47# dc_inst.x5.x1/a_27_47# 0.08729f
C4179 dc_inst.x2.x10/a_27_47# dc_inst.x2.net12 0
C4180 dc_inst.x2.net1 dc_inst.x2.x12/a_27_47# 0
C4181 _24_/a_543_47# dc_inst.net3 0
C4182 _19_/a_193_297# path[3] 0
C4183 dc_inst.x6.net15 dc_inst.x7.net4 0
C4184 dc_inst.x7.net2 dc_inst.x9/a_834_97# 0
C4185 _23_/a_27_47# _03_ 0.00352f
C4186 dc_inst.in dc_inst.x8/a_834_97# 0
C4187 VPWR dc_inst.net4 0.4166f
C4188 path[6] dc_inst.x3.x20/a_27_47# 0.01455f
C4189 _14_/a_76_199# tdi 0.00366f
C4190 dc_inst.x3.net11 shadow_q 0
C4191 _14_/a_218_374# se 0.00206f
C4192 dc_inst.x6.x16/a_27_47# dc_inst.net4 0.001f
C4193 dc_inst.x1.net16 dc_inst.x1.net9 0.00426f
C4194 path_sel[2] dc_inst.net4 0.04836f
C4195 dc_inst.x1.net17 dc_inst.x1.net10 0
C4196 _24_/a_1283_21# dc_inst.x3.x17/a_27_47# 0
C4197 dc_inst.x1.x5/a_27_47# dc_inst.x1.net12 0.03188f
C4198 dc_inst.x1.net6 dc_inst.x1.x12/a_27_47# 0.04038f
C4199 se _13_/a_112_47# 0.00242f
C4200 _14_/a_505_21# _05_ 0.00385f
C4201 dc_inst.x4.x12/a_27_47# dc_inst.x5.x6/a_27_47# 0
C4202 dc_inst.x4.net17 dc_inst.net5 0
C4203 dc_inst.x1.net15 dc_inst.x6.net13 0
C4204 dc_inst.x7.net4 dc_inst.x4.net5 0
C4205 dc_inst.x1.x20/a_27_47# dc_inst.x5.net6 0
C4206 tdi dc_inst.x3.net14 0
C4207 dc_inst.x6.net5 dc_inst.x6.x6/a_27_47# 0
C4208 dc_inst.x6.x4/a_27_47# dc_inst.x6.net7 0
C4209 dc_inst.x4.net16 dc_inst.x4.net17 0.19602f
C4210 dc_inst.net8 _23_/a_543_47# 0
C4211 delay_sel[2] _23_/a_1283_21# 0.00305f
C4212 capture_d _23_/a_448_47# 0.01304f
C4213 dc_inst.x6.net15 dc_inst.net4 0
C4214 dc_inst.x3.net3 dc_inst.x8/a_750_97# 0
C4215 dc_inst.x3.net2 dc_inst.x8/a_1478_413# 0.02979f
C4216 dc_inst.x5.net14 path_sel[1] 0.02997f
C4217 path_sel[1] dc_inst.x5.x13/a_27_47# 0.00476f
C4218 dc_inst.x3.net7 dc_inst.x3.net17 0.04162f
C4219 dc_inst.x7.x1/a_27_47# dc_inst.x6.net2 0.03899f
C4220 dc_inst.x1.net15 dc_inst.x6.net12 0.00219f
C4221 dc_inst.net3 dc_inst.x1.x8/a_27_47# 0
C4222 dc_inst.x1.x13/a_27_47# dc_inst.x1.net12 0.01626f
C4223 _10_ path[3] 0.16291f
C4224 _23_/a_1217_47# _03_ 0
C4225 dc_inst.x3.net3 path[5] 0
C4226 _01_ dc_inst.x3.x4/a_27_47# 0
C4227 dc_inst.x5.x4/a_27_47# dc_inst.x5.net9 0.03031f
C4228 dc_inst.x1.net10 dc_inst.x2.net14 0.03001f
C4229 dc_inst.x4.x4/a_27_47# dc_inst.in 0
C4230 dc_inst.x1.net10 dc_inst.x5.net12 0.0086f
C4231 dc_inst.x7.net3 _01_ 0.09865f
C4232 dc_inst.x7.x1/a_27_47# dc_inst.x7.net2 0.00214f
C4233 _13_/a_470_47# shadow_q -0.0072f
C4234 dc_inst.x4.net12 dc_inst.x6.net10 0
C4235 delay_sel[2] _13_/a_112_47# 0.00106f
C4236 VPWR _23_/a_27_47# 0.0953f
C4237 dc_inst.net4 dc_inst.x4.net5 0
C4238 _04_ _20_/a_470_297# 0
C4239 dc_inst.x9/a_1290_413# dc_inst.x6.net13 0
C4240 dc_inst.x1.net2 path_sel[1] 0.52953f
C4241 dc_inst.x5.net7 dc_inst.x6.net14 0.0014f
C4242 clknet_1_1__leaf_clk dc_inst.x3.x17/a_27_47# 0
C4243 dc_inst.x2.net6 path_sel[0] 0.00147f
C4244 dc_inst.x4.net2 dc_inst.x6.x19/a_27_47# 0
C4245 VPWR dc_inst.x7.x10/a_27_47# 0.00213f
C4246 dc_inst.x7.net2 dc_inst.x7.x20/a_27_47# 0.00399f
C4247 path_sel[0] dc_inst.x3.net14 0
C4248 tdi _05_ 0.01865f
C4249 dc_inst.x2.net5 dc_inst.x5.net9 0
C4250 dc_inst.x5.net1 _17_/a_27_93# 0
C4251 dc_inst.x9/a_247_21# dc_inst.x7.net10 0.01303f
C4252 clkbuf_1_1__f_clk/a_110_47# _23_/a_193_47# 0
C4253 dc_inst.net3 dc_inst.net1 0.0135f
C4254 dc_inst.x7.x10/a_27_47# path_sel[2] 0.00229f
C4255 delay_sel[1] dc_inst.x8/a_1290_413# 0.00303f
C4256 dc_inst.x5.net15 dc_inst.net4 0
C4257 dc_inst.x9/a_1290_413# dc_inst.x6.net12 0
C4258 dc_inst.x10/a_218_374# delay_sel[2] 0
C4259 dc_inst.x10/a_505_21# dc_inst.net8 0.01076f
C4260 dc_inst.x1.x10/a_27_47# dc_inst.x1.net11 0
C4261 dc_inst.x1.net1 dc_inst.x1.x11/a_27_47# 0.12862f
C4262 dc_inst.x5.x18/a_27_47# dc_inst.x5.net19 0.00509f
C4263 dc_inst.x5.net18 dc_inst.x5.x19/a_27_47# 0.12901f
C4264 dc_inst.x1.x1/a_27_47# dc_inst.in 0.04327f
C4265 dc_inst.net3 dc_inst.x6.x18/a_27_47# 0
C4266 dc_inst.x6.net4 dc_inst.x6.x5/a_27_47# 0
C4267 dc_inst.x1.net15 path_sel[1] 0.01039f
C4268 dc_inst.x2.net10 path[0] 0.00115f
C4269 dc_inst.x3.net7 dc_inst.x3.net11 0
C4270 dc_inst.x3.net6 dc_inst.x3.net12 0.03274f
C4271 dc_inst.x2.net18 path_sel[0] 0
C4272 _24_/a_543_47# _23_/a_543_47# 0
C4273 _24_/a_193_47# _23_/a_1108_47# 0
C4274 dc_inst.x4.net14 dc_inst.x4.net18 0.23747f
C4275 dc_inst.x5.x3/a_27_47# dc_inst.x5.x4/a_27_47# 0.02448f
C4276 dc_inst.x5.x20/a_27_47# dc_inst.x7.net18 0
C4277 VPWR dc_inst.x3.net13 0.1668f
C4278 dc_inst.x3.x18/a_27_47# dc_inst.x3.x19/a_27_47# 0
C4279 dc_inst.x6.net3 dc_inst.x5.net19 0.04559f
C4280 dc_inst.x4.net1 dc_inst.x2.x7/a_27_47# 0
C4281 dc_inst.x7.x3/a_27_47# dc_inst.x8/a_834_97# 0
C4282 _15_/a_193_47# path[6] 0
C4283 _25_/a_543_47# clkbuf_0_clk/a_110_47# 0.01033f
C4284 _25_/a_27_47# clk 0.00915f
C4285 _15_/a_788_316# path[7] 0.0501f
C4286 _15_/a_288_47# path[5] 0.00385f
C4287 dc_inst.x1.x11/a_27_47# _18_/a_76_199# 0.01787f
C4288 dc_inst.x3.net15 shadow_q 0.06119f
C4289 dc_inst.x2.net5 dc_inst.x2.x9/a_27_47# 0.01154f
C4290 VPWR _23_/a_1217_47# 0
C4291 path_sel[0] dc_inst.x3.x15/a_27_47# 0
C4292 _00_ dc_inst.x3.x17/a_27_47# 0
C4293 dc_inst.x8/a_247_21# dc_inst.x8/a_277_47# -0.00757f
C4294 dc_inst.x3.x18/a_27_47# dc_inst.x3.net18 0.03666f
C4295 dc_inst.x1.net16 dc_inst.x2.net15 0.07129f
C4296 dc_inst.net3 rst 0
C4297 dc_inst.x5.net18 dc_inst.x5.net6 0
C4298 dc_inst.x5.net7 dc_inst.x4.net9 0.02344f
C4299 path_sel[0] dc_inst.x5.net2 0.00282f
C4300 dc_inst.x1.net17 dc_inst.x2.net4 0
C4301 _24_/a_193_47# _13_/a_27_297# 0
C4302 dc_inst.x7.net3 dc_inst.x7.net16 0.00239f
C4303 dc_inst.x3.net3 dc_inst.x3.x4/a_27_47# 0.00146f
C4304 dc_inst.x5.net6 dc_inst.x4.net10 0
C4305 delay_sel[0] dc_inst.x7.x9/a_27_47# 0
C4306 dc_inst.x7.net3 dc_inst.x3.net3 0
C4307 dc_inst.x5.x4/a_27_47# dc_inst.x5.net1 0
C4308 se dc_inst.x3.x6/a_27_47# 0
C4309 path_sel[1] dc_inst.x3.net19 0
C4310 dc_inst.x5.net5 dc_inst.x5.x7/a_27_47# 0
C4311 dc_inst.x5.x5/a_27_47# dc_inst.x5.net7 0.0292f
C4312 dc_inst.x6.net7 dc_inst.x5.net3 0
C4313 path[2] _20_/a_470_297# 0
C4314 dc_inst.net5 dc_inst.net7 0
C4315 _16_/a_27_93# _07_ 0.00101f
C4316 _16_/a_229_47# path[1] 0.00826f
C4317 rst dc_inst.x7.x19/a_27_47# 0
C4318 se clkbuf_1_1__f_clk/a_110_47# 0.04994f
C4319 dc_inst.x7.net12 dc_inst.x7.x14/a_27_47# 0.02595f
C4320 dc_inst.x6.x15/a_27_47# dc_inst.x7.net4 0
C4321 dc_inst.x1.x19/a_27_47# dc_inst.x2.net15 0
C4322 dc_inst.x1.x5/a_27_47# dc_inst.in 0
C4323 dc_inst.x1.net5 _06_ 0
C4324 dc_inst.x9/a_193_413# dc_inst.x7.net4 0.00144f
C4325 clknet_1_1__leaf_clk _23_/a_761_289# 0.00121f
C4326 _02_ _23_/a_27_47# 0
C4327 clknet_0_clk dc_inst.x7.net4 0
C4328 dc_inst.x2.net5 dc_inst.x2.net9 0
C4329 _24_/a_543_47# dc_inst.x10/a_505_21# 0
C4330 _13_/a_470_297# dc_inst.x3.x8/a_27_47# 0.03087f
C4331 _25_/a_761_289# dc_inst.x7.net1 0.00399f
C4332 _15_/a_1281_47# path[4] 0
C4333 dc_inst.x7.net15 dc_inst.x7.net18 0.01931f
C4334 clknet_1_1__leaf_clk _14_/a_76_199# 0.00155f
C4335 dc_inst.x1.x11/a_27_47# path[2] 0.0011f
C4336 dc_inst.x7.net3 dc_inst.x6.net14 0
C4337 dc_inst.x2.net14 dc_inst.x2.net4 0
C4338 dc_inst.x7.net12 dc_inst.x7.net13 0.10319f
C4339 clkbuf_1_0__f_clk/a_110_47# dc_inst.x7.x19/a_27_47# 0.01024f
C4340 _24_/a_193_47# _03_ 0
C4341 VPWR _16_/a_229_47# 0
C4342 dc_inst.x8/a_923_363# dc_inst.x8/a_834_97# -0
C4343 dc_inst.x2.x12/a_27_47# path_sel[1] 0.01216f
C4344 dc_inst.x3.net6 shadow_q 0
C4345 dc_inst.x1.net5 dc_inst.x1.net11 0.06778f
C4346 dc_inst.x7.net1 dc_inst.x7.net6 0.00244f
C4347 dc_inst.x7.net5 dc_inst.x7.x5/a_27_47# 0.03846f
C4348 dc_inst.x6.x8/a_27_47# dc_inst.x6.x9/a_27_47# 0
C4349 _24_/a_1283_21# _05_ 0
C4350 _19_/a_109_297# _07_ 0
C4351 dc_inst.x7.net3 dc_inst.net9 0.06888f
C4352 dc_inst.net4 dc_inst.x6.x15/a_27_47# 0
C4353 delay_sel[2] clkbuf_1_1__f_clk/a_110_47# 0.0471f
C4354 dc_inst.x3.x4/a_27_47# _15_/a_288_47# 0
C4355 dc_inst.x9/a_193_413# dc_inst.net4 0.00266f
C4356 dc_inst.net5 dc_inst.x6.net3 0
C4357 clknet_1_1__leaf_clk dc_inst.x3.net14 0
C4358 dc_inst.x4.net16 dc_inst.x4.x9/a_27_47# 0
C4359 dc_inst.x4.x2/a_27_47# dc_inst.in 0
C4360 dc_inst.x1.x15/a_27_47# _15_/a_27_47# 0
C4361 dc_inst.x2.x17/a_27_47# dc_inst.x2.x20/a_27_47# 0
C4362 dc_inst.x5.x17/a_27_47# dc_inst.x6.net8 0.03581f
C4363 dc_inst.x3.net7 dc_inst.x3.net15 0
C4364 dc_inst.net3 dc_inst.x3.net2 0.07208f
C4365 dc_inst.x5.net10 dc_inst.x2.x15/a_27_47# 0
C4366 dc_inst.x4.net14 dc_inst.x4.x13/a_27_47# 0
C4367 dc_inst.x2.x8/a_27_47# dc_inst.x2.net4 0
C4368 _24_/a_1108_47# delay_sel[2] 0.01021f
C4369 _24_/a_1283_21# dc_inst.net8 0
C4370 clknet_1_1__leaf_clk dc_inst.x10/a_76_199# 0
C4371 dc_inst.x2.x6/a_27_47# dc_inst.x5.net8 0
C4372 dc_inst.x1.net17 dc_inst.x2.net6 0
C4373 dc_inst.x5.net7 dc_inst.x6.net13 0
C4374 VPWR _19_/a_193_297# 0
C4375 dc_inst.x3.x5/a_27_47# _23_/a_193_47# 0
C4376 _00_ _14_/a_76_199# 0.00228f
C4377 dc_inst.x2.x20/a_27_47# delay_sel[1] 0.00775f
C4378 dc_inst.x4.net13 path_sel[0] 0.00211f
C4379 dc_inst.x5.net18 dc_inst.x7.net10 0
C4380 dc_inst.x5.net17 dc_inst.x7.net9 0
C4381 dc_inst.x2.x10/a_27_47# dc_inst.x2.x11/a_27_47# 0
C4382 dc_inst.x1.net4 _15_/a_397_47# 0
C4383 _25_/a_761_289# _03_ 0
C4384 dc_inst.x6.x20/a_27_47# dc_inst.x6.net19 0.12444f
C4385 _01_ _23_/a_193_47# 0.00841f
C4386 rst _23_/a_543_47# 0.00237f
C4387 dc_inst.x8/a_1290_413# dc_inst.net2 0.06635f
C4388 dc_inst.x5.net14 dc_inst.x4.x19/a_27_47# 0.00149f
C4389 dc_inst.x1.x19/a_27_47# dc_inst.x2.net7 0
C4390 dc_inst.x2.net1 dc_inst.x5.net11 0.00916f
C4391 dc_inst.x5.net7 dc_inst.x6.net12 0
C4392 clknet_1_1__leaf_clk _05_ 0
C4393 clknet_1_1__leaf_clk dc_inst.x3.x15/a_27_47# 0
C4394 dc_inst.x6.net12 dc_inst.x4.x6/a_27_47# 0.01153f
C4395 _24_/a_193_47# VPWR -0.28109f
C4396 dc_inst.x5.x13/a_27_47# dc_inst.x4.x19/a_27_47# 0.04629f
C4397 dc_inst.x6.x7/a_27_47# dc_inst.x5.net12 0.00148f
C4398 dc_inst.x4.x4/a_27_47# dc_inst.x5.net6 0
C4399 _14_/a_505_21# rst 0.086f
C4400 _00_ dc_inst.x3.net14 0
C4401 dc_inst.x2.x19/a_27_47# dc_inst.in 0.02705f
C4402 tdo dc_inst.x6.net5 0
C4403 dc_inst.x7.net12 _25_/a_27_47# 0.10783f
C4404 dc_inst.x5.x14/a_27_47# dc_inst.x5.x2/a_27_47# 0
C4405 dc_inst.x2.net6 dc_inst.x2.net14 0
C4406 VPWR dc_inst.x4.net12 0.03013f
C4407 dc_inst.x2.net6 dc_inst.x5.net12 0.03666f
C4408 clknet_0_clk _23_/a_27_47# 0
C4409 dc_inst.x1.x3/a_27_47# dc_inst.x1.x5/a_27_47# 0
C4410 dc_inst.x3.net5 dc_inst.x3.x19/a_27_47# 0.0172f
C4411 dc_inst.x4.x17/a_27_47# dc_inst.x4.net19 0.00235f
C4412 _24_/a_761_289# clkbuf_1_1__f_clk/a_110_47# 0.00203f
C4413 dc_inst.x1.net4 dc_inst.x8/a_1290_413# 0
C4414 dc_inst.x2.net11 dc_inst.x2.net12 0.25259f
C4415 dc_inst.x7.x10/a_27_47# dc_inst.x9/a_193_413# 0
C4416 _25_/a_448_47# delay_sel[2] 0
C4417 clknet_1_1__leaf_clk dc_inst.net8 0
C4418 dc_inst.x5.x16/a_27_47# path_sel[0] 0
C4419 dc_inst.x4.net12 path_sel[2] 0
C4420 delay_sel[1] dc_inst.x7.net5 0
C4421 dc_inst.x3.x7/a_27_47# dc_inst.x3.net17 0.01151f
C4422 rst dc_inst.x7.x17/a_27_47# 0
C4423 dc_inst.net3 _15_/a_27_47# 0
C4424 dc_inst.x5.net17 dc_inst.x5.net2 0.00352f
C4425 path_sel[0] dc_inst.x1.x8/a_27_47# 0
C4426 dc_inst.x7.x1/a_27_47# dc_inst.x7.net4 0
C4427 dc_inst.net6 dc_inst.x7.x4/a_27_47# 0
C4428 dc_inst.x3.net6 dc_inst.x3.net7 0.35229f
C4429 VPWR _10_ 0.147f
C4430 dc_inst.x1.net13 dc_inst.x3.net3 0
C4431 dc_inst.x4.net11 path_sel[0] 0
C4432 dc_inst.x2.net10 dc_inst.x2.net13 0
C4433 dc_inst.x4.net17 dc_inst.x2.net7 0
C4434 VPWR dc_inst.x1.x7/a_27_47# 0.07181f
C4435 dc_inst.x3.net8 dc_inst.x3.net1 0.04892f
C4436 dc_inst.x3.net5 dc_inst.x3.net18 0.00368f
C4437 _24_/a_193_47# _24_/a_448_47# -0.00779f
C4438 dc_inst.x5.net4 dc_inst.x2.net13 0
C4439 dc_inst.x1.net4 path[4] 0.00167f
C4440 path_sel[2] _10_ 0
C4441 clkload0/a_27_47# _23_/a_448_47# 0
C4442 dc_inst.x5.net7 path_sel[1] 0.05363f
C4443 se dc_inst.x3.x5/a_27_47# 0
C4444 path_sel[1] dc_inst.x4.x6/a_27_47# 0.0027f
C4445 path_sel[2] dc_inst.x1.x7/a_27_47# 0.00563f
C4446 _19_/a_465_47# dc_inst.x1.net7 0
C4447 clkbuf_1_0__f_clk/a_110_47# dc_inst.x7.x17/a_27_47# 0.00579f
C4448 dc_inst.x10/a_505_21# rst 0.07933f
C4449 dc_inst.x1.x17/a_27_47# dc_inst.x1.x16/a_27_47# 0.01018f
C4450 _00_ _05_ 0.00303f
C4451 dc_inst.x1.x1/a_27_47# path[7] 0
C4452 _00_ dc_inst.x3.x15/a_27_47# 0
C4453 dc_inst.x2.net6 dc_inst.x2.x8/a_27_47# 0.0178f
C4454 _25_/a_761_289# VPWR 0.00249f
C4455 dc_inst.x2.net6 dc_inst.x5.x10/a_27_47# 0.00132f
C4456 _13_/a_27_297# dc_inst.x3.x11/a_27_47# 0
C4457 dc_inst.x1.x3/a_27_47# dc_inst.x3.net17 0
C4458 dc_inst.x4.x17/a_27_47# dc_inst.x6.net6 0
C4459 dc_inst.x1.x5/a_27_47# _15_/a_872_316# 0
C4460 dc_inst.x1.net5 _15_/a_788_316# 0
C4461 tdi rst 0.19219f
C4462 path_sel[1] path[5] 0.00241f
C4463 VPWR dc_inst.x4.net1 0.10976f
C4464 dc_inst.x7.x3/a_27_47# dc_inst.x3.net17 0
C4465 dc_inst.x7.net4 dc_inst.x8/a_27_413# 0
C4466 dc_inst.x7.x8/a_27_47# dc_inst.x7.net8 0.12789f
C4467 dc_inst.x7.net9 dc_inst.x7.x7/a_27_47# 0
C4468 dc_inst.x7.net12 _25_/a_1217_47# 0
C4469 dc_inst.x7.x1/a_27_47# dc_inst.net4 0.01889f
C4470 dc_inst.x7.net14 dc_inst.x7.net7 0
C4471 dc_inst.x1.net2 dc_inst.x3.x16/a_27_47# 0
C4472 dc_inst.x6.net16 dc_inst.x6.x19/a_27_47# 0
C4473 dc_inst.x1.net4 dc_inst.x5.x12/a_27_47# 0
C4474 dc_inst.x5.net12 dc_inst.x5.net2 0.0055f
C4475 dc_inst.x4.net15 dc_inst.x5.x14/a_27_47# 0
C4476 tdo shadow_q 0
C4477 dc_inst.x4.net4 dc_inst.x2.x3/a_27_47# 0
C4478 dc_inst.x4.net1 path_sel[2] 0
C4479 dc_inst.x7.net1 dc_inst.x9/a_1290_413# 0
C4480 dc_inst.x4.net3 dc_inst.x6.net14 0
C4481 VPWR dc_inst.x7.net6 0.00322f
C4482 clkbuf_0_clk/a_110_47# dc_inst.net7 0
C4483 _04_ path[4] 0.00869f
C4484 path_sel[2] dc_inst.x7.net6 0.00478f
C4485 dc_inst.x5.net19 dc_inst.x7.net5 0
C4486 dc_inst.x4.net14 dc_inst.x5.net9 0
C4487 dc_inst.x4.net15 dc_inst.x5.net8 0
C4488 dc_inst.x4.x17/a_27_47# dc_inst.x4.net15 0
C4489 dc_inst.x10/a_439_47# dc_inst.in 0
C4490 _24_/a_543_47# clknet_1_1__leaf_clk 0.03011f
C4491 _24_/a_193_47# _02_ -0.00164f
C4492 dc_inst.x4.net17 dc_inst.x5.net3 0.03608f
C4493 dc_inst.x1.net13 dc_inst.x2.net1 0
C4494 path_sel[0] _20_/a_384_47# 0.00984f
C4495 dc_inst.x5.net15 dc_inst.x4.net12 0.0029f
C4496 dc_inst.x4.net5 dc_inst.x1.x7/a_27_47# 0
C4497 _10_ dc_inst.x1.net8 0
C4498 delay_sel[2] _01_ 0.21392f
C4499 dc_inst.net6 dc_inst.x7.net19 0
C4500 dc_inst.x9/a_923_363# dc_inst.x7.net17 0
C4501 path[3] _15_/a_1279_413# 0
C4502 dc_inst.x1.net1 dc_inst.x5.x12/a_27_47# 0.00144f
C4503 dc_inst.x1.x7/a_27_47# dc_inst.x1.net8 0.00259f
C4504 dc_inst.net3 dc_inst.x8/a_1478_413# 0.05782f
C4505 VPWR dc_inst.x5.net14 0.2586f
C4506 dc_inst.x7.x3/a_27_47# dc_inst.x2.x19/a_27_47# 0
C4507 dc_inst.x4.net14 dc_inst.x4.x12/a_27_47# 0
C4508 dc_inst.x1.net3 path_sel[0] 0.04931f
C4509 dc_inst.x7.net4 dc_inst.x8/a_668_97# 0.00755f
C4510 VPWR dc_inst.x5.x13/a_27_47# 0.00151f
C4511 dc_inst.x2.net16 dc_inst.x2.x20/a_27_47# 0
C4512 dc_inst.x9/a_247_21# dc_inst.x7.net18 0
C4513 dc_inst.x7.net14 rst 0
C4514 dc_inst.x4.net13 dc_inst.x5.x8/a_27_47# 0
C4515 dc_inst.x1.x4/a_27_47# path_sel[1] 0.01131f
C4516 _14_/a_76_199# dc_inst.x3.net8 0
C4517 dc_inst.net9 _23_/a_193_47# 0
C4518 dc_inst.x3.x3/a_27_47# dc_inst.x3.net19 0
C4519 dc_inst.x5.net14 path_sel[2] 0
C4520 VPWR _20_/a_79_21# 0.00677f
C4521 tdi dc_inst.x3.net9 0
C4522 dc_inst.x2.x20/a_27_47# dc_inst.net2 0.00869f
C4523 dc_inst.x5.net10 _16_/a_27_93# 0
C4524 dc_inst.x7.net1 delay_sel[0] 0.03034f
C4525 dc_inst.x3.net16 dc_inst.x8/a_750_97# 0
C4526 path_sel[2] _20_/a_79_21# 0.01731f
C4527 dc_inst.x5.net19 dc_inst.x6.x10/a_27_47# 0
C4528 dc_inst.x5.x8/a_27_47# dc_inst.x4.x5/a_27_47# 0
C4529 dc_inst.x1.net17 dc_inst.x4.x5/a_27_47# 0
C4530 dc_inst.x1.net4 dc_inst.x1.net10 0
C4531 se dc_inst.x3.net3 0.00167f
C4532 dc_inst.x2.net10 path_sel[0] 0
C4533 dc_inst.x9/a_1290_413# _03_ 0
C4534 dc_inst.x4.x2/a_27_47# dc_inst.x5.net6 0
C4535 _00_ _24_/a_543_47# 0.02975f
C4536 _25_/a_1283_21# clknet_1_1__leaf_clk 0.01408f
C4537 dc_inst.x7.x14/a_27_47# clknet_1_0__leaf_clk 0
C4538 dc_inst.x7.net14 clkbuf_1_0__f_clk/a_110_47# 0.00663f
C4539 VPWR dc_inst.x1.net2 0.10141f
C4540 dc_inst.x3.net8 dc_inst.x3.net14 0.08559f
C4541 _24_/a_1462_47# _02_ 0
C4542 dc_inst.x5.net4 path_sel[0] 0.00153f
C4543 dc_inst.x4.x12/a_27_47# dc_inst.x4.x13/a_27_47# 0.02448f
C4544 dc_inst.x7.x15/a_27_47# dc_inst.x9/a_27_413# 0
C4545 path[5] dc_inst.x3.net16 0
C4546 path[7] dc_inst.x3.net17 0
C4547 dc_inst.x2.net19 _15_/a_288_47# 0
C4548 dc_inst.x1.x16/a_27_47# dc_inst.in 0
C4549 clkload0/X delay_sel[2] 0.00363f
C4550 dc_inst.x4.x3/a_27_47# dc_inst.x2.net6 0
C4551 path_sel[1] dc_inst.x1.x9/a_27_47# 0.00607f
C4552 dc_inst.x1.net4 dc_inst.x2.x20/a_27_47# 0
C4553 dc_inst.x1.net2 path_sel[2] 0.32507f
C4554 dc_inst.x5.net16 dc_inst.x5.x17/a_27_47# 0.01776f
C4555 dc_inst.x6.net3 dc_inst.x6.x4/a_27_47# 0
C4556 dc_inst.x2.net17 dc_inst.x2.x18/a_27_47# 0.02031f
C4557 dc_inst.x2.x17/a_27_47# dc_inst.x2.net18 0
C4558 delay_sel[1] dc_inst.x3.net14 0
C4559 dc_inst.x2.net8 dc_inst.x4.net10 0.00985f
C4560 dc_inst.x1.net11 _19_/a_109_297# 0.01456f
C4561 dc_inst.x4.net13 dc_inst.x5.net12 0
C4562 dc_inst.x2.x7/a_27_47# dc_inst.x5.net7 0.00227f
C4563 dc_inst.x7.net13 dc_inst.x9/a_277_47# 0
C4564 dc_inst.x7.net13 clknet_1_0__leaf_clk 0.00332f
C4565 dc_inst.x2.net15 dc_inst.x8/a_1290_413# 0
C4566 dc_inst.x1.net15 VPWR 0.57728f
C4567 VPWR dc_inst.x3.x11/a_27_47# 0.0144f
C4568 _24_/a_1283_21# rst 0
C4569 _24_/a_761_289# _01_ 0
C4570 dc_inst.x5.net7 dc_inst.x6.net10 0.0089f
C4571 dc_inst.x1.net10 dc_inst.x1.net9 0.00338f
C4572 dc_inst.x3.net9 path_sel[0] 0
C4573 dc_inst.x6.net10 dc_inst.x4.x6/a_27_47# 0.00161f
C4574 delay_sel[1] dc_inst.x7.net9 0
C4575 delay_sel[0] dc_inst.x7.x18/a_27_47# 0
C4576 dc_inst.x1.net17 dc_inst.x2.x2/a_27_47# 0
C4577 dc_inst.x1.net10 dc_inst.x1.net1 0.0144f
C4578 dc_inst.x10/a_76_199# delay_sel[1] 0
C4579 delay_sel[2] dc_inst.x7.net16 0
C4580 dc_inst.net5 dc_inst.x7.net5 0.2686f
C4581 dc_inst.x5.net6 dc_inst.x6.net1 0
C4582 dc_inst.x2.net14 dc_inst.x4.x5/a_27_47# 0
C4583 dc_inst.x4.net4 dc_inst.x2.x18/a_27_47# 0
C4584 dc_inst.x4.x3/a_27_47# dc_inst.x2.net18 0.03673f
C4585 dc_inst.x1.net15 path_sel[2] 0.06904f
C4586 delay_sel[2] dc_inst.x3.net3 0
C4587 path_sel[1] dc_inst.x5.net11 0.08975f
C4588 dc_inst.x3.net2 path_sel[0] 0
C4589 dc_inst.x2.net18 delay_sel[1] 0
C4590 dc_inst.x3.x17/a_27_47# dc_inst.net2 0.0031f
C4591 path[2] dc_inst.x5.x12/a_27_47# 0
C4592 _24_/a_193_47# clknet_0_clk 0
C4593 _05_ dc_inst.x3.net8 0.06699f
C4594 dc_inst.x3.net8 dc_inst.x3.x15/a_27_47# 0
C4595 dc_inst.x3.x7/a_27_47# dc_inst.x3.net15 0
C4596 delay_sel[0] _03_ 0
C4597 _25_/a_27_47# tdo 0
C4598 _25_/a_1283_21# _00_ 0.04655f
C4599 dc_inst.x7.net14 dc_inst.x9/a_27_47# 0
C4600 dc_inst.x1.net17 dc_inst.net1 0.13467f
C4601 tdo _24_/a_805_47# 0
C4602 dc_inst.x5.net13 dc_inst.x5.net16 0
C4603 dc_inst.x5.net14 dc_inst.x5.net15 0.01842f
C4604 dc_inst.x4.x11/a_27_47# dc_inst.x4.x12/a_27_47# 0
C4605 dc_inst.x2.net7 dc_inst.x4.x9/a_27_47# 0
C4606 dc_inst.x4.net13 dc_inst.x2.x8/a_27_47# 0
C4607 dc_inst.x1.net10 _18_/a_76_199# 0
C4608 dc_inst.x1.net17 dc_inst.x6.x18/a_27_47# 0
C4609 dc_inst.x7.net15 dc_inst.x7.x16/a_27_47# 0.13602f
C4610 dc_inst.x2.x19/a_27_47# path[7] 0
C4611 dc_inst.x5.net12 dc_inst.x1.x8/a_27_47# 0
C4612 path[6] dc_inst.x3.net12 0
C4613 path[7] dc_inst.x3.net11 0.03057f
C4614 path[4] dc_inst.x3.x12/a_27_47# 0.01682f
C4615 VPWR dc_inst.x9/a_1290_413# -0.0265f
C4616 dc_inst.x1.net18 dc_inst.x1.net16 0.01639f
C4617 dc_inst.x6.x8/a_27_47# dc_inst.x5.net17 0
C4618 dc_inst.x4.net11 dc_inst.x5.net12 0
C4619 dc_inst.x2.net14 dc_inst.x2.x2/a_27_47# 0
C4620 dc_inst.x6.net4 dc_inst.x9/a_277_47# 0
C4621 dc_inst.x5.x19/a_27_47# dc_inst.x6.net8 0.01947f
C4622 dc_inst.x1.net3 dc_inst.x1.net7 0.00705f
C4623 dc_inst.x1.net2 dc_inst.x1.net8 0
C4624 dc_inst.net6 dc_inst.x7.net17 0.00809f
C4625 VPWR dc_inst.x3.net19 0.0214f
C4626 _23_/a_27_47# dc_inst.x8/a_668_97# 0
C4627 _23_/a_1283_21# dc_inst.x8/a_1290_413# 0
C4628 dc_inst.x3.net5 dc_inst.x7.net4 0
C4629 tdo dc_inst.x1.x17/a_27_47# 0
C4630 dc_inst.x5.net12 dc_inst.x2.x2/a_27_47# 0
C4631 dc_inst.x3.x1/a_27_47# dc_inst.x3.net17 0.00159f
C4632 path_sel[2] dc_inst.x9/a_1290_413# 0
C4633 dc_inst.x6.x16/a_27_47# dc_inst.x9/a_1290_413# 0
C4634 _25_/a_1108_47# rst 0.00256f
C4635 clknet_1_1__leaf_clk rst 0.70232f
C4636 dc_inst.x6.net17 dc_inst.in 0.02785f
C4637 dc_inst.x1.net19 dc_inst.x2.x1/a_27_47# 0.0013f
C4638 dc_inst.x2.x5/a_27_47# dc_inst.x5.net7 0
C4639 dc_inst.x4.x3/a_27_47# dc_inst.net8 0
C4640 path_sel[2] dc_inst.x3.net19 0
C4641 dc_inst.x6.x1/a_27_47# dc_inst.x6.net10 0
C4642 dc_inst.net5 dc_inst.x6.x10/a_27_47# 0
C4643 dc_inst.x3.x4/a_27_47# dc_inst.x3.net16 0.00107f
C4644 dc_inst.net8 delay_sel[1] 0.00627f
C4645 dc_inst.x2.x16/a_27_47# dc_inst.x2.x19/a_27_47# 0
C4646 delay_sel[2] dc_inst.net9 0.00232f
C4647 dc_inst.x1.net15 dc_inst.x4.net5 0.0176f
C4648 dc_inst.x7.net3 dc_inst.x3.net16 0
C4649 dc_inst.x2.net14 dc_inst.net1 0
C4650 dc_inst.x1.x19/a_27_47# dc_inst.x1.net18 0.03428f
C4651 path[5] _23_/a_1108_47# 0
C4652 _09_ path_sel[1] 0.02114f
C4653 dc_inst.x1.net15 dc_inst.x1.net8 0.03083f
C4654 path_sel[0] _15_/a_27_47# -0.00469f
C4655 dc_inst.x5.net19 dc_inst.x7.net9 0.06838f
C4656 dc_inst.x6.net15 dc_inst.x9/a_1290_413# 0.00113f
C4657 dc_inst.x4.net2 dc_inst.x4.x4/a_27_47# 0.00704f
C4658 dc_inst.x6.net2 dc_inst.x5.x20/a_27_47# 0
C4659 _25_/a_761_289# clknet_0_clk 0.00604f
C4660 _25_/a_193_47# dc_inst.x9/a_247_21# 0
C4661 _25_/a_27_47# clknet_1_0__leaf_clk 0.03665f
C4662 _13_/a_470_297# dc_inst.x3.net18 0
C4663 dc_inst.x6.x19/a_27_47# dc_inst.x9/a_750_97# 0
C4664 _24_/a_1283_21# dc_inst.x3.net2 0
C4665 dc_inst.x1.net6 path_sel[1] 0
C4666 _14_/a_535_374# path[5] 0
C4667 _25_/a_1217_47# tdo 0
C4668 dc_inst.x2.x11/a_27_47# dc_inst.x2.net11 0.01506f
C4669 dc_inst.x6.net8 dc_inst.x5.net6 0
C4670 dc_inst.x3.net6 dc_inst.x3.x7/a_27_47# 0.12378f
C4671 VPWR dc_inst.x2.x12/a_27_47# -0.00377f
C4672 dc_inst.x1.net10 path[2] 0
C4673 dc_inst.x6.x8/a_27_47# dc_inst.x5.net12 0
C4674 dc_inst.x4.x9/a_27_47# dc_inst.x5.net3 0
C4675 _15_/a_788_316# dc_inst.x3.x13/a_27_47# 0
C4676 _02_ dc_inst.x3.x11/a_27_47# 0.00609f
C4677 dc_inst.x7.net7 dc_inst.x7.x7/a_27_47# 0.12789f
C4678 VPWR delay_sel[0] 1.70302f
C4679 dc_inst.x9/a_193_413# dc_inst.x7.net6 0
C4680 path_sel[2] dc_inst.x2.x12/a_27_47# 0
C4681 dc_inst.x10/a_76_199# dc_inst.x8/a_27_47# 0
C4682 _00_ rst 0.13068f
C4683 path_sel[2] delay_sel[0] 0.0663f
C4684 dc_inst.x4.net2 dc_inst.x1.x1/a_27_47# 0
C4685 dc_inst.x1.net13 path_sel[1] 0
C4686 dc_inst.x4.x10/a_27_47# dc_inst.x5.net9 0
C4687 _19_/a_27_47# _15_/a_600_345# 0
C4688 dc_inst.x5.net19 dc_inst.x5.net2 0
C4689 tdo dc_inst.x4.x18/a_27_47# 0
C4690 dc_inst.x6.net7 dc_inst.x4.net9 0
C4691 dc_inst.x5.net9 dc_inst.x2.x9/a_27_47# 0
C4692 _18_/a_505_21# _09_ 0
C4693 dc_inst.x1.net10 dc_inst.x2.net15 0
C4694 dc_inst.x4.net3 path_sel[1] 0
C4695 dc_inst.x5.x3/a_27_47# dc_inst.x5.net9 0.02959f
C4696 dc_inst.x2.x10/a_27_47# dc_inst.x5.x9/a_27_47# 0.01224f
C4697 dc_inst.x1.net6 _18_/a_505_21# 0
C4698 path[6] shadow_q 0.10742f
C4699 path_sel[0] _15_/a_1064_47# -0
C4700 dc_inst.x6.net15 delay_sel[0] 0
C4701 dc_inst.net7 dc_inst.x6.net11 0
C4702 path[5] dc_inst.x3.x16/a_27_47# 0
C4703 _25_/a_543_47# dc_inst.x9/a_668_97# 0
C4704 _00_ clkbuf_1_0__f_clk/a_110_47# 0.01666f
C4705 dc_inst.x4.net1 dc_inst.x4.x7/a_27_47# 0
C4706 _24_/a_448_47# delay_sel[0] 0
C4707 dc_inst.x1.x5/a_27_47# dc_inst.x1.net5 0.01301f
C4708 dc_inst.x2.x20/a_27_47# dc_inst.x2.net15 0
C4709 dc_inst.x6.x17/a_27_47# delay_sel[1] 0.0012f
C4710 dc_inst.x6.net18 dc_inst.in 0.02938f
C4711 dc_inst.x3.net5 _23_/a_27_47# 0
C4712 dc_inst.x6.x2/a_27_47# dc_inst.x6.net4 0
C4713 dc_inst.x6.net3 dc_inst.x6.x3/a_27_47# 0.04974f
C4714 dc_inst.x7.net13 dc_inst.x7.x12/a_27_47# 0
C4715 dc_inst.x7.net3 _23_/a_1108_47# 0.00172f
C4716 dc_inst.x2.net9 dc_inst.x5.net9 0
C4717 dc_inst.x2.net10 dc_inst.x2.net14 0
C4718 tdo dc_inst.in 0.47942f
C4719 dc_inst.x3.x9/a_27_47# path[4] 0
C4720 dc_inst.x5.net9 dc_inst.x5.net1 0.13966f
C4721 dc_inst.x2.net10 dc_inst.x5.net12 0.04018f
C4722 dc_inst.x2.net16 dc_inst.x2.net18 0
C4723 dc_inst.net8 dc_inst.x8/a_27_47# 0.00108f
C4724 dc_inst.x4.x14/a_27_47# dc_inst.x4.net13 0.01851f
C4725 dc_inst.x7.x11/a_27_47# dc_inst.x7.net1 0.01241f
C4726 dc_inst.x7.net3 dc_inst.x7.net1 0
C4727 dc_inst.x6.x1/a_27_47# dc_inst.x7.x18/a_27_47# 0
C4728 dc_inst.x3.net6 _15_/a_872_316# 0
C4729 dc_inst.x3.net7 _15_/a_600_345# 0
C4730 delay_sel[0] dc_inst.x4.net5 0
C4731 dc_inst.x5.net4 dc_inst.x5.net12 0.00328f
C4732 dc_inst.x5.x3/a_27_47# dc_inst.x2.x9/a_27_47# 0.01224f
C4733 dc_inst.net5 dc_inst.x7.net9 0
C4734 dc_inst.x2.net18 dc_inst.net2 0.02076f
C4735 dc_inst.x5.x18/a_27_47# dc_inst.x6.net11 0
C4736 _09_ path[3] 0.00176f
C4737 dc_inst.x1.net4 dc_inst.x3.net14 0.00154f
C4738 dc_inst.x1.x16/a_27_47# dc_inst.x5.net6 0.00103f
C4739 _15_/a_27_47# dc_inst.x1.net7 0
C4740 dc_inst.x2.net19 path_sel[1] 0
C4741 _00_ dc_inst.x3.net9 0
C4742 _19_/a_27_47# dc_inst.x1.x6/a_27_47# 0.00585f
C4743 dc_inst.x1.net6 path[3] 0.04236f
C4744 dc_inst.x6.net8 dc_inst.x7.net10 0
C4745 dc_inst.x6.net3 dc_inst.x6.net11 0
C4746 dc_inst.x1.net12 _15_/a_600_345# 0
C4747 dc_inst.x2.x20/a_27_47# _23_/a_1283_21# 0
C4748 _25_/a_1283_21# delay_sel[1] 0
C4749 _00_ dc_inst.x3.net2 0
C4750 dc_inst.x4.net1 dc_inst.x2.net12 0
C4751 _02_ delay_sel[0] 0
C4752 VPWR dc_inst.x8/a_750_97# -0.19511f
C4753 dc_inst.x1.net4 dc_inst.x2.net18 0.00475f
C4754 dc_inst.x2.x17/a_27_47# dc_inst.net1 0
C4755 dc_inst.x2.net9 dc_inst.x2.x9/a_27_47# 0.12862f
C4756 dc_inst.x2.x8/a_27_47# dc_inst.x2.net10 0.00134f
C4757 VPWR dc_inst.x4.x6/a_27_47# 0.00173f
C4758 VPWR dc_inst.x5.net7 0.93075f
C4759 dc_inst.x7.net2 dc_inst.x6.x19/a_27_47# 0.01192f
C4760 dc_inst.x2.net10 dc_inst.x5.x10/a_27_47# 0
C4761 dc_inst.x6.x2/a_27_47# dc_inst.x5.x17/a_27_47# 0
C4762 dc_inst.x3.x3/a_27_47# dc_inst.x3.x4/a_27_47# 0
C4763 dc_inst.x5.net9 dc_inst.x4.net7 0
C4764 dc_inst.x5.net8 dc_inst.x4.net8 0
C4765 path_sel[2] dc_inst.x8/a_750_97# 0
C4766 dc_inst.x7.net3 dc_inst.x3.x3/a_27_47# 0
C4767 dc_inst.x5.x3/a_27_47# dc_inst.x2.net9 0
C4768 clknet_1_0__leaf_clk dc_inst.in 0.00808f
C4769 dc_inst.x5.net4 dc_inst.x5.x10/a_27_47# 0.00267f
C4770 dc_inst.x5.x3/a_27_47# dc_inst.x5.net1 0
C4771 dc_inst.x6.net9 dc_inst.x5.net2 0
C4772 dc_inst.x4.x17/a_27_47# dc_inst.x4.net8 0.00108f
C4773 dc_inst.x7.net3 dc_inst.x7.x18/a_27_47# 0.00142f
C4774 dc_inst.x7.x2/a_27_47# dc_inst.x7.net18 0
C4775 dc_inst.x6.x16/a_27_47# dc_inst.x4.x6/a_27_47# 0
C4776 path_sel[2] dc_inst.x4.x6/a_27_47# 0.00518f
C4777 dc_inst.x5.net7 path_sel[2] 0.00411f
C4778 dc_inst.x7.x2/a_27_47# capture_d 0
C4779 _04_ dc_inst.x3.net14 0
C4780 _17_/a_174_21# _16_/a_27_93# 0.00254f
C4781 delay_sel[1] dc_inst.x7.net7 0
C4782 dc_inst.x2.x16/a_27_47# dc_inst.x1.x16/a_27_47# 0
C4783 dc_inst.x1.net19 dc_inst.x1.net14 0
C4784 VPWR path[5] 0.31985f
C4785 dc_inst.net8 dc_inst.net2 0.04354f
C4786 dc_inst.x3.net6 path[7] 0
C4787 dc_inst.x7.x1/a_27_47# dc_inst.x7.net6 0.00257f
C4788 dc_inst.net6 dc_inst.x7.x6/a_27_47# 0
C4789 dc_inst.x4.x3/a_27_47# dc_inst.net1 0
C4790 dc_inst.x1.net19 dc_inst.x6.x14/a_27_47# 0
C4791 dc_inst.x6.net5 dc_inst.x7.x4/a_27_47# 0
C4792 dc_inst.x3.net7 path[6] 0.00137f
C4793 dc_inst.x4.x2/a_27_47# dc_inst.x4.net2 0.01556f
C4794 delay_sel[1] dc_inst.net1 0.10981f
C4795 dc_inst.x1.net15 dc_inst.x1.x14/a_27_47# 0.04037f
C4796 dc_inst.x7.net3 _03_ 0
C4797 dc_inst.x2.net18 dc_inst.x1.net9 0
C4798 _24_/a_1283_21# dc_inst.x8/a_1478_413# 0
C4799 _24_/a_27_47# dc_inst.x8/a_834_97# 0
C4800 dc_inst.x6.x18/a_27_47# delay_sel[1] 0
C4801 dc_inst.x3.net12 dc_inst.x3.x10/a_27_47# 0.00552f
C4802 dc_inst.x9/a_277_47# dc_inst.x9/a_757_363# -0
C4803 _25_/a_27_47# dc_inst.x7.x12/a_27_47# 0
C4804 dc_inst.x9/a_247_21# dc_inst.x9/a_750_97# -0.00559f
C4805 dc_inst.x1.net12 path[6] 0
C4806 dc_inst.x6.x20/a_27_47# dc_inst.x6.net13 0
C4807 dc_inst.x1.net4 dc_inst.net8 0
C4808 dc_inst.x4.x10/a_27_47# dc_inst.x4.net7 0
C4809 dc_inst.x3.net16 _23_/a_193_47# 0
C4810 dc_inst.x6.net17 dc_inst.x5.net6 0
C4811 dc_inst.x1.net12 dc_inst.x1.x6/a_27_47# 0
C4812 dc_inst.x5.net16 dc_inst.x5.x19/a_27_47# 0.00133f
C4813 _19_/a_27_47# _17_/a_27_93# 0
C4814 VPWR dc_inst.x6.x1/a_27_47# 0.0032f
C4815 dc_inst.x1.x2/a_27_47# dc_inst.x2.net17 0
C4816 rst dc_inst.x3.net8 0
C4817 dc_inst.x7.net12 dc_inst.x7.net10 0.00273f
C4818 dc_inst.x4.x16/a_27_47# path_sel[0] 0.00239f
C4819 dc_inst.x4.net5 dc_inst.x8/a_750_97# 0
C4820 dc_inst.x1.x17/a_27_47# dc_inst.x5.net5 0
C4821 dc_inst.x5.net7 dc_inst.x4.net5 0
C4822 dc_inst.x6.x20/a_27_47# dc_inst.x6.net12 0
C4823 path[0] path_sel[0] 0.11095f
C4824 dc_inst.x6.x1/a_27_47# path_sel[2] 0.00583f
C4825 rst delay_sel[1] 0
C4826 dc_inst.x5.net6 dc_inst.x4.net6 0.2803f
C4827 dc_inst.x4.net2 dc_inst.x2.x19/a_27_47# 0.00142f
C4828 dc_inst.x1.x15/a_27_47# path_sel[0] 0
C4829 dc_inst.x6.net7 path_sel[1] 0.02273f
C4830 dc_inst.x4.x17/a_27_47# dc_inst.x7.net2 0
C4831 dc_inst.x1.x4/a_27_47# VPWR 0.01128f
C4832 dc_inst.x5.net19 dc_inst.x7.net7 0.01108f
C4833 dc_inst.net8 dc_inst.x1.net9 0
C4834 dc_inst.x1.net3 delay_sel[1] 0
C4835 dc_inst.x1.x19/a_27_47# dc_inst.x5.x5/a_27_47# 0
C4836 delay_sel[0] dc_inst.x6.x15/a_27_47# 0
C4837 dc_inst.x1.x4/a_27_47# path_sel[2] 0.01588f
C4838 dc_inst.x1.net2 _15_/a_372_413# 0
C4839 dc_inst.x9/a_193_413# delay_sel[0] 0.02625f
C4840 clknet_0_clk delay_sel[0] 0
C4841 clkbuf_1_0__f_clk/a_110_47# delay_sel[1] 0.00532f
C4842 dc_inst.x1.net15 dc_inst.x2.net12 0
C4843 VPWR dc_inst.x3.x4/a_27_47# 0.00214f
C4844 dc_inst.x1.net17 dc_inst.x1.x18/a_27_47# 0.0426f
C4845 dc_inst.x7.x11/a_27_47# VPWR 0.05651f
C4846 dc_inst.x7.net3 VPWR 0.14144f
C4847 dc_inst.x5.net7 dc_inst.x2.net2 0.16557f
C4848 dc_inst.net5 dc_inst.x6.x17/a_27_47# 0.00594f
C4849 dc_inst.x5.x20/a_27_47# dc_inst.x7.net4 0.00106f
C4850 dc_inst.x5.net6 dc_inst.x2.net3 0.00626f
C4851 _02_ path[5] 0.00774f
C4852 dc_inst.x4.net16 dc_inst.x6.x17/a_27_47# 0
C4853 _19_/a_193_297# _08_ 0.01026f
C4854 dc_inst.x6.x8/a_27_47# dc_inst.x5.net19 0.05771f
C4855 dc_inst.x5.x7/a_27_47# dc_inst.x5.net9 0.02951f
C4856 dc_inst.x4.net16 dc_inst.x4.net13 0.06707f
C4857 VPWR dc_inst.x1.x9/a_27_47# 0.01697f
C4858 dc_inst.x4.net17 dc_inst.x4.net9 0.00422f
C4859 dc_inst.net1 dc_inst.x8/a_27_47# 0.00127f
C4860 dc_inst.x6.x1/a_27_47# dc_inst.x4.net5 0
C4861 _15_/a_600_345# dc_inst.in 0
C4862 path_sel[2] dc_inst.x1.x9/a_27_47# 0.00523f
C4863 dc_inst.x5.net13 dc_inst.x5.x15/a_27_47# 0
C4864 dc_inst.x3.net8 dc_inst.x3.net9 0
C4865 dc_inst.x6.x18/a_27_47# dc_inst.x8/a_27_47# 0
C4866 dc_inst.x2.net7 dc_inst.x2.net4 0
C4867 dc_inst.x9/a_1478_413# dc_inst.x6.net14 0
C4868 _23_/a_193_47# _23_/a_1108_47# 0
C4869 _23_/a_27_47# _23_/a_448_47# -0.00373f
C4870 dc_inst.x5.net6 dc_inst.x6.net18 0
C4871 VPWR dc_inst.x5.net11 0.02288f
C4872 dc_inst.x6.net2 dc_inst.x9/a_247_21# 0
C4873 dc_inst.net3 path_sel[0] 0
C4874 dc_inst.x1.net16 dc_inst.x6.net13 0
C4875 dc_inst.x1.net3 _15_/a_1281_47# 0
C4876 dc_inst.x5.x20/a_27_47# dc_inst.net4 0
C4877 dc_inst.net7 dc_inst.x7.net16 0
C4878 dc_inst.x9/a_834_97# delay_sel[0] 0
C4879 dc_inst.x3.net12 dc_inst.x3.x14/a_27_47# 0.1104f
C4880 dc_inst.x3.x12/a_27_47# dc_inst.x3.net14 0
C4881 dc_inst.x9/a_1478_413# dc_inst.net9 0.00163f
C4882 dc_inst.x9/a_27_47# delay_sel[1] 0.06914f
C4883 dc_inst.x9/a_668_97# dc_inst.net7 0.00572f
C4884 dc_inst.x2.net18 dc_inst.x2.net15 0.00488f
C4885 dc_inst.x3.x9/a_27_47# dc_inst.x3.net1 0.00293f
C4886 tdo dc_inst.x5.net6 0.0545f
C4887 dc_inst.x1.x4/a_27_47# dc_inst.x1.net8 0.00894f
C4888 dc_inst.x3.net2 delay_sel[1] 0
C4889 dc_inst.x4.x10/a_27_47# dc_inst.x5.x7/a_27_47# 0
C4890 path_sel[2] dc_inst.x5.net11 0.0013f
C4891 dc_inst.x3.net4 dc_inst.x3.net17 0.09037f
C4892 dc_inst.net6 dc_inst.x9/a_923_363# 0
C4893 dc_inst.x7.net2 dc_inst.x9/a_247_21# 0
C4894 dc_inst.in dc_inst.x8/a_247_21# 0.00692f
C4895 delay_sel[2] dc_inst.x3.net16 0
C4896 _15_/a_372_413# dc_inst.x3.net19 0
C4897 dc_inst.x5.net19 clkbuf_1_0__f_clk/a_110_47# 0
C4898 dc_inst.x1.x5/a_27_47# _19_/a_109_297# 0
C4899 dc_inst.x4.net16 dc_inst.x4.net11 0.02162f
C4900 dc_inst.x2.net16 dc_inst.net1 0
C4901 _10_ _08_ 0.05861f
C4902 dc_inst.x7.x20/a_27_47# dc_inst.x9/a_1290_413# 0.00361f
C4903 _08_ dc_inst.x1.x7/a_27_47# 0
C4904 dc_inst.x1.net19 dc_inst.x6.x13/a_27_47# 0
C4905 dc_inst.x1.net4 dc_inst.x1.x8/a_27_47# 0.00606f
C4906 dc_inst.net5 dc_inst.x7.net7 0
C4907 dc_inst.x1.x15/a_27_47# dc_inst.x1.net7 0.01236f
C4908 dc_inst.x1.x9/a_27_47# dc_inst.x4.net5 0
C4909 _14_/a_76_199# _13_/a_112_47# 0
C4910 path[6] dc_inst.in 0.00136f
C4911 dc_inst.x6.x5/a_27_47# dc_inst.x4.net19 0
C4912 dc_inst.x7.net14 dc_inst.x7.x19/a_27_47# 0.17563f
C4913 dc_inst.x1.x9/a_27_47# dc_inst.x1.net8 0.00597f
C4914 dc_inst.x2.x12/a_27_47# dc_inst.x2.net12 0.00374f
C4915 dc_inst.x6.net19 dc_inst.x7.net5 0.00388f
C4916 dc_inst.x9/a_1290_413# dc_inst.x8/a_27_413# 0
C4917 dc_inst.x9/a_750_97# dc_inst.x8/a_193_413# 0
C4918 _02_ dc_inst.x3.x4/a_27_47# 0
C4919 dc_inst.x9/a_757_363# dc_inst.x8/a_247_21# 0
C4920 dc_inst.x10/a_505_21# _23_/a_543_47# 0
C4921 dc_inst.x1.net19 dc_inst.x6.x12/a_27_47# 0
C4922 dc_inst.x7.net3 _02_ 0
C4923 dc_inst.x3.x7/a_27_47# _15_/a_600_345# 0
C4924 dc_inst.x3.x18/a_27_47# dc_inst.x3.net19 0
C4925 dc_inst.x2.net18 _23_/a_1283_21# 0
C4926 VPWR _09_ 0.16016f
C4927 dc_inst.x3.x16/a_27_47# _23_/a_193_47# 0
C4928 dc_inst.x4.x20/a_27_47# dc_inst.x4.net19 0.01436f
C4929 dc_inst.x6.x8/a_27_47# dc_inst.x6.net9 0.04365f
C4930 dc_inst.x6.x8/a_27_47# dc_inst.net5 0
C4931 dc_inst.net7 dc_inst.net9 0.00275f
C4932 dc_inst.x7.net13 dc_inst.x7.net19 0
C4933 _13_/a_112_47# dc_inst.x3.net14 0
C4934 dc_inst.x1.net9 dc_inst.x1.x8/a_27_47# 0.00366f
C4935 dc_inst.x6.net6 dc_inst.x6.net1 0.02768f
C4936 dc_inst.x1.net6 VPWR 0.16247f
C4937 clkbuf_1_1__f_clk/a_110_47# dc_inst.x3.x17/a_27_47# 0
C4938 dc_inst.x3.x6/a_27_47# dc_inst.x3.net1 0.12214f
C4939 dc_inst.x2.net6 dc_inst.x2.net7 0.00295f
C4940 path_sel[2] _09_ 0
C4941 dc_inst.x1.net16 path_sel[1] 0
C4942 dc_inst.x7.x1/a_27_47# delay_sel[0] 0
C4943 _23_/a_193_47# _03_ 0
C4944 dc_inst.x5.net11 dc_inst.x1.net8 0.00303f
C4945 dc_inst.x7.x10/a_27_47# dc_inst.x5.x20/a_27_47# 0.01771f
C4946 dc_inst.x6.net11 dc_inst.x7.net5 0
C4947 dc_inst.x6.x19/a_27_47# dc_inst.x7.net4 0.02961f
C4948 _14_/a_505_21# tdi 0.03354f
C4949 _14_/a_535_374# se 0.00105f
C4950 dc_inst.x1.net6 path_sel[2] 0.00154f
C4951 rst dc_inst.net2 0
C4952 dc_inst.x6.x5/a_27_47# dc_inst.x6.net6 0.01725f
C4953 dc_inst.x1.x3/a_27_47# _15_/a_600_345# 0
C4954 dc_inst.x4.net4 dc_inst.x2.net17 0.00137f
C4955 dc_inst.x4.net17 dc_inst.x6.net12 0
C4956 _14_/a_218_374# _05_ 0
C4957 se _13_/a_27_297# 0
C4958 dc_inst.x1.net3 dc_inst.net2 0
C4959 dc_inst.x1.x17/a_27_47# dc_inst.x2.net5 0
C4960 dc_inst.x1.net17 dc_inst.x2.x4/a_27_47# 0
C4961 dc_inst.x6.net3 dc_inst.x6.net14 0
C4962 dc_inst.x1.x19/a_27_47# path_sel[1] 0
C4963 dc_inst.x1.net13 VPWR -0
C4964 dc_inst.x5.net7 dc_inst.x4.x7/a_27_47# 0.03348f
C4965 dc_inst.x6.x20/a_27_47# dc_inst.x6.net10 0
C4966 dc_inst.x6.net8 dc_inst.x4.net19 0
C4967 dc_inst.x6.net6 dc_inst.x4.x20/a_27_47# 0.021f
C4968 dc_inst.x9/a_1290_413# dc_inst.x8/a_668_97# 0
C4969 delay_sel[0] dc_inst.x8/a_27_413# 0.039f
C4970 dc_inst.x4.x16/a_27_47# dc_inst.x5.net12 0
C4971 delay_sel[2] _23_/a_1108_47# 0.01664f
C4972 dc_inst.net8 _23_/a_1283_21# 0
C4973 capture_d _23_/a_651_413# 0.00353f
C4974 dc_inst.x3.net2 dc_inst.x8/a_27_47# 0
C4975 dc_inst.x3.net3 dc_inst.x8/a_1290_413# 0
C4976 dc_inst.x4.net3 VPWR 0.10454f
C4977 dc_inst.x1.net13 path_sel[2] 0.01888f
C4978 dc_inst.x3.x7/a_27_47# path[6] 0.00219f
C4979 _13_/a_112_47# _05_ 0.02069f
C4980 _13_/a_112_47# dc_inst.x3.x15/a_27_47# 0
C4981 dc_inst.net5 clkbuf_1_0__f_clk/a_110_47# 0.00146f
C4982 dc_inst.x2.net13 path_sel[0] 0
C4983 delay_sel[2] dc_inst.x7.net1 0.00179f
C4984 dc_inst.x5.x4/a_27_47# dc_inst.x2.x14/a_27_47# 0
C4985 se dc_inst.x3.x3/a_27_47# 0
C4986 dc_inst.x6.x7/a_27_47# dc_inst.x5.net3 0
C4987 dc_inst.x4.net3 path_sel[2] 0.00821f
C4988 dc_inst.x4.net3 dc_inst.x6.x16/a_27_47# 0
C4989 _08_ _20_/a_79_21# 0
C4990 dc_inst.x3.x9/a_27_47# dc_inst.x3.net14 0
C4991 dc_inst.x1.net4 dc_inst.x1.net3 0.06563f
C4992 dc_inst.x6.net1 dc_inst.x6.x11/a_27_47# 0.04988f
C4993 dc_inst.x6.x10/a_27_47# dc_inst.x6.net11 0.01782f
C4994 _23_/a_1462_47# _03_ 0
C4995 se dc_inst.x3.x16/a_27_47# 0
C4996 dc_inst.x3.net3 path[4] 0
C4997 dc_inst.x2.net6 dc_inst.x5.net3 0.14692f
C4998 dc_inst.x2.net17 dc_inst.x8/a_277_47# 0
C4999 delay_sel[2] _13_/a_27_297# 0
C5000 dc_inst.x4.net17 path_sel[1] 0.04393f
C5001 dc_inst.x2.net5 dc_inst.x2.x14/a_27_47# 0.00125f
C5002 dc_inst.x2.x4/a_27_47# dc_inst.x2.net14 0
C5003 dc_inst.x3.net15 _23_/a_805_47# 0
C5004 VPWR _23_/a_193_47# 0.04702f
C5005 dc_inst.x6.x5/a_27_47# dc_inst.x6.x11/a_27_47# 0
C5006 _04_ _20_/a_384_47# 0.01778f
C5007 dc_inst.x7.x15/a_27_47# dc_inst.x7.net1 0.01839f
C5008 dc_inst.x6.x6/a_27_47# dc_inst.x4.net19 0.0218f
C5009 dc_inst.x6.net7 dc_inst.x4.x19/a_27_47# 0.00103f
C5010 dc_inst.x4.net3 dc_inst.x6.net15 0
C5011 dc_inst.x1.net17 dc_inst.net3 0
C5012 dc_inst.x4.x9/a_27_47# dc_inst.x4.net9 0.01369f
C5013 dc_inst.x6.net6 dc_inst.x6.net8 0.04306f
C5014 dc_inst.x1.x11/a_27_47# path_sel[1] 0.01114f
C5015 dc_inst.x6.net2 dc_inst.x5.net18 0
C5016 dc_inst.x7.x13/a_27_47# dc_inst.x7.net9 0.01157f
C5017 dc_inst.x7.net3 dc_inst.x6.x15/a_27_47# 0
C5018 dc_inst.x9/a_277_47# dc_inst.x7.net10 0
C5019 dc_inst.x4.net2 dc_inst.x6.net17 0
C5020 dc_inst.x5.net7 dc_inst.x2.net12 0
C5021 dc_inst.x1.net3 dc_inst.x1.net9 0
C5022 clknet_1_0__leaf_clk dc_inst.x7.net10 0
C5023 delay_sel[2] dc_inst.x3.x3/a_27_47# 0
C5024 delay_sel[2] dc_inst.x7.x18/a_27_47# 0
C5025 delay_sel[1] dc_inst.x8/a_1478_413# 0
C5026 delay_sel[0] dc_inst.x8/a_668_97# 0
C5027 dc_inst.x4.x20/a_27_47# dc_inst.x6.x11/a_27_47# 0.01198f
C5028 dc_inst.x1.net3 dc_inst.x1.net1 0
C5029 dc_inst.x7.x14/a_27_47# dc_inst.x7.net17 0
C5030 dc_inst.x1.net3 _04_ 0.04258f
C5031 dc_inst.x3.net2 dc_inst.net2 0.06877f
C5032 dc_inst.x10/a_535_374# delay_sel[2] 0
C5033 VPWR dc_inst.x2.net19 0.00996f
C5034 dc_inst.x6.x1/a_27_47# dc_inst.x9/a_834_97# 0
C5035 dc_inst.x1.net13 dc_inst.x4.net5 0
C5036 dc_inst.net5 dc_inst.x9/a_27_47# 0.00166f
C5037 _14_/a_76_199# clkbuf_1_1__f_clk/a_110_47# 0.01055f
C5038 delay_sel[2] dc_inst.x3.x16/a_27_47# 0
C5039 dc_inst.x1.net13 dc_inst.x1.net8 0.02218f
C5040 dc_inst.x2.net19 path_sel[2] 0.00124f
C5041 dc_inst.x2.x4/a_27_47# dc_inst.x2.x8/a_27_47# 0.01254f
C5042 dc_inst.x4.net3 dc_inst.x4.net5 0.00633f
C5043 _24_/a_27_47# _23_/a_651_413# 0
C5044 _24_/a_448_47# _23_/a_193_47# 0
C5045 delay_sel[2] _03_ 0
C5046 dc_inst.x2.net10 dc_inst.x1.net9 0
C5047 dc_inst.x4.net3 dc_inst.x1.net8 0
C5048 dc_inst.x7.net13 dc_inst.x7.net17 0
C5049 dc_inst.x3.x6/a_27_47# dc_inst.x3.net14 0.00889f
C5050 dc_inst.x6.x6/a_27_47# dc_inst.x6.net6 0.01239f
C5051 _25_/a_1283_21# clkbuf_0_clk/a_110_47# 0.02393f
C5052 _25_/a_193_47# clk 0
C5053 _15_/a_288_47# path[4] 0
C5054 _15_/a_600_345# path[7] 0.03374f
C5055 dc_inst.x5.net2 dc_inst.x5.net3 0.00907f
C5056 dc_inst.x1.net4 dc_inst.x3.net2 0.0886f
C5057 dc_inst.x4.x17/a_27_47# dc_inst.net4 0.00444f
C5058 dc_inst.x1.net15 dc_inst.x2.x11/a_27_47# 0
C5059 clkbuf_1_1__f_clk/a_110_47# dc_inst.x3.net14 0
C5060 dc_inst.in dc_inst.x7.x4/a_27_47# 0
C5061 dc_inst.x8/a_27_413# dc_inst.x8/a_750_97# -0
C5062 dc_inst.x6.net8 dc_inst.x6.x11/a_27_47# 0
C5063 dc_inst.x7.net12 dc_inst.x7.net18 0.02486f
C5064 dc_inst.x6.x20/a_27_47# dc_inst.x7.x18/a_27_47# 0
C5065 _24_/a_193_47# _13_/a_470_297# 0
C5066 _24_/a_27_47# _13_/a_470_47# 0
C5067 VPWR se 0.26683f
C5068 dc_inst.x3.net5 dc_inst.x3.net19 0.21284f
C5069 dc_inst.x2.net15 dc_inst.net1 0
C5070 dc_inst.x2.net18 dc_inst.x6.net19 0
C5071 dc_inst.x3.x13/a_27_47# dc_inst.x3.net15 0
C5072 dc_inst.x3.x5/a_27_47# dc_inst.x3.net1 0
C5073 _15_/a_27_47# dc_inst.net2 0
C5074 dc_inst.x5.net5 dc_inst.x5.net6 0.0282f
C5075 path[3] _20_/a_470_297# 0.00252f
C5076 dc_inst.x3.x18/a_27_47# path[5] 0.0191f
C5077 dc_inst.x4.net13 dc_inst.x2.net7 0
C5078 _01_ dc_inst.x3.x17/a_27_47# 0
C5079 dc_inst.x3.net2 dc_inst.x1.net9 0
C5080 _06_ dc_inst.x3.net10 0.00274f
C5081 dc_inst.x7.x1/a_27_47# dc_inst.x6.x1/a_27_47# 0.02448f
C5082 dc_inst.x9/a_247_21# dc_inst.x7.net4 0.00222f
C5083 dc_inst.x1.x1/a_27_47# dc_inst.x1.net14 0
C5084 clknet_1_1__leaf_clk _23_/a_543_47# 0
C5085 _02_ _23_/a_193_47# 0
C5086 tdo dc_inst.x2.x15/a_27_47# 0
C5087 dc_inst.x5.net12 dc_inst.x4.x8/a_27_47# 0
C5088 dc_inst.x1.net18 dc_inst.x2.net4 0.0012f
C5089 _13_/a_470_47# dc_inst.x3.x8/a_27_47# 0
C5090 _25_/a_543_47# dc_inst.x7.net1 0.01069f
C5091 dc_inst.x2.net11 dc_inst.x5.net10 0
C5092 _05_ clkbuf_1_1__f_clk/a_110_47# 0
C5093 clkbuf_1_1__f_clk/a_110_47# dc_inst.x3.x15/a_27_47# 0
C5094 path[6] path[7] 0.12921f
C5095 dc_inst.x4.net2 dc_inst.x6.net18 0
C5096 dc_inst.x6.net3 dc_inst.x6.net13 0
C5097 clknet_1_1__leaf_clk _14_/a_505_21# 0
C5098 dc_inst.x1.x11/a_27_47# path[3] 0
C5099 dc_inst.x5.x17/a_27_47# dc_inst.x7.x8/a_27_47# 0
C5100 dc_inst.x1.net4 _15_/a_27_47# 0.02033f
C5101 VPWR delay_sel[2] 0.55262f
C5102 _24_/a_761_289# _03_ 0
C5103 dc_inst.x8/a_757_363# dc_inst.x8/a_834_97# -0.00174f
C5104 dc_inst.x4.net2 tdo 0
C5105 dc_inst.x1.net16 dc_inst.x2.x5/a_27_47# 0.01107f
C5106 VPWR dc_inst.x6.net7 0.05224f
C5107 _24_/a_1108_47# _05_ 0
C5108 dc_inst.x2.x10/a_27_47# dc_inst.x5.x11/a_27_47# 0
C5109 _25_/a_27_47# dc_inst.x7.net17 0
C5110 _19_/a_193_297# _07_ 0.00759f
C5111 clkbuf_0_clk/a_110_47# rst 0.02343f
C5112 dc_inst.x6.net3 dc_inst.x6.net12 0.00342f
C5113 dc_inst.x9/a_247_21# dc_inst.net4 0.22563f
C5114 dc_inst.x4.net17 dc_inst.x6.net10 0.00111f
C5115 dc_inst.x2.net12 dc_inst.x1.x9/a_27_47# 0
C5116 dc_inst.x4.x14/a_27_47# dc_inst.x4.x16/a_27_47# 0.02448f
C5117 dc_inst.x7.x2/a_27_47# dc_inst.x7.net2 0.02597f
C5118 dc_inst.x6.net7 path_sel[2] 0.00152f
C5119 dc_inst.x1.x20/a_27_47# dc_inst.x7.net4 0
C5120 _20_/a_384_47# dc_inst.x3.x12/a_27_47# 0
C5121 dc_inst.x4.net11 dc_inst.x2.net7 0
C5122 dc_inst.x4.x4/a_27_47# dc_inst.x7.net2 0
C5123 dc_inst.x3.net6 dc_inst.x3.x13/a_27_47# 0.02951f
C5124 dc_inst.x7.x15/a_27_47# VPWR -0.00881f
C5125 dc_inst.x4.net13 dc_inst.x5.net3 0.05337f
C5126 dc_inst.x2.x11/a_27_47# dc_inst.x2.x12/a_27_47# 0.02448f
C5127 dc_inst.x7.net3 dc_inst.x7.x20/a_27_47# 0.03859f
C5128 _00_ _23_/a_543_47# 0
C5129 dc_inst.x9/a_668_97# dc_inst.x7.net5 0
C5130 _24_/a_448_47# delay_sel[2] 0.00145f
C5131 _04_ _15_/a_27_47# 0
C5132 clkbuf_0_clk/a_110_47# clkbuf_1_0__f_clk/a_110_47# 0.00337f
C5133 dc_inst.x1.x18/a_27_47# dc_inst.x2.net16 0
C5134 capture_d dc_inst.x6.net17 0
C5135 dc_inst.x2.net13 dc_inst.x2.net14 0.21645f
C5136 VPWR dc_inst.x6.x20/a_27_47# -0.00427f
C5137 dc_inst.x5.x18/a_27_47# path_sel[1] 0.00258f
C5138 dc_inst.x2.net12 dc_inst.x5.net11 0.02031f
C5139 dc_inst.x2.net13 dc_inst.x5.net12 0.0097f
C5140 _00_ _14_/a_505_21# 0
C5141 dc_inst.x2.net10 dc_inst.x2.net15 0
C5142 _02_ se 0.01294f
C5143 clknet_1_1__leaf_clk tdi 0.00213f
C5144 dc_inst.x5.net3 dc_inst.x4.x5/a_27_47# 0
C5145 dc_inst.x4.net3 dc_inst.x6.x15/a_27_47# 0
C5146 path_sel[1] dc_inst.x4.x9/a_27_47# 0.01052f
C5147 dc_inst.x3.net3 dc_inst.x3.x17/a_27_47# 0.03436f
C5148 _25_/a_543_47# _03_ 0
C5149 dc_inst.x2.x20/a_27_47# _15_/a_288_47# 0
C5150 _19_/a_205_47# path_sel[2] 0
C5151 path_sel[2] dc_inst.x6.x20/a_27_47# 0.0034f
C5152 _14_/a_76_199# dc_inst.x3.x5/a_27_47# 0
C5153 dc_inst.x5.net16 dc_inst.x4.net19 0
C5154 dc_inst.x5.net6 dc_inst.x5.x6/a_27_47# 0.0495f
C5155 _01_ _23_/a_761_289# 0
C5156 rst _23_/a_1283_21# 0
C5157 dc_inst.x8/a_1478_413# dc_inst.net2 0.01881f
C5158 dc_inst.x6.net3 path_sel[1] 0
C5159 dc_inst.x5.net13 dc_inst.x4.net18 0.01027f
C5160 _25_/a_1217_47# dc_inst.x7.net17 0
C5161 _10_ _07_ 0
C5162 _24_/a_761_289# VPWR 0.00249f
C5163 tdo dc_inst.x2.x6/a_27_47# 0
C5164 dc_inst.x5.x16/a_27_47# dc_inst.x5.net3 0
C5165 _07_ dc_inst.x1.x7/a_27_47# 0
C5166 path_sel[1] _15_/a_397_47# 0.00147f
C5167 path_sel[0] dc_inst.x1.net7 0.00891f
C5168 dc_inst.x5.x20/a_27_47# dc_inst.x7.net6 0.00116f
C5169 dc_inst.x1.x13/a_27_47# dc_inst.x1.net14 0.04665f
C5170 dc_inst.x1.net13 dc_inst.x1.x14/a_27_47# 0.04661f
C5171 dc_inst.x7.net12 _25_/a_193_47# 0.00161f
C5172 dc_inst.x4.x3/a_27_47# dc_inst.net3 0
C5173 clknet_0_clk _23_/a_193_47# 0.0014f
C5174 dc_inst.x3.x5/a_27_47# dc_inst.x3.net14 0.04376f
C5175 dc_inst.x4.net11 dc_inst.x5.net3 0
C5176 _24_/a_543_47# clkbuf_1_1__f_clk/a_110_47# 0.00694f
C5177 dc_inst.net3 delay_sel[1] 0.08258f
C5178 dc_inst.x2.x2/a_27_47# dc_inst.x5.net3 0
C5179 _13_/a_112_47# rst 0
C5180 dc_inst.x1.net4 dc_inst.x8/a_1478_413# 0
C5181 dc_inst.x5.x10/a_27_47# dc_inst.x2.net13 0
C5182 _06_ dc_inst.x3.net13 0
C5183 dc_inst.x7.x10/a_27_47# dc_inst.x9/a_247_21# 0.00279f
C5184 dc_inst.x6.x17/a_27_47# dc_inst.x6.net19 0
C5185 _25_/a_651_413# delay_sel[2] 0
C5186 _02_ delay_sel[2] 0.03217f
C5187 capture_q shadow_q 0.02732f
C5188 dc_inst.x4.net17 dc_inst.x4.x19/a_27_47# 0.00104f
C5189 dc_inst.x4.x18/a_27_47# dc_inst.x4.net18 0.00435f
C5190 _01_ dc_inst.x3.net14 0
C5191 dc_inst.x5.net16 dc_inst.x6.net6 0
C5192 dc_inst.x5.net15 dc_inst.x6.net7 0.00547f
C5193 dc_inst.x1.net3 _13_/a_112_47# 0
C5194 _00_ tdi 0
C5195 dc_inst.x7.x19/a_27_47# delay_sel[1] 0
C5196 _24_/a_193_47# _24_/a_651_413# -0.00701f
C5197 dc_inst.net1 dc_inst.x5.net3 0
C5198 dc_inst.x2.x18/a_27_47# dc_inst.in 0.00317f
C5199 dc_inst.x3.net2 dc_inst.x3.x12/a_27_47# 0
C5200 dc_inst.x10/a_76_199# _01_ 0
C5201 dc_inst.x10/a_218_374# rst 0.00116f
C5202 dc_inst.x5.x8/a_27_47# path_sel[0] 0.00219f
C5203 tdo dc_inst.x4.net19 0
C5204 dc_inst.x5.x4/a_27_47# dc_inst.x5.net6 0
C5205 dc_inst.x2.net18 _01_ 0
C5206 _25_/a_543_47# VPWR 0.00538f
C5207 _15_/a_788_316# dc_inst.x3.net10 0
C5208 dc_inst.x3.net5 path[5] 0.06373f
C5209 dc_inst.x1.net5 _15_/a_600_345# 0.00127f
C5210 dc_inst.x6.x8/a_27_47# dc_inst.x5.net3 0
C5211 dc_inst.x3.x5/a_27_47# dc_inst.x3.x15/a_27_47# 0.00381f
C5212 _05_ dc_inst.x3.x5/a_27_47# 0
C5213 path_sel[1] path[4] 0
C5214 dc_inst.x7.net4 dc_inst.x8/a_193_413# 0.00211f
C5215 dc_inst.x6.net11 dc_inst.x4.x5/a_27_47# 0
C5216 dc_inst.x7.net12 _25_/a_1462_47# 0
C5217 dc_inst.x2.net7 dc_inst.x2.net10 0.0091f
C5218 dc_inst.x4.net14 dc_inst.x5.net13 0
C5219 dc_inst.x5.net4 dc_inst.x2.net7 0
C5220 dc_inst.x2.net5 dc_inst.x5.net6 0.02452f
C5221 dc_inst.x7.net15 dc_inst.x7.net6 0
C5222 dc_inst.x6.net16 dc_inst.x6.net17 0.28164f
C5223 tdo dc_inst.x7.net18 0
C5224 dc_inst.x1.net16 VPWR 0.05165f
C5225 dc_inst.x1.net13 dc_inst.x2.net12 0
C5226 _01_ dc_inst.x3.x15/a_27_47# 0
C5227 tdo capture_d 0.09908f
C5228 dc_inst.x3.x9/a_27_47# rst 0
C5229 dc_inst.x4.x14/a_27_47# dc_inst.x4.x8/a_27_47# 0
C5230 se clknet_0_clk 0
C5231 dc_inst.x6.net4 dc_inst.x7.x6/a_27_47# 0
C5232 dc_inst.x6.x3/a_27_47# dc_inst.x7.net7 0
C5233 tdo dc_inst.x6.net6 0
C5234 path_sel[0] dc_inst.x2.net14 0
C5235 dc_inst.x1.net16 path_sel[2] 0.0128f
C5236 path_sel[0] dc_inst.x5.net12 0.04941f
C5237 path_sel[1] dc_inst.x5.x12/a_27_47# 0.0086f
C5238 _24_/a_761_289# _02_ 0
C5239 _24_/a_1283_21# clknet_1_1__leaf_clk 0.00195f
C5240 dc_inst.x6.net16 dc_inst.x4.net6 0
C5241 _07_ _20_/a_79_21# 0.00107f
C5242 clkload0/X dc_inst.x10/a_76_199# 0
C5243 dc_inst.x7.net14 _00_ -0
C5244 dc_inst.x4.x18/a_27_47# dc_inst.x4.net14 0.05421f
C5245 dc_inst.x4.net17 dc_inst.x4.x15/a_27_47# 0.00348f
C5246 dc_inst.x9/a_757_363# dc_inst.x7.net17 0
C5247 dc_inst.x6.net19 dc_inst.net1 0
C5248 dc_inst.net8 _01_ 0
C5249 dc_inst.x4.net16 dc_inst.x4.x16/a_27_47# 0.00892f
C5250 dc_inst.x4.x20/a_27_47# dc_inst.x4.net8 0
C5251 dc_inst.x2.x17/a_27_47# dc_inst.x2.net13 0
C5252 dc_inst.x4.x2/a_27_47# dc_inst.x7.net2 0
C5253 dc_inst.x1.x19/a_27_47# VPWR 0.01563f
C5254 dc_inst.x5.net19 dc_inst.x7.x19/a_27_47# 0
C5255 dc_inst.x5.x18/a_27_47# dc_inst.x6.net10 0
C5256 dc_inst.x2.x16/a_27_47# dc_inst.x2.net5 0
C5257 dc_inst.x6.x18/a_27_47# dc_inst.x6.net19 0.00101f
C5258 dc_inst.x3.net3 dc_inst.x3.net14 0.00405f
C5259 dc_inst.x3.x19/a_27_47# dc_inst.x3.net17 0.04436f
C5260 dc_inst.x1.x19/a_27_47# path_sel[2] 0.00379f
C5261 dc_inst.x1.net5 path[6] 0.00312f
C5262 dc_inst.x7.x13/a_27_47# clkbuf_1_0__f_clk/a_110_47# 0
C5263 dc_inst.x6.x8/a_27_47# dc_inst.x6.x3/a_27_47# 0
C5264 dc_inst.x7.net4 dc_inst.x8/a_834_97# 0.0046f
C5265 dc_inst.x4.net9 dc_inst.x2.net4 0
C5266 tdo dc_inst.x4.net15 0
C5267 _14_/a_505_21# dc_inst.x3.net8 0.00214f
C5268 clknet_1_0__leaf_clk dc_inst.x7.net18 0.00115f
C5269 dc_inst.x6.net2 dc_inst.x6.net1 0
C5270 dc_inst.x6.net11 dc_inst.net1 0
C5271 dc_inst.x10/a_76_199# dc_inst.x7.net16 0
C5272 delay_sel[2] clknet_0_clk 0.02628f
C5273 dc_inst.x1.x3/a_27_47# dc_inst.x3.x14/a_27_47# 0
C5274 dc_inst.x4.x17/a_27_47# dc_inst.x4.net12 0
C5275 VPWR _20_/a_470_297# -0
C5276 dc_inst.x2.x8/a_27_47# path_sel[0] 0
C5277 dc_inst.x5.net10 _16_/a_229_47# 0
C5278 dc_inst.x5.x10/a_27_47# path_sel[0] 0.00267f
C5279 dc_inst.x5.net6 dc_inst.x2.x3/a_27_47# 0.00943f
C5280 shadow_q dc_inst.x3.x20/a_27_47# 0
C5281 dc_inst.x7.net1 dc_inst.net7 0.02072f
C5282 dc_inst.x5.net4 dc_inst.x5.net3 0.02466f
C5283 dc_inst.x4.x18/a_27_47# dc_inst.x4.x13/a_27_47# 0
C5284 dc_inst.x6.net17 dc_inst.x2.x1/a_27_47# 0
C5285 dc_inst.x3.net16 dc_inst.x8/a_1290_413# 0.00119f
C5286 dc_inst.x3.net18 dc_inst.x3.net17 0.0989f
C5287 dc_inst.x4.x2/a_27_47# dc_inst.x8/a_757_363# 0
C5288 dc_inst.x4.net2 dc_inst.x8/a_247_21# 0
C5289 dc_inst.x6.net2 dc_inst.x6.x5/a_27_47# 0
C5290 dc_inst.x3.x4/a_27_47# dc_inst.x3.net5 0.00241f
C5291 dc_inst.x4.net17 VPWR 0.14248f
C5292 dc_inst.x1.net16 dc_inst.x4.net5 0.10135f
C5293 dc_inst.x7.net14 dc_inst.x7.x7/a_27_47# 0
C5294 dc_inst.x9/a_1478_413# _03_ 0
C5295 dc_inst.x7.net3 dc_inst.x3.net5 0
C5296 tdo dc_inst.x6.x11/a_27_47# 0
C5297 dc_inst.x6.x8/a_27_47# dc_inst.x6.net11 0
C5298 _00_ _24_/a_1283_21# 0.03905f
C5299 _25_/a_1108_47# clknet_1_1__leaf_clk 0.0038f
C5300 tdo _24_/a_27_47# 0.01817f
C5301 dc_inst.x1.net16 dc_inst.x1.net8 0
C5302 dc_inst.x1.net17 dc_inst.x1.net7 0
C5303 dc_inst.x3.x9/a_27_47# dc_inst.x3.net9 0.01236f
C5304 VPWR dc_inst.x1.x11/a_27_47# 0.00573f
C5305 dc_inst.x7.x15/a_27_47# dc_inst.x9/a_193_413# 0
C5306 rst clkbuf_1_1__f_clk/a_110_47# 0.24776f
C5307 dc_inst.x2.x1/a_27_47# dc_inst.x4.net6 0
C5308 dc_inst.x4.net17 path_sel[2] 0.00119f
C5309 clkload0/X dc_inst.net8 0
C5310 dc_inst.x4.net2 path[6] 0
C5311 delay_sel[1] dc_inst.x7.x17/a_27_47# 0
C5312 dc_inst.net3 dc_inst.x2.net16 0
C5313 dc_inst.x3.net3 dc_inst.x3.x15/a_27_47# 0
C5314 path[3] path[4] 0.09977f
C5315 dc_inst.x1.net10 path_sel[1] 0.07728f
C5316 dc_inst.x10/a_76_199# dc_inst.x6.net14 0
C5317 dc_inst.x1.net11 _19_/a_193_297# 0.00694f
C5318 dc_inst.x1.x11/a_27_47# path_sel[2] 0.01355f
C5319 dc_inst.x7.x13/a_27_47# dc_inst.x9/a_27_47# 0.0101f
C5320 dc_inst.x7.net12 dc_inst.x9/a_750_97# 0
C5321 dc_inst.net3 dc_inst.net2 0.10781f
C5322 dc_inst.x5.net19 dc_inst.x6.x9/a_27_47# 0.00182f
C5323 dc_inst.x1.x19/a_27_47# dc_inst.x4.net5 0.03981f
C5324 dc_inst.x2.net18 dc_inst.x6.net14 0
C5325 dc_inst.x7.net10 dc_inst.x7.x4/a_27_47# 0.00275f
C5326 _15_/a_288_47# dc_inst.x3.net14 0
C5327 _15_/a_872_316# dc_inst.x3.x14/a_27_47# 0
C5328 _15_/a_788_316# dc_inst.x3.net13 0
C5329 dc_inst.x1.net3 dc_inst.x1.x12/a_27_47# 0
C5330 dc_inst.x1.x2/a_27_47# dc_inst.x1.net12 0.06922f
C5331 _24_/a_1108_47# rst 0
C5332 _24_/a_543_47# _01_ 0.00146f
C5333 clknet_0_clk dc_inst.x6.x20/a_27_47# 0
C5334 dc_inst.x5.net5 dc_inst.x2.net8 0
C5335 dc_inst.x2.net6 dc_inst.x2.net1 0.00143f
C5336 dc_inst.net6 dc_inst.x6.net5 0.01048f
C5337 dc_inst.x4.net1 dc_inst.x5.net8 0
C5338 tdo dc_inst.x6.net16 0.0053f
C5339 dc_inst.x4.x4/a_27_47# dc_inst.x7.net4 0
C5340 dc_inst.net7 dc_inst.x7.x18/a_27_47# 0.0224f
C5341 tdi dc_inst.x3.net8 0.00143f
C5342 dc_inst.x2.x20/a_27_47# path_sel[1] 0
C5343 dc_inst.net8 dc_inst.x7.net16 0
C5344 dc_inst.x10/a_76_199# dc_inst.net9 0.00533f
C5345 clk dc_inst.x7.net11 0.05534f
C5346 dc_inst.net8 dc_inst.x3.net3 0.02685f
C5347 _08_ dc_inst.x5.net11 0.0023f
C5348 dc_inst.x1.x17/a_27_47# dc_inst.x5.net9 0
C5349 dc_inst.x2.net14 dc_inst.x1.net7 0
C5350 path[3] dc_inst.x5.x12/a_27_47# 0
C5351 dc_inst.x5.x19/a_27_47# dc_inst.x7.x8/a_27_47# 0
C5352 dc_inst.x3.net18 dc_inst.x3.net11 0
C5353 _10_ _06_ 0.01749f
C5354 _24_/a_761_289# clknet_0_clk 0.00325f
C5355 dc_inst.x1.net4 dc_inst.net3 0.02949f
C5356 dc_inst.x5.x20/a_27_47# delay_sel[0] 0
C5357 dc_inst.net5 dc_inst.x7.x19/a_27_47# 0
C5358 dc_inst.net7 _03_ 0.00129f
C5359 _25_/a_193_47# tdo -0
C5360 _25_/a_1108_47# _00_ 0.06457f
C5361 dc_inst.x6.net2 dc_inst.x6.net8 0
C5362 _00_ clknet_1_1__leaf_clk 0.18198f
C5363 tdo _24_/a_1217_47# 0
C5364 dc_inst.x2.net6 dc_inst.x4.net9 0
C5365 dc_inst.x1.net18 dc_inst.x2.x2/a_27_47# 0
C5366 dc_inst.x1.x19/a_27_47# dc_inst.x2.net2 0.0011f
C5367 dc_inst.x1.net10 _18_/a_505_21# 0
C5368 dc_inst.x5.x14/a_27_47# dc_inst.x5.net14 0.00266f
C5369 VPWR dc_inst.x9/a_1478_413# 0
C5370 dc_inst.x5.x5/a_27_47# dc_inst.x2.net6 0
C5371 dc_inst.x5.net5 dc_inst.x2.x6/a_27_47# 0.065f
C5372 dc_inst.x5.x14/a_27_47# dc_inst.x5.x13/a_27_47# 0.02448f
C5373 dc_inst.x2.x11/a_27_47# dc_inst.x5.net11 0
C5374 dc_inst.x1.net14 dc_inst.x1.x16/a_27_47# 0
C5375 dc_inst.x1.net11 _10_ 0.10421f
C5376 _23_/a_27_47# dc_inst.x8/a_834_97# 0
C5377 _23_/a_1283_21# dc_inst.x8/a_1478_413# 0
C5378 _23_/a_193_47# dc_inst.x8/a_668_97# 0
C5379 dc_inst.x1.net11 dc_inst.x1.x7/a_27_47# 0
C5380 path_sel[2] dc_inst.x9/a_1478_413# 0.00112f
C5381 path[7] dc_inst.x3.x14/a_27_47# 0
C5382 dc_inst.x9/a_834_97# dc_inst.x6.x20/a_27_47# 0
C5383 dc_inst.x1.net18 dc_inst.net1 0.2697f
C5384 _13_/a_470_47# dc_inst.x3.x19/a_27_47# 0
C5385 dc_inst.net3 dc_inst.x1.net9 0
C5386 dc_inst.x1.net17 dc_inst.x2.net14 0.0037f
C5387 dc_inst.x4.net17 dc_inst.x5.net15 0
C5388 dc_inst.x1.x17/a_27_47# dc_inst.x2.x9/a_27_47# 0
C5389 dc_inst.x5.net9 dc_inst.x2.x14/a_27_47# 0
C5390 dc_inst.x5.x8/a_27_47# dc_inst.x5.net12 0
C5391 dc_inst.x4.net16 dc_inst.x4.x8/a_27_47# 0.00526f
C5392 tdo dc_inst.x2.x1/a_27_47# 0.00482f
C5393 dc_inst.x3.net2 clkbuf_1_1__f_clk/a_110_47# 0
C5394 dc_inst.net8 dc_inst.net9 0.20179f
C5395 dc_inst.x1.net12 dc_inst.x5.net1 0
C5396 dc_inst.x6.x2/a_27_47# dc_inst.x6.net6 0
C5397 _09_ _08_ 0
C5398 path[2] path[0] 0.00687f
C5399 dc_inst.x6.x5/a_27_47# dc_inst.x6.x12/a_27_47# 0.04629f
C5400 dc_inst.x1.net12 dc_inst.x3.x20/a_27_47# 0
C5401 dc_inst.x6.net15 dc_inst.x9/a_1478_413# 0
C5402 _25_/a_193_47# dc_inst.x9/a_277_47# 0
C5403 _25_/a_761_289# dc_inst.x9/a_247_21# 0
C5404 _25_/a_543_47# clknet_0_clk 0.00495f
C5405 _25_/a_193_47# clknet_1_0__leaf_clk 0.00367f
C5406 _25_/a_448_47# clkbuf_1_0__f_clk/a_110_47# 0
C5407 _13_/a_470_47# dc_inst.x3.net18 0
C5408 dc_inst.x6.x19/a_27_47# dc_inst.x9/a_1290_413# 0
C5409 dc_inst.x1.net6 _08_ 0
C5410 dc_inst.x4.x14/a_27_47# path_sel[0] 0.00261f
C5411 _25_/a_1462_47# tdo 0
C5412 delay_sel[2] dc_inst.x7.x20/a_27_47# 0
C5413 dc_inst.x7.net14 delay_sel[1] 0
C5414 dc_inst.x6.net9 dc_inst.x6.x9/a_27_47# 0.12901f
C5415 dc_inst.x1.net10 path[3] 0.00227f
C5416 dc_inst.x5.x17/a_27_47# dc_inst.x7.net8 0
C5417 dc_inst.x7.net15 delay_sel[0] 0.01622f
C5418 VPWR dc_inst.net7 0.01578f
C5419 dc_inst.x2.net16 dc_inst.x2.net13 0
C5420 dc_inst.x1.x17/a_27_47# dc_inst.x2.net9 0
C5421 dc_inst.x9/a_27_413# dc_inst.x7.net7 0
C5422 dc_inst.x9/a_247_21# dc_inst.x7.net6 0
C5423 _13_/a_470_297# path[5] 0.00129f
C5424 dc_inst.x7.net12 dc_inst.x6.net2 0
C5425 dc_inst.x2.net14 dc_inst.x5.net12 0.00132f
C5426 path_sel[1] dc_inst.x6.x10/a_27_47# 0.00248f
C5427 dc_inst.x5.x4/a_27_47# dc_inst.x2.x15/a_27_47# 0
C5428 capture_d dc_inst.x8/a_247_21# 0
C5429 delay_sel[2] dc_inst.x8/a_27_413# 0
C5430 dc_inst.x1.x15/a_27_47# dc_inst.x2.net15 0
C5431 path_sel[1] dc_inst.x2.net4 0.00783f
C5432 path_sel[2] dc_inst.net7 0
C5433 dc_inst.x3.x6/a_27_47# _15_/a_27_47# 0
C5434 dc_inst.x5.x15/a_27_47# dc_inst.x4.net19 0
C5435 _19_/a_109_297# _15_/a_600_345# 0
C5436 dc_inst.x7.net13 dc_inst.net6 0
C5437 _18_/a_218_374# _09_ 0.00111f
C5438 _20_/a_79_21# _06_ 0
C5439 rst dc_inst.x3.x5/a_27_47# 0
C5440 _24_/a_1283_21# dc_inst.x3.net8 0
C5441 dc_inst.x3.net4 path[6] 0.0281f
C5442 dc_inst.x6.x17/a_27_47# dc_inst.x6.net14 0
C5443 dc_inst.x1.x12/a_27_47# _15_/a_27_47# 0
C5444 path_sel[0] _15_/a_1281_47# 0
C5445 VPWR dc_inst.x5.x18/a_27_47# 0.07214f
C5446 _25_/a_543_47# dc_inst.x9/a_834_97# 0
C5447 dc_inst.x1.net16 dc_inst.x1.x14/a_27_47# 0
C5448 _24_/a_1283_21# delay_sel[1] 0
C5449 rst _01_ 0.01251f
C5450 dc_inst.x6.x19/a_27_47# delay_sel[0] 0
C5451 VPWR dc_inst.x4.x9/a_27_47# 0.00192f
C5452 dc_inst.x1.net2 _06_ 0
C5453 dc_inst.x3.net3 dc_inst.x1.x8/a_27_47# 0
C5454 dc_inst.x1.net19 dc_inst.x1.net15 0.02896f
C5455 dc_inst.x5.x18/a_27_47# path_sel[2] 0.00524f
C5456 dc_inst.x1.net13 dc_inst.x2.x11/a_27_47# 0
C5457 dc_inst.x4.x2/a_27_47# dc_inst.x4.x1/a_27_47# 0.01018f
C5458 dc_inst.x2.x8/a_27_47# dc_inst.x5.net12 0
C5459 dc_inst.x5.x10/a_27_47# dc_inst.x2.net14 0
C5460 dc_inst.x6.net14 dc_inst.x4.x5/a_27_47# 0
C5461 dc_inst.x2.x17/a_27_47# dc_inst.x1.net7 0
C5462 dc_inst.x1.net11 _20_/a_79_21# 0
C5463 dc_inst.x3.net17 dc_inst.x7.net4 0
C5464 dc_inst.x5.x10/a_27_47# dc_inst.x5.net12 0.00809f
C5465 VPWR dc_inst.x6.net3 0.12498f
C5466 dc_inst.x4.x2/a_27_47# dc_inst.x7.net4 0
C5467 path[6] dc_inst.x3.x13/a_27_47# 0
C5468 path_sel[2] dc_inst.x4.x9/a_27_47# 0
C5469 dc_inst.x2.net17 dc_inst.x1.net12 0
C5470 dc_inst.x3.net5 _23_/a_193_47# 0
C5471 dc_inst.x7.net14 dc_inst.x5.net19 0
C5472 dc_inst.x7.x8/a_27_47# dc_inst.x7.net10 0
C5473 dc_inst.x7.net9 dc_inst.x7.x9/a_27_47# 0.01798f
C5474 dc_inst.x7.net12 dc_inst.x7.net11 0.00682f
C5475 dc_inst.x4.net6 dc_inst.x4.net8 0.01298f
C5476 dc_inst.x6.net3 path_sel[2] 0.0386f
C5477 dc_inst.x3.x17/a_27_47# dc_inst.x3.net16 0.01982f
C5478 dc_inst.x10/a_505_21# dc_inst.net2 0
C5479 dc_inst.x4.net14 dc_inst.x5.net6 0
C5480 dc_inst.x3.net6 _15_/a_1060_369# 0
C5481 dc_inst.x1.x16/a_27_47# dc_inst.x8/a_757_363# 0
C5482 path_sel[2] _15_/a_397_47# 0
C5483 _10_ _15_/a_788_316# 0
C5484 dc_inst.x3.net17 dc_inst.x3.net10 0
C5485 dc_inst.x1.net10 dc_inst.x2.x5/a_27_47# 0
C5486 dc_inst.x1.net1 dc_inst.x2.net13 0.00439f
C5487 dc_inst.net3 dc_inst.x2.net15 0
C5488 dc_inst.x6.net18 dc_inst.x9/a_750_97# 0
C5489 dc_inst.x4.net11 dc_inst.x6.net14 0
C5490 clkbuf_1_0__f_clk/a_110_47# dc_inst.x9/a_27_413# 0
C5491 dc_inst.x4.x16/a_27_47# dc_inst.x2.net7 0
C5492 dc_inst.x6.x7/a_27_47# path_sel[1] 0.00736f
C5493 dc_inst.x6.net10 dc_inst.x7.net5 0
C5494 dc_inst.x4.net12 dc_inst.x4.net10 0.00791f
C5495 dc_inst.x4.net13 dc_inst.x4.net9 0.0023f
C5496 _07_ path[5] 0
C5497 tdo dc_inst.x9/a_750_97# 0.00479f
C5498 clkload0/X rst 0.06153f
C5499 _25_/a_1108_47# delay_sel[1] 0
C5500 tdo dc_inst.x7.x16/a_27_47# 0
C5501 clknet_1_1__leaf_clk delay_sel[1] 0
C5502 dc_inst.x2.net6 path_sel[1] 0.03881f
C5503 dc_inst.x6.net2 dc_inst.x6.net17 0.0046f
C5504 dc_inst.x2.net3 dc_inst.x4.net8 0.0126f
C5505 VPWR dc_inst.x8/a_1290_413# -0.02539f
C5506 path_sel[1] dc_inst.x3.net14 0
C5507 dc_inst.x4.x1/a_27_47# dc_inst.x2.x19/a_27_47# 0.08729f
C5508 _24_/a_27_47# path[6] 0
C5509 dc_inst.x6.x5/a_27_47# dc_inst.x7.net4 0
C5510 dc_inst.x3.net6 dc_inst.x3.net18 0.00133f
C5511 dc_inst.x3.net2 dc_inst.x3.x5/a_27_47# 0
C5512 dc_inst.x2.x19/a_27_47# dc_inst.x7.net4 0.0016f
C5513 dc_inst.x4.net9 dc_inst.x4.x5/a_27_47# 0
C5514 dc_inst.x4.x9/a_27_47# dc_inst.x4.net5 0
C5515 dc_inst.x7.net2 dc_inst.x6.net17 0.00527f
C5516 dc_inst.net1 dc_inst.x6.net14 0.07913f
C5517 path_sel[2] dc_inst.x8/a_1290_413# 0
C5518 dc_inst.x7.net3 dc_inst.x10/a_218_47# 0.00134f
C5519 dc_inst.in dc_inst.x3.x20/a_27_47# 0
C5520 _17_/a_27_93# _16_/a_27_93# 0.01199f
C5521 _17_/a_174_21# _16_/a_229_47# 0
C5522 dc_inst.x6.x18/a_27_47# dc_inst.x6.net14 0.01273f
C5523 rst dc_inst.x7.net16 0
C5524 VPWR path[4] 0.25749f
C5525 dc_inst.x2.x4/a_27_47# dc_inst.x2.net7 0.00127f
C5526 dc_inst.x3.net2 _01_ 0.00127f
C5527 dc_inst.x3.net3 rst 0
C5528 path_sel[0] dc_inst.net2 0
C5529 se dc_inst.x3.net5 0
C5530 dc_inst.x6.net1 dc_inst.net4 0.03674f
C5531 dc_inst.net9 dc_inst.net1 0.05897f
C5532 tdo dc_inst.x6.x14/a_27_47# 0.00367f
C5533 dc_inst.x2.x17/a_27_47# dc_inst.x2.net14 0.01151f
C5534 dc_inst.x3.x8/a_27_47# path[6] 0.00322f
C5535 dc_inst.net3 _23_/a_1283_21# 0
C5536 dc_inst.x4.x14/a_27_47# dc_inst.x5.x8/a_27_47# 0.00381f
C5537 _00_ dc_inst.x3.net8 0
C5538 dc_inst.x1.net3 dc_inst.x3.net3 0.00431f
C5539 dc_inst.x3.net11 dc_inst.x3.net10 0.22901f
C5540 dc_inst.x6.x18/a_27_47# dc_inst.net9 0
C5541 dc_inst.x9/a_1478_413# dc_inst.x6.x15/a_27_47# 0
C5542 dc_inst.x4.net16 path_sel[0] 0.00146f
C5543 dc_inst.x6.net2 dc_inst.x5.net16 0
C5544 dc_inst.x6.x10/a_27_47# dc_inst.x6.net10 0.05394f
C5545 dc_inst.x6.x5/a_27_47# dc_inst.net4 0.01971f
C5546 dc_inst.x9/a_277_47# dc_inst.x7.x16/a_27_47# 0
C5547 dc_inst.x9/a_247_21# dc_inst.x9/a_1290_413# -0.00452f
C5548 dc_inst.x9/a_277_47# dc_inst.x9/a_750_97# -0.05766f
C5549 clkbuf_1_0__f_clk/a_110_47# dc_inst.x9/a_668_97# 0
C5550 _25_/a_193_47# dc_inst.x7.x12/a_27_47# 0
C5551 tdo dc_inst.x4.net8 0.04786f
C5552 dc_inst.x4.net11 dc_inst.x4.net9 0.00369f
C5553 dc_inst.x4.net1 dc_inst.x4.net10 0.30598f
C5554 dc_inst.x1.net15 dc_inst.x1.x20/a_27_47# 0.00182f
C5555 clkbuf_1_0__f_clk/a_110_47# dc_inst.x7.net16 0.00736f
C5556 clknet_1_0__leaf_clk dc_inst.x7.x16/a_27_47# 0
C5557 dc_inst.x6.x19/a_27_47# dc_inst.x4.x6/a_27_47# 0
C5558 dc_inst.x7.net1 dc_inst.x7.net5 0
C5559 dc_inst.x4.x16/a_27_47# dc_inst.x5.net3 0.04184f
C5560 dc_inst.x4.net9 dc_inst.x2.x2/a_27_47# 0
C5561 _00_ delay_sel[1] 0.00141f
C5562 VPWR dc_inst.x5.x12/a_27_47# 0.00741f
C5563 dc_inst.x7.net14 dc_inst.net5 0
C5564 dc_inst.x3.net16 _23_/a_761_289# 0
C5565 dc_inst.x1.net4 path_sel[0] 0.03732f
C5566 dc_inst.x4.x11/a_27_47# dc_inst.x5.net6 0
C5567 dc_inst.x4.net15 dc_inst.x5.x6/a_27_47# 0
C5568 path_sel[1] dc_inst.x5.net2 0.03192f
C5569 _19_/a_193_297# _17_/a_174_21# 0
C5570 dc_inst.x4.x20/a_27_47# dc_inst.net4 0.02715f
C5571 path[2] dc_inst.x2.net13 0
C5572 path_sel[2] dc_inst.x5.x12/a_27_47# 0.00207f
C5573 delay_sel[2] dc_inst.x3.net5 0.00147f
C5574 _15_/a_788_316# _20_/a_79_21# 0
C5575 rst dc_inst.net9 0.04427f
C5576 dc_inst.x4.x14/a_27_47# dc_inst.x5.net12 0
C5577 dc_inst.x5.net17 dc_inst.x5.net19 0.02282f
C5578 dc_inst.x6.net17 dc_inst.x6.x13/a_27_47# 0
C5579 dc_inst.x6.x17/a_27_47# dc_inst.x6.net13 0
C5580 dc_inst.x3.net13 dc_inst.x3.net17 0
C5581 dc_inst.x1.net1 path_sel[0] 0
C5582 dc_inst.x1.net2 _15_/a_788_316# 0
C5583 dc_inst.x3.net14 dc_inst.x3.net16 0
C5584 _02_ dc_inst.x8/a_1290_413# 0
C5585 _04_ path_sel[0] 0.02866f
C5586 dc_inst.x1.net3 _15_/a_288_47# 0.03122f
C5587 _24_/a_1283_21# dc_inst.net2 0
C5588 dc_inst.x2.net13 dc_inst.x2.net15 0
C5589 _13_/a_27_297# dc_inst.x3.net1 0
C5590 dc_inst.x2.x18/a_27_47# dc_inst.x2.x15/a_27_47# 0
C5591 dc_inst.x2.net17 dc_inst.in 0
C5592 dc_inst.x9/a_247_21# delay_sel[0] 0.03698f
C5593 clknet_0_clk dc_inst.net7 0.00615f
C5594 tdo dc_inst.x6.net2 0
C5595 dc_inst.x7.net2 dc_inst.x6.net18 0.00505f
C5596 dc_inst.x5.x1/a_27_47# dc_inst.x4.net19 0.00624f
C5597 dc_inst.x2.x5/a_27_47# dc_inst.x2.net4 0
C5598 dc_inst.x6.x13/a_27_47# dc_inst.x4.net6 0.01154f
C5599 dc_inst.x7.net3 dc_inst.x7.net15 0
C5600 dc_inst.x6.net8 dc_inst.net4 0.00364f
C5601 dc_inst.x6.x17/a_27_47# dc_inst.x6.net12 0
C5602 dc_inst.x3.net2 dc_inst.x3.net3 0.39317f
C5603 dc_inst.x3.x3/a_27_47# dc_inst.x3.x17/a_27_47# 0
C5604 dc_inst.x6.x4/a_27_47# dc_inst.x6.x9/a_27_47# 0
C5605 dc_inst.x6.net6 dc_inst.x7.x4/a_27_47# 0
C5606 dc_inst.x10/a_76_199# dc_inst.x3.net16 0
C5607 tdo dc_inst.x7.net2 0.1285f
C5608 dc_inst.x4.net4 dc_inst.in 0
C5609 dc_inst.x5.net11 _07_ 0
C5610 dc_inst.x5.net7 dc_inst.x5.net8 0.03435f
C5611 _18_/a_76_199# path_sel[0] 0
C5612 dc_inst.x4.net2 dc_inst.x2.x18/a_27_47# 0
C5613 dc_inst.x2.net16 dc_inst.x1.net7 0
C5614 dc_inst.x4.x17/a_27_47# dc_inst.x5.net7 0.00757f
C5615 VPWR dc_inst.x1.net10 0.24587f
C5616 dc_inst.x5.net6 dc_inst.x5.net9 0.04481f
C5617 dc_inst.x5.x12/a_27_47# dc_inst.x1.net8 0
C5618 dc_inst.x2.net1 dc_inst.x2.net10 0.11946f
C5619 dc_inst.net6 dc_inst.in 0
C5620 dc_inst.x5.x9/a_27_47# dc_inst.x1.x9/a_27_47# 0
C5621 dc_inst.x1.net18 dc_inst.x1.x18/a_27_47# 0.00232f
C5622 dc_inst.x1.net10 path_sel[2] 0.00385f
C5623 dc_inst.x4.net11 dc_inst.x6.net13 0
C5624 dc_inst.x3.x15/a_27_47# dc_inst.x3.net16 0
C5625 _23_/a_193_47# _23_/a_448_47# -0.00373f
C5626 VPWR dc_inst.x2.x20/a_27_47# -0.00539f
C5627 dc_inst.x1.x20/a_27_47# delay_sel[0] 0
C5628 dc_inst.x6.net6 dc_inst.x5.x1/a_27_47# 0.03439f
C5629 dc_inst.x1.net19 dc_inst.x4.x6/a_27_47# 0
C5630 dc_inst.x1.net19 dc_inst.x5.net7 0
C5631 dc_inst.x7.net3 dc_inst.x6.x19/a_27_47# 0
C5632 dc_inst.x1.x2/a_27_47# path[7] 0
C5633 clknet_1_1__leaf_clk dc_inst.net2 0
C5634 dc_inst.x4.net13 path_sel[1] 0.01816f
C5635 dc_inst.x3.net15 dc_inst.x3.net10 0
C5636 dc_inst.x2.x20/a_27_47# path_sel[2] 0.00371f
C5637 dc_inst.x4.x1/a_27_47# dc_inst.x1.x16/a_27_47# 0
C5638 dc_inst.x9/a_193_47# delay_sel[1] 0
C5639 dc_inst.x9/a_834_97# dc_inst.net7 0.01255f
C5640 dc_inst.x3.net11 dc_inst.x3.net13 0.42382f
C5641 dc_inst.x4.net11 dc_inst.x6.net12 0
C5642 dc_inst.x1.x16/a_27_47# dc_inst.x7.net4 0
C5643 dc_inst.x1.net17 dc_inst.x2.net16 0
C5644 dc_inst.x7.net2 dc_inst.x9/a_277_47# 0.02653f
C5645 dc_inst.net6 dc_inst.x9/a_757_363# 0.01284f
C5646 dc_inst.x5.x19/a_27_47# dc_inst.x7.net8 0
C5647 dc_inst.x5.net19 dc_inst.x7.x7/a_27_47# 0.01484f
C5648 dc_inst.net1 dc_inst.x6.net13 0
C5649 dc_inst.x7.net2 clknet_1_0__leaf_clk 0
C5650 dc_inst.x3.net3 _15_/a_27_47# 0
C5651 dc_inst.in dc_inst.x8/a_277_47# 0.01046f
C5652 dc_inst.x5.x11/a_27_47# dc_inst.x1.x7/a_27_47# 0.00122f
C5653 dc_inst.x7.net19 dc_inst.x7.net18 0.54452f
C5654 dc_inst.x4.x10/a_27_47# dc_inst.x5.net6 0
C5655 dc_inst.x7.net10 dc_inst.x7.x6/a_27_47# 0
C5656 dc_inst.net8 dc_inst.x3.net16 0
C5657 capture_d dc_inst.x7.net19 0.01448f
C5658 path_sel[1] dc_inst.x4.x5/a_27_47# 0.00225f
C5659 dc_inst.x1.x5/a_27_47# _19_/a_193_297# 0
C5660 dc_inst.x6.net18 dc_inst.x6.x13/a_27_47# 0
C5661 dc_inst.x5.x3/a_27_47# dc_inst.x5.net6 0.00413f
C5662 dc_inst.x5.net4 dc_inst.x5.x5/a_27_47# 0
C5663 _09_ _07_ 0.24016f
C5664 path[2] path_sel[0] 0.08748f
C5665 dc_inst.x7.x20/a_27_47# dc_inst.x9/a_1478_413# 0
C5666 dc_inst.x7.net12 dc_inst.net4 0.00118f
C5667 dc_inst.x5.net3 dc_inst.x4.x8/a_27_47# 0
C5668 tdo dc_inst.x6.x13/a_27_47# 0.00974f
C5669 dc_inst.x2.x17/a_27_47# delay_sel[1] 0
C5670 dc_inst.x2.x5/a_27_47# dc_inst.x2.net6 0.00364f
C5671 dc_inst.x6.net12 dc_inst.net1 0
C5672 dc_inst.x1.net6 _07_ 0
C5673 path[5] _06_ 0
C5674 VPWR dc_inst.x7.net5 0.01619f
C5675 dc_inst.x4.net16 dc_inst.x5.x8/a_27_47# 0
C5676 dc_inst.x4.x9/a_27_47# dc_inst.x4.x7/a_27_47# 0.01018f
C5677 dc_inst.x1.net10 dc_inst.x4.net5 0
C5678 dc_inst.net3 dc_inst.x6.net19 0
C5679 dc_inst.x1.net9 dc_inst.x1.net7 0.00621f
C5680 dc_inst.x5.x16/a_27_47# path_sel[1] 0.01325f
C5681 dc_inst.x9/a_1290_413# dc_inst.x8/a_193_413# 0
C5682 dc_inst.x9/a_750_97# dc_inst.x8/a_247_21# 0
C5683 dc_inst.x1.net1 dc_inst.x1.net7 0
C5684 dc_inst.x1.net10 dc_inst.x1.net8 0.22069f
C5685 dc_inst.x5.net19 dc_inst.x7.x5/a_27_47# 0
C5686 path_sel[2] dc_inst.x7.net5 0.00257f
C5687 _14_/a_535_374# dc_inst.x3.net14 0
C5688 path_sel[1] dc_inst.x1.x8/a_27_47# 0
C5689 _04_ dc_inst.x1.net7 0
C5690 VPWR dc_inst.x3.x17/a_27_47# 0.00493f
C5691 _00_ dc_inst.net2 0
C5692 dc_inst.x6.x11/a_27_47# dc_inst.x5.x1/a_27_47# 0
C5693 dc_inst.x2.x16/a_27_47# dc_inst.x2.x9/a_27_47# 0
C5694 dc_inst.x7.net1 dc_inst.x7.net9 0
C5695 dc_inst.x7.net11 clknet_1_0__leaf_clk 0.02684f
C5696 dc_inst.x4.net11 path_sel[1] 0.02019f
C5697 tdo dc_inst.x6.x12/a_27_47# 0.00205f
C5698 dc_inst.x4.x3/a_27_47# delay_sel[1] 0
C5699 dc_inst.x2.net18 _23_/a_1108_47# 0
C5700 dc_inst.x5.net6 dc_inst.x2.net9 0.00853f
C5701 dc_inst.x5.net6 dc_inst.x5.net1 0
C5702 path_sel[1] dc_inst.x2.x2/a_27_47# 0.00577f
C5703 dc_inst.x1.net11 path[5] 0.0024f
C5704 VPWR dc_inst.x3.net1 0.17892f
C5705 dc_inst.x6.x9/a_27_47# dc_inst.x5.net3 0
C5706 _19_/a_465_47# path[3] 0
C5707 _23_/a_761_289# _03_ 0
C5708 dc_inst.x3.net6 dc_inst.x3.net10 0.00894f
C5709 dc_inst.x3.x2/a_27_47# path[6] 0.00344f
C5710 dc_inst.x4.x1/a_27_47# dc_inst.x6.net17 0
C5711 dc_inst.x1.x5/a_27_47# _10_ 0.00482f
C5712 dc_inst.x3.net15 _23_/a_27_47# 0
C5713 dc_inst.x3.x15/a_27_47# _23_/a_1108_47# 0
C5714 dc_inst.x4.net16 dc_inst.x5.net12 0
C5715 dc_inst.x7.x20/a_27_47# dc_inst.net7 0.00219f
C5716 path_sel[0] dc_inst.x3.x12/a_27_47# 0
C5717 dc_inst.x6.net17 dc_inst.x7.net4 0.00254f
C5718 dc_inst.x1.x14/a_27_47# dc_inst.x8/a_1290_413# 0
C5719 path_sel[1] dc_inst.net1 0.00153f
C5720 dc_inst.x1.net17 dc_inst.x1.net9 0
C5721 VPWR dc_inst.x6.x10/a_27_47# -0.00316f
C5722 tdi _13_/a_112_47# 0
C5723 se _13_/a_470_297# 0.00102f
C5724 _14_/a_535_374# _05_ 0
C5725 VPWR dc_inst.x2.net4 0.04291f
C5726 dc_inst.x2.net12 dc_inst.x4.x9/a_27_47# 0
C5727 dc_inst.x1.x4/a_27_47# _06_ 0
C5728 clkbuf_1_0__f_clk/a_110_47# dc_inst.x7.x9/a_27_47# 0
C5729 dc_inst.x4.net18 dc_inst.x4.net19 0.02916f
C5730 path_sel[2] dc_inst.x6.x10/a_27_47# 0.00517f
C5731 dc_inst.x1.net14 path[6] 0
C5732 delay_sel[0] dc_inst.x8/a_193_413# 0.05138f
C5733 dc_inst.x6.x8/a_27_47# path_sel[1] 0.00255f
C5734 _23_/a_639_47# shadow_q 0
C5735 dc_inst.x6.x2/a_27_47# dc_inst.x6.net2 0.02034f
C5736 path_sel[2] dc_inst.x2.net4 0.00225f
C5737 dc_inst.net5 dc_inst.x7.x7/a_27_47# 0
C5738 delay_sel[2] _23_/a_448_47# 0
C5739 dc_inst.net8 _23_/a_1108_47# 0
C5740 dc_inst.x3.net3 dc_inst.x8/a_1478_413# 0
C5741 dc_inst.x5.net6 dc_inst.x4.net7 0.14758f
C5742 _13_/a_27_297# _05_ 0
C5743 _13_/a_27_297# dc_inst.x3.x15/a_27_47# 0
C5744 dc_inst.x3.x13/a_27_47# dc_inst.x3.x14/a_27_47# 0
C5745 dc_inst.x5.net2 dc_inst.x4.x19/a_27_47# 0
C5746 dc_inst.x6.net17 dc_inst.net4 0.00122f
C5747 dc_inst.x3.net13 dc_inst.x3.net15 0
C5748 dc_inst.x1.net18 dc_inst.x2.x4/a_27_47# 0
C5749 dc_inst.x2.net14 dc_inst.x1.net9 0.04266f
C5750 dc_inst.x4.net13 dc_inst.x2.x7/a_27_47# 0
C5751 dc_inst.x1.net1 dc_inst.x2.net14 0
C5752 dc_inst.x5.net12 dc_inst.x1.net9 0
C5753 dc_inst.x7.x3/a_27_47# dc_inst.x8/a_277_47# 0
C5754 path[2] dc_inst.x1.net7 0
C5755 dc_inst.x1.x1/a_27_47# dc_inst.x1.net2 0.00213f
C5756 dc_inst.x5.net19 delay_sel[1] 0
C5757 dc_inst.x1.net1 dc_inst.x5.net12 0.00426f
C5758 dc_inst.x1.x18/a_27_47# dc_inst.x6.net14 0.01689f
C5759 dc_inst.x4.net13 dc_inst.x6.net10 0
C5760 dc_inst.x4.net12 dc_inst.x6.net1 0
C5761 dc_inst.x3.net15 _23_/a_1217_47# 0
C5762 delay_sel[2] _13_/a_470_297# 0
C5763 dc_inst.x7.net17 dc_inst.x7.net18 0.22043f
C5764 dc_inst.net4 dc_inst.x4.net6 0
C5765 dc_inst.net5 dc_inst.x7.x5/a_27_47# 0.03349f
C5766 capture_d dc_inst.x7.net17 0
C5767 VPWR _23_/a_761_289# 0.0219f
C5768 dc_inst.x1.net3 path_sel[1] 0.02582f
C5769 dc_inst.x6.net6 dc_inst.x4.net18 0
C5770 dc_inst.x3.x15/a_27_47# dc_inst.x3.x16/a_27_47# 0
C5771 _02_ dc_inst.x3.x17/a_27_47# 0
C5772 _25_/a_193_47# dc_inst.x7.net19 0
C5773 dc_inst.x2.net7 path_sel[0] 0.00121f
C5774 dc_inst.x7.net10 dc_inst.x7.net8 0
C5775 dc_inst.x6.x9/a_27_47# dc_inst.x6.net11 0
C5776 VPWR _14_/a_76_199# 0.00194f
C5777 dc_inst.x6.net10 dc_inst.x4.x5/a_27_47# 0
C5778 dc_inst.x5.net1 _17_/a_478_47# 0
C5779 dc_inst.x1.net15 dc_inst.x1.x1/a_27_47# 0
C5780 clkbuf_1_1__f_clk/a_110_47# _23_/a_543_47# 0
C5781 _18_/a_76_199# dc_inst.x5.net12 0
C5782 _02_ dc_inst.x3.net1 0.09102f
C5783 delay_sel[1] dc_inst.x8/a_27_47# 0.01243f
C5784 dc_inst.x2.net4 dc_inst.x4.net5 0.00349f
C5785 dc_inst.x2.net15 dc_inst.x1.net7 0
C5786 dc_inst.x10/a_535_374# dc_inst.net8 0
C5787 dc_inst.x4.x1/a_27_47# dc_inst.x6.net18 0
C5788 dc_inst.x4.net4 dc_inst.x5.net6 0
C5789 VPWR dc_inst.x6.x7/a_27_47# 0.02279f
C5790 dc_inst.x2.net10 path_sel[1] 0.03703f
C5791 dc_inst.x6.net18 dc_inst.x7.net4 0.10622f
C5792 dc_inst.x1.x10/a_27_47# dc_inst.x5.net1 0.00212f
C5793 dc_inst.x3.net7 dc_inst.x3.net12 0.05039f
C5794 dc_inst.x5.net4 path_sel[1] 0.00522f
C5795 dc_inst.x1.x5/a_27_47# _20_/a_79_21# 0.01002f
C5796 _24_/a_543_47# _23_/a_1108_47# 0
C5797 _24_/a_193_47# _23_/a_651_413# 0
C5798 _24_/a_651_413# _23_/a_193_47# 0
C5799 _24_/a_1283_21# _23_/a_1283_21# 0.00264f
C5800 VPWR dc_inst.x2.net6 0.10127f
C5801 dc_inst.x6.x7/a_27_47# path_sel[2] 0.0024f
C5802 VPWR dc_inst.x3.net14 0.13751f
C5803 dc_inst.x4.net14 dc_inst.x4.net19 0.03744f
C5804 dc_inst.x4.net15 dc_inst.x4.net18 0.23138f
C5805 dc_inst.x2.x16/a_27_47# dc_inst.x2.net17 0.00108f
C5806 dc_inst.x2.net16 dc_inst.x2.x17/a_27_47# 0.12267f
C5807 tdo dc_inst.x7.net4 0.01921f
C5808 _25_/a_1108_47# clkbuf_0_clk/a_110_47# 0.00531f
C5809 dc_inst.x3.net6 dc_inst.x3.net13 0.09908f
C5810 dc_inst.x5.x6/a_27_47# dc_inst.x6.x14/a_27_47# 0.01254f
C5811 _15_/a_193_47# path[7] 0
C5812 _15_/a_788_316# path[5] 0.03056f
C5813 dc_inst.x2.net6 path_sel[2] 0
C5814 dc_inst.x1.net11 dc_inst.x5.net11 0
C5815 dc_inst.x6.net4 dc_inst.x6.net5 0.03371f
C5816 clkbuf_0_clk/a_110_47# clknet_1_1__leaf_clk 0
C5817 dc_inst.x2.x17/a_27_47# dc_inst.net2 0
C5818 dc_inst.x4.x15/a_27_47# dc_inst.x5.net2 0
C5819 VPWR dc_inst.x7.net9 0.08931f
C5820 VPWR dc_inst.x10/a_76_199# 0.00631f
C5821 dc_inst.x5.net18 dc_inst.x5.net7 0
C5822 dc_inst.x2.net2 dc_inst.x2.net4 0
C5823 dc_inst.x1.net5 dc_inst.x1.x2/a_27_47# 0.03148f
C5824 dc_inst.x3.x9/a_27_47# path_sel[0] 0
C5825 dc_inst.x3.x19/a_27_47# path[6] 0.00541f
C5826 dc_inst.x8/a_247_21# dc_inst.x8/a_757_363# -0.0033f
C5827 dc_inst.x2.net19 dc_inst.x6.x19/a_27_47# 0
C5828 dc_inst.x8/a_193_413# dc_inst.x8/a_750_97# -0
C5829 dc_inst.x5.net9 dc_inst.x2.x15/a_27_47# 0
C5830 dc_inst.x2.net12 dc_inst.x5.x12/a_27_47# 0.03324f
C5831 dc_inst.x1.net17 dc_inst.x2.net15 0
C5832 dc_inst.net3 _01_ 0
C5833 VPWR dc_inst.x2.net18 0.05417f
C5834 dc_inst.x5.net7 dc_inst.x4.net10 0.0479f
C5835 path_sel[2] dc_inst.x7.net9 0.00552f
C5836 dc_inst.x2.net16 delay_sel[1] 0
C5837 path_sel[0] dc_inst.x5.net3 0.00556f
C5838 _24_/a_1283_21# _13_/a_112_47# 0.00337f
C5839 dc_inst.x6.net18 dc_inst.net4 0
C5840 dc_inst.x4.x3/a_27_47# dc_inst.net2 0
C5841 path[2] dc_inst.x2.net14 0
C5842 dc_inst.x3.net2 path_sel[1] 0.01443f
C5843 dc_inst.x4.x13/a_27_47# dc_inst.x4.net19 0.00327f
C5844 path[2] dc_inst.x5.net12 0
C5845 dc_inst.x2.net18 path_sel[2] 0.00445f
C5846 dc_inst.x7.x12/a_27_47# dc_inst.x7.net11 0.02051f
C5847 delay_sel[1] dc_inst.net2 0.13183f
C5848 dc_inst.x5.net6 dc_inst.x5.x7/a_27_47# 0.11197f
C5849 dc_inst.x6.net10 dc_inst.net1 0
C5850 dc_inst.x4.x4/a_27_47# delay_sel[0] 0.0012f
C5851 dc_inst.x4.net14 dc_inst.x6.net6 0
C5852 tdo dc_inst.net4 0.04252f
C5853 dc_inst.x6.x5/a_27_47# dc_inst.x7.net6 0
C5854 dc_inst.net5 delay_sel[1] 0.03816f
C5855 dc_inst.x3.net18 path[6] 0.00408f
C5856 _15_/a_193_369# dc_inst.net2 0
C5857 dc_inst.x1.x5/a_27_47# dc_inst.x1.net15 0
C5858 path[3] _20_/a_384_47# 0.00109f
C5859 tdi clkbuf_1_1__f_clk/a_110_47# 0
C5860 VPWR _05_ 0.1171f
C5861 VPWR dc_inst.x3.x15/a_27_47# 0.07034f
C5862 rst dc_inst.x3.net16 0
C5863 dc_inst.x7.net13 dc_inst.x7.x14/a_27_47# 0.01776f
C5864 dc_inst.x1.net6 _06_ 0
C5865 dc_inst.x9/a_277_47# dc_inst.x7.net4 0
C5866 _02_ _23_/a_761_289# 0.00132f
C5867 clknet_1_1__leaf_clk _23_/a_1283_21# 0
C5868 clknet_1_0__leaf_clk dc_inst.x7.net4 0
C5869 clknet_0_clk dc_inst.x7.net5 0
C5870 dc_inst.x6.x8/a_27_47# dc_inst.x6.net10 0
C5871 VPWR dc_inst.x5.net2 0.95643f
C5872 dc_inst.x2.net18 dc_inst.x6.net15 0
C5873 dc_inst.x1.net13 dc_inst.x1.net19 0
C5874 dc_inst.x4.x3/a_27_47# dc_inst.x1.net4 0
C5875 _25_/a_1283_21# dc_inst.x7.net1 0
C5876 dc_inst.x2.x13/a_27_47# dc_inst.x2.x14/a_27_47# 0.02448f
C5877 _00_ clkbuf_0_clk/a_110_47# 0.0016f
C5878 dc_inst.x1.net3 path[3] 0
C5879 dc_inst.x1.net4 delay_sel[1] 0
C5880 dc_inst.x2.net14 dc_inst.x2.net15 0.00682f
C5881 dc_inst.x1.net11 _09_ 0.35869f
C5882 _02_ _14_/a_76_199# 0.00244f
C5883 dc_inst.x4.net16 dc_inst.x4.x14/a_27_47# 0.00426f
C5884 path_sel[2] dc_inst.x5.net2 0
C5885 dc_inst.x1.net4 _15_/a_193_369# 0.00166f
C5886 dc_inst.x2.net8 dc_inst.x5.net9 0
C5887 dc_inst.x1.x13/a_27_47# dc_inst.x1.net15 0.13028f
C5888 dc_inst.x2.x17/a_27_47# dc_inst.x1.net9 0.00488f
C5889 VPWR dc_inst.net8 0.15121f
C5890 _24_/a_543_47# _03_ 0
C5891 dc_inst.x6.x6/a_27_47# dc_inst.x4.net12 0
C5892 dc_inst.x4.net14 dc_inst.x4.net15 0.16244f
C5893 dc_inst.x3.net7 shadow_q 0
C5894 dc_inst.x8/a_750_97# dc_inst.x8/a_834_97# -0
C5895 dc_inst.x1.net6 dc_inst.x1.net11 0.20078f
C5896 dc_inst.net8 path_sel[2] 0
C5897 dc_inst.x7.net1 dc_inst.x7.net7 0.00134f
C5898 clknet_1_1__leaf_clk _13_/a_112_47# 0
C5899 _25_/a_193_47# dc_inst.x7.net17 0
C5900 dc_inst.x7.net2 dc_inst.x5.x6/a_27_47# 0
C5901 dc_inst.x2.net18 dc_inst.x4.net5 0
C5902 clknet_1_0__leaf_clk dc_inst.net4 0
C5903 dc_inst.x9/a_277_47# dc_inst.net4 0.07913f
C5904 path_sel[1] _15_/a_27_47# 0.0013f
C5905 _02_ dc_inst.x3.net14 0
C5906 dc_inst.x1.net10 dc_inst.x2.net12 0.01883f
C5907 dc_inst.x1.x15/a_27_47# _15_/a_288_47# 0
C5908 dc_inst.x4.x3/a_27_47# dc_inst.x1.net9 0
C5909 dc_inst.x7.x15/a_27_47# dc_inst.x7.net15 0.03582f
C5910 dc_inst.x4.net14 dc_inst.x6.x11/a_27_47# 0
C5911 dc_inst.x1.x12/a_27_47# path_sel[0] 0.0021f
C5912 dc_inst.x2.net6 dc_inst.x2.net2 0
C5913 dc_inst.x3.x3/a_27_47# dc_inst.x1.x8/a_27_47# 0
C5914 dc_inst.x1.x18/a_27_47# dc_inst.x6.net13 0.00102f
C5915 _00_ _23_/a_1283_21# 0
C5916 tdo _23_/a_27_47# 0.04334f
C5917 dc_inst.net3 dc_inst.x3.net3 0.02012f
C5918 dc_inst.x9/a_834_97# dc_inst.x7.net5 0
C5919 dc_inst.x1.net13 dc_inst.x1.net11 0
C5920 dc_inst.x4.net15 dc_inst.x4.x13/a_27_47# 0
C5921 dc_inst.x6.net9 dc_inst.x5.net19 0.00899f
C5922 dc_inst.net5 dc_inst.x5.net19 0.0088f
C5923 _24_/a_651_413# delay_sel[2] 0.0022f
C5924 _24_/a_639_47# capture_d 0.00114f
C5925 dc_inst.x3.x1/a_27_47# dc_inst.x8/a_277_47# 0
C5926 dc_inst.x1.net17 dc_inst.x2.net7 0
C5927 dc_inst.x2.net7 dc_inst.x5.x8/a_27_47# 0
C5928 dc_inst.x2.x6/a_27_47# dc_inst.x5.net9 0.02794f
C5929 dc_inst.x6.x8/a_27_47# dc_inst.x7.net1 0
C5930 dc_inst.x1.net2 dc_inst.x2.x19/a_27_47# 0
C5931 dc_inst.x4.x10/a_27_47# dc_inst.x2.net8 0.00145f
C5932 dc_inst.x2.x7/a_27_47# dc_inst.x2.net10 0
C5933 VPWR _19_/a_465_47# -0
C5934 _00_ _14_/a_218_374# 0
C5935 dc_inst.x7.net19 dc_inst.x7.x16/a_27_47# 0.0345f
C5936 _25_/a_1283_21# _03_ 0.05581f
C5937 dc_inst.x1.x18/a_27_47# dc_inst.x6.net12 0.00134f
C5938 dc_inst.x3.net2 dc_inst.x3.net16 0.07201f
C5939 dc_inst.x3.net17 dc_inst.x3.net19 0.03741f
C5940 rst _23_/a_1108_47# 0
C5941 _01_ _23_/a_543_47# 0
C5942 _00_ _13_/a_112_47# 0
C5943 dc_inst.x1.net15 dc_inst.x2.x19/a_27_47# 0
C5944 dc_inst.net8 dc_inst.x4.net5 0
C5945 dc_inst.x5.net14 dc_inst.x6.net8 0.00798f
C5946 _02_ _05_ 0.13601f
C5947 _02_ dc_inst.x3.x15/a_27_47# 0
C5948 rst dc_inst.x7.net1 0.01975f
C5949 dc_inst.x3.x11/a_27_47# dc_inst.x3.net11 0.01744f
C5950 _24_/a_543_47# VPWR 0.02355f
C5951 dc_inst.x6.net8 dc_inst.x5.x13/a_27_47# 0
C5952 dc_inst.x5.net15 dc_inst.x5.net2 0.09204f
C5953 dc_inst.x2.x4/a_27_47# dc_inst.x4.net9 0
C5954 VPWR dc_inst.x6.x17/a_27_47# 0.0038f
C5955 dc_inst.x7.net12 _25_/a_761_289# 0
C5956 VPWR dc_inst.x4.net13 0.46863f
C5957 dc_inst.x2.net8 dc_inst.x2.net9 0.03433f
C5958 dc_inst.x2.net7 dc_inst.x5.net12 0
C5959 dc_inst.x6.x19/a_27_47# dc_inst.x6.x20/a_27_47# 0.00104f
C5960 clknet_0_clk _23_/a_761_289# 0
C5961 clknet_1_0__leaf_clk _23_/a_27_47# 0.01449f
C5962 dc_inst.net3 dc_inst.net9 0
C5963 dc_inst.x6.net2 dc_inst.x7.x4/a_27_47# 0
C5964 _24_/a_1283_21# clkbuf_1_1__f_clk/a_110_47# 0.02393f
C5965 capture_q dc_inst.x3.net4 0
C5966 dc_inst.x5.x3/a_27_47# dc_inst.x2.x6/a_27_47# 0.08729f
C5967 dc_inst.x6.x17/a_27_47# path_sel[2] 0.00664f
C5968 dc_inst.x6.x16/a_27_47# dc_inst.x6.x17/a_27_47# 0.02448f
C5969 dc_inst.x7.x10/a_27_47# dc_inst.x9/a_277_47# 0
C5970 dc_inst.x4.net13 path_sel[2] 0
C5971 _25_/a_1270_413# delay_sel[2] 0
C5972 dc_inst.x7.net1 clkbuf_1_0__f_clk/a_110_47# 0.05314f
C5973 _02_ dc_inst.net8 0
C5974 capture_q capture_d 0
C5975 dc_inst.x7.x1/a_27_47# dc_inst.x7.net5 0
C5976 dc_inst.x1.net5 dc_inst.x2.net17 0
C5977 VPWR dc_inst.x4.x5/a_27_47# -0
C5978 dc_inst.x5.x8/a_27_47# dc_inst.x5.net3 0.04831f
C5979 dc_inst.x1.x18/a_27_47# path_sel[1] 0
C5980 dc_inst.x3.net6 _10_ 0.00164f
C5981 dc_inst.x5.net14 dc_inst.x6.x6/a_27_47# 0.01524f
C5982 dc_inst.x2.net16 dc_inst.net2 0
C5983 dc_inst.x4.x2/a_27_47# delay_sel[0] 0
C5984 rst dc_inst.x3.x3/a_27_47# 0
C5985 path_sel[2] dc_inst.x4.x5/a_27_47# 0.00459f
C5986 dc_inst.x6.net15 dc_inst.x6.x17/a_27_47# 0
C5987 rst dc_inst.x7.x18/a_27_47# 0.00106f
C5988 dc_inst.x5.net9 _16_/a_27_93# 0
C5989 dc_inst.x10/a_505_21# _01_ 0.01367f
C5990 dc_inst.x10/a_535_374# rst 0.00106f
C5991 dc_inst.x3.net11 dc_inst.x3.net19 0
C5992 dc_inst.x2.net17 dc_inst.x2.x15/a_27_47# 0
C5993 dc_inst.x2.x17/a_27_47# dc_inst.x2.net15 0.01158f
C5994 dc_inst.x4.net4 dc_inst.x1.net5 0
C5995 dc_inst.x1.x1/a_27_47# path[5] 0
C5996 VPWR dc_inst.x5.x16/a_27_47# 0.02434f
C5997 dc_inst.x2.net7 dc_inst.x2.x8/a_27_47# 0.01894f
C5998 dc_inst.x2.net7 dc_inst.x5.x10/a_27_47# 0
C5999 dc_inst.x2.x6/a_27_47# dc_inst.x5.net1 0
C6000 dc_inst.x6.net5 dc_inst.x9/a_757_363# 0
C6001 rst dc_inst.x3.x16/a_27_47# 0
C6002 _25_/a_1283_21# VPWR -0.00295f
C6003 VPWR dc_inst.x1.x8/a_27_47# 0.01235f
C6004 dc_inst.x4.x1/a_27_47# dc_inst.x8/a_247_21# 0.00115f
C6005 dc_inst.x6.net9 dc_inst.net5 0
C6006 dc_inst.x1.net6 _15_/a_788_316# 0.00163f
C6007 dc_inst.x1.x12/a_27_47# dc_inst.x1.net7 0.14989f
C6008 dc_inst.x7.net4 dc_inst.x8/a_247_21# 0.02842f
C6009 VPWR dc_inst.x4.net11 0.01396f
C6010 dc_inst.x5.x16/a_27_47# path_sel[2] 0
C6011 VPWR dc_inst.x2.x2/a_27_47# 0.01421f
C6012 rst _03_ 0.16478f
C6013 path_sel[2] dc_inst.x1.x8/a_27_47# 0.00573f
C6014 clkbuf_1_0__f_clk/a_110_47# dc_inst.x7.x18/a_27_47# 0
C6015 dc_inst.x4.x3/a_27_47# dc_inst.x2.net15 0
C6016 dc_inst.x4.net2 dc_inst.x2.net17 0.00393f
C6017 dc_inst.x5.net12 dc_inst.x5.net3 0.02959f
C6018 dc_inst.x2.net12 dc_inst.x2.net4 0
C6019 clknet_1_1__leaf_clk clkbuf_1_1__f_clk/a_110_47# 0.22639f
C6020 dc_inst.x1.net4 dc_inst.net2 0.02064f
C6021 dc_inst.x4.net11 path_sel[2] 0
C6022 dc_inst.x6.x17/a_27_47# dc_inst.x4.net5 0
C6023 dc_inst.x2.net18 dc_inst.x6.x15/a_27_47# 0
C6024 dc_inst.x7.net1 dc_inst.x9/a_27_47# 0.00945f
C6025 dc_inst.x2.net15 delay_sel[1] 0
C6026 dc_inst.x5.net5 dc_inst.x2.net11 0
C6027 VPWR dc_inst.x7.net7 0.00979f
C6028 path_sel[2] dc_inst.x2.x2/a_27_47# 0
C6029 dc_inst.x3.x7/a_27_47# dc_inst.x3.net12 0.03092f
C6030 dc_inst.x6.x5/a_27_47# delay_sel[0] 0
C6031 VPWR dc_inst.net1 0.55524f
C6032 dc_inst.x4.net15 dc_inst.x5.net9 0
C6033 path_sel[2] dc_inst.x7.net7 0.00695f
C6034 dc_inst.x6.x16/a_27_47# dc_inst.x7.net7 0
C6035 dc_inst.x6.net16 dc_inst.x7.x6/a_27_47# 0
C6036 dc_inst.x4.net2 dc_inst.x4.net4 0.17138f
C6037 dc_inst.x7.x2/a_27_47# dc_inst.x7.net3 0.00422f
C6038 _13_/a_27_297# dc_inst.x3.net9 0
C6039 clkbuf_1_0__f_clk/a_110_47# _03_ 0.01636f
C6040 dc_inst.x3.net18 dc_inst.x3.x10/a_27_47# 0
C6041 _24_/a_543_47# _02_ 0
C6042 dc_inst.in shadow_q 0
C6043 _24_/a_27_47# capture_q 0
C6044 _24_/a_1108_47# clknet_1_1__leaf_clk 0
C6045 dc_inst.x4.x5/a_27_47# dc_inst.x4.net5 0.0134f
C6046 VPWR dc_inst.x6.x18/a_27_47# 0.06714f
C6047 dc_inst.x5.net15 dc_inst.x4.net13 0
C6048 dc_inst.x2.net16 dc_inst.x1.net9 0.0027f
C6049 dc_inst.x2.net6 dc_inst.x4.x7/a_27_47# 0
C6050 dc_inst.x4.net2 _15_/a_193_47# 0
C6051 dc_inst.x4.net2 dc_inst.net6 0
C6052 dc_inst.x9/a_668_97# dc_inst.x7.x17/a_27_47# 0
C6053 path_sel[2] dc_inst.net1 0.06287f
C6054 dc_inst.x7.x16/a_27_47# dc_inst.x7.net17 0.0018f
C6055 dc_inst.x7.net2 dc_inst.x7.net19 0.11611f
C6056 dc_inst.x7.net16 dc_inst.x7.x17/a_27_47# 0.13602f
C6057 dc_inst.x9/a_750_97# dc_inst.x7.net17 0.00109f
C6058 dc_inst.x4.net9 dc_inst.x4.x8/a_27_47# 0.00325f
C6059 dc_inst.x6.x8/a_27_47# VPWR 0.00986f
C6060 dc_inst.x6.x18/a_27_47# path_sel[2] 0.0023f
C6061 dc_inst.x5.net17 dc_inst.x6.net11 0
C6062 path[6] dc_inst.x3.net10 0
C6063 dc_inst.x1.net17 dc_inst.x6.net11 0
C6064 dc_inst.x2.x8/a_27_47# dc_inst.x5.net3 0
C6065 dc_inst.x6.net15 dc_inst.x7.net7 0
C6066 dc_inst.x1.x5/a_27_47# path[5] 0
C6067 dc_inst.x7.net18 dc_inst.x7.net8 0
C6068 dc_inst.x4.net15 dc_inst.x4.x12/a_27_47# 0.01149f
C6069 dc_inst.x6.net15 dc_inst.net1 0
C6070 dc_inst.x1.x11/a_27_47# _07_ 0.00599f
C6071 dc_inst.x6.x8/a_27_47# path_sel[2] 0.0053f
C6072 dc_inst.x3.net2 dc_inst.x3.x3/a_27_47# 0.0017f
C6073 dc_inst.net9 _23_/a_543_47# 0
C6074 capture_q dc_inst.x3.x8/a_27_47# 0
C6075 delay_sel[1] _23_/a_1283_21# 0
C6076 delay_sel[0] _23_/a_651_413# 0
C6077 VPWR _20_/a_384_47# -0.00266f
C6078 _00_ clkbuf_1_1__f_clk/a_110_47# 0.03416f
C6079 dc_inst.x3.net4 dc_inst.x3.x20/a_27_47# 0
C6080 dc_inst.x4.net1 dc_inst.x4.net6 0
C6081 dc_inst.x1.net8 dc_inst.x1.x8/a_27_47# 0.01895f
C6082 _17_/a_174_21# dc_inst.x5.net11 0
C6083 dc_inst.x3.net6 _20_/a_79_21# 0
C6084 dc_inst.x2.x2/a_27_47# dc_inst.x4.net5 0
C6085 dc_inst.x3.net16 dc_inst.x8/a_1478_413# 0.00217f
C6086 dc_inst.x4.x16/a_27_47# path_sel[1] 0.00441f
C6087 dc_inst.x4.net2 dc_inst.x8/a_277_47# 0
C6088 VPWR rst 1.20407f
C6089 dc_inst.x3.net2 dc_inst.x3.x16/a_27_47# 0
C6090 dc_inst.x1.net4 dc_inst.x1.net9 0.0021f
C6091 _13_/a_112_47# dc_inst.x3.net8 0.0255f
C6092 dc_inst.x5.x16/a_27_47# dc_inst.x5.net15 0.04845f
C6093 dc_inst.x4.net19 dc_inst.x4.net7 0
C6094 path[0] path_sel[1] 0
C6095 dc_inst.x1.net15 dc_inst.x1.x16/a_27_47# 0.05244f
C6096 dc_inst.x7.net14 dc_inst.x9/a_27_413# 0
C6097 rst dc_inst.x6.x16/a_27_47# 0
C6098 _25_/a_1283_21# _02_ 0
C6099 _00_ _24_/a_1108_47# 0.05433f
C6100 _25_/a_448_47# clknet_1_1__leaf_clk 0
C6101 tdo _24_/a_193_47# 0.00235f
C6102 dc_inst.x1.x1/a_27_47# dc_inst.x1.x9/a_27_47# 0
C6103 dc_inst.x1.x15/a_27_47# path_sel[1] 0.01915f
C6104 VPWR dc_inst.x1.net3 0.18499f
C6105 dc_inst.x5.net15 dc_inst.x4.net11 0
C6106 dc_inst.x7.x15/a_27_47# dc_inst.x9/a_247_21# 0.00868f
C6107 dc_inst.x2.net6 dc_inst.x2.net12 0.02099f
C6108 dc_inst.net1 dc_inst.x4.net5 0.22858f
C6109 path[5] dc_inst.x3.net17 0.04178f
C6110 tdo dc_inst.x4.net12 0
C6111 _15_/a_872_316# dc_inst.x3.net12 0
C6112 VPWR clkbuf_1_0__f_clk/a_110_47# 0.07073f
C6113 dc_inst.x1.net3 path_sel[2] 0.24619f
C6114 dc_inst.x1.net10 _08_ 0
C6115 dc_inst.x6.x3/a_27_47# dc_inst.x7.x7/a_27_47# 0
C6116 dc_inst.x1.net11 _19_/a_205_47# 0
C6117 dc_inst.x3.x7/a_27_47# shadow_q 0
C6118 dc_inst.x5.net13 dc_inst.x5.x17/a_27_47# 0
C6119 dc_inst.x2.x4/a_27_47# path_sel[1] 0.00643f
C6120 dc_inst.x2.x2/a_27_47# dc_inst.x2.net2 0.01582f
C6121 dc_inst.x5.x11/a_27_47# dc_inst.x5.net11 0.00377f
C6122 dc_inst.x6.net2 dc_inst.x7.x8/a_27_47# 0.0296f
C6123 _24_/a_1283_21# _01_ 0.00174f
C6124 _24_/a_448_47# rst 0
C6125 dc_inst.x5.net7 dc_inst.x6.net1 0
C6126 VPWR dc_inst.x2.net10 0.23669f
C6127 dc_inst.x1.net18 dc_inst.x1.net7 0
C6128 _04_ dc_inst.x1.net9 0
C6129 dc_inst.x5.net6 dc_inst.x2.x13/a_27_47# 0
C6130 dc_inst.x6.x4/a_27_47# dc_inst.x5.net19 0.00617f
C6131 dc_inst.x10/a_505_21# dc_inst.net9 0.0021f
C6132 dc_inst.x10/a_218_47# dc_inst.net7 0
C6133 VPWR dc_inst.x5.net4 -0.00549f
C6134 dc_inst.x4.x14/a_27_47# dc_inst.x2.net7 0
C6135 dc_inst.x7.x1/a_27_47# dc_inst.x7.net9 0
C6136 dc_inst.x7.net2 dc_inst.x7.x8/a_27_47# 0
C6137 path_sel[2] dc_inst.x2.net10 0
C6138 path[6] _23_/a_27_47# 0
C6139 dc_inst.x3.net3 path_sel[0] 0
C6140 _18_/a_505_21# path[0] 0.00326f
C6141 dc_inst.x2.x19/a_27_47# dc_inst.x8/a_750_97# 0
C6142 dc_inst.x4.net3 dc_inst.x8/a_834_97# 0
C6143 dc_inst.net1 dc_inst.x2.net2 0.01504f
C6144 _24_/a_543_47# clknet_0_clk 0.00372f
C6145 dc_inst.x5.x6/a_27_47# dc_inst.net4 0.00358f
C6146 dc_inst.x6.net19 dc_inst.x7.x5/a_27_47# 0
C6147 dc_inst.x3.x9/a_27_47# dc_inst.x3.net8 0
C6148 _25_/a_761_289# tdo 0
C6149 _25_/a_448_47# _00_ 0.01459f
C6150 tdo _24_/a_1462_47# 0
C6151 dc_inst.x5.net14 dc_inst.x5.net16 0.00347f
C6152 dc_inst.x3.x18/a_27_47# dc_inst.x3.net14 0.01204f
C6153 dc_inst.x1.net1 _18_/a_76_199# 0.00214f
C6154 VPWR dc_inst.x3.net9 0.00405f
C6155 tdo dc_inst.x4.net1 0.03773f
C6156 dc_inst.x1.net12 dc_inst.in 0
C6157 dc_inst.x6.net2 dc_inst.x7.net17 0
C6158 dc_inst.x4.x20/a_27_47# dc_inst.x5.net7 0
C6159 VPWR dc_inst.x9/a_27_47# -0.00178f
C6160 dc_inst.x6.net18 dc_inst.x7.net6 0
C6161 dc_inst.x1.net19 dc_inst.x1.net16 0
C6162 dc_inst.x1.net18 dc_inst.x1.net17 0.23806f
C6163 path[5] dc_inst.x3.net11 0.04331f
C6164 path[7] dc_inst.x3.net12 0.06234f
C6165 dc_inst.x2.net16 dc_inst.x2.net15 0.0849f
C6166 VPWR dc_inst.x3.net2 0.04279f
C6167 dc_inst.x4.net14 dc_inst.x4.net8 0
C6168 _23_/a_193_47# dc_inst.x8/a_834_97# 0
C6169 dc_inst.x7.net2 dc_inst.x7.net17 0.11406f
C6170 dc_inst.x6.x15/a_27_47# dc_inst.x4.x5/a_27_47# 0.00122f
C6171 dc_inst.x6.net16 dc_inst.x7.net8 0
C6172 dc_inst.x10/a_76_199# dc_inst.x8/a_27_413# 0
C6173 dc_inst.x7.net12 delay_sel[0] 0.04357f
C6174 dc_inst.x6.net11 dc_inst.x7.x5/a_27_47# 0
C6175 dc_inst.x7.x13/a_27_47# delay_sel[1] 0.04372f
C6176 path[6] dc_inst.x3.net13 0
C6177 dc_inst.x3.net6 dc_inst.x3.net19 0
C6178 dc_inst.x3.net2 path_sel[2] 0
C6179 _02_ rst 0.06037f
C6180 clknet_1_1__leaf_clk _01_ 0
C6181 dc_inst.x5.x4/a_27_47# dc_inst.x2.net11 0.01151f
C6182 dc_inst.x3.x4/a_27_47# dc_inst.x3.net17 0.04488f
C6183 dc_inst.x3.net5 dc_inst.x3.x17/a_27_47# 0
C6184 dc_inst.x4.net17 dc_inst.x5.x14/a_27_47# 0
C6185 dc_inst.x4.x14/a_27_47# dc_inst.x5.net3 0.03973f
C6186 dc_inst.x7.net3 dc_inst.x3.net17 0
C6187 _02_ dc_inst.x1.net3 0
C6188 dc_inst.x1.x19/a_27_47# dc_inst.x1.net19 0.00336f
C6189 dc_inst.x4.x10/a_27_47# dc_inst.x2.x1/a_27_47# 0
C6190 path[3] path[0] 0
C6191 dc_inst.x1.x13/a_27_47# dc_inst.x1.x9/a_27_47# 0.01018f
C6192 path_sel[0] _15_/a_288_47# -0.00951f
C6193 dc_inst.x7.x4/a_27_47# dc_inst.x7.net4 0.02609f
C6194 dc_inst.x2.net10 dc_inst.x1.net8 0
C6195 dc_inst.x4.net3 dc_inst.x4.x4/a_27_47# 0.00221f
C6196 dc_inst.x6.net3 dc_inst.x5.x20/a_27_47# 0
C6197 dc_inst.x3.net5 dc_inst.x3.net1 0
C6198 _25_/a_543_47# dc_inst.x9/a_247_21# 0
C6199 dc_inst.x2.net1 path_sel[0] 0
C6200 _25_/a_1283_21# clknet_0_clk 0.03803f
C6201 _25_/a_761_289# clknet_1_0__leaf_clk 0
C6202 _25_/a_651_413# clkbuf_1_0__f_clk/a_110_47# 0
C6203 _05_ dc_inst.x3.x18/a_27_47# 0
C6204 dc_inst.x6.x19/a_27_47# dc_inst.x9/a_1478_413# 0
C6205 dc_inst.x6.net8 dc_inst.x5.net7 0
C6206 dc_inst.net6 dc_inst.x6.net6 0
C6207 _14_/a_439_47# path[5] 0
C6208 dc_inst.x4.net17 dc_inst.x5.net8 0
C6209 dc_inst.x1.net18 dc_inst.x2.net14 0
C6210 dc_inst.x6.net17 dc_inst.x9/a_1290_413# 0
C6211 dc_inst.x4.x17/a_27_47# dc_inst.x4.net17 0.00338f
C6212 dc_inst.x3.net7 dc_inst.x3.x7/a_27_47# 0.04654f
C6213 dc_inst.x1.net1 path[2] 0.00407f
C6214 dc_inst.x7.net15 dc_inst.net7 0
C6215 path_sel[1] dc_inst.x4.x8/a_27_47# 0.00664f
C6216 dc_inst.x6.net9 dc_inst.x6.x4/a_27_47# 0.01152f
C6217 dc_inst.net5 dc_inst.x6.x4/a_27_47# 0
C6218 dc_inst.x6.x15/a_27_47# dc_inst.x7.net7 0
C6219 dc_inst.x4.x5/a_27_47# dc_inst.x4.x7/a_27_47# 0
C6220 dc_inst.x1.x13/a_27_47# dc_inst.x5.net11 0
C6221 dc_inst.x9/a_277_47# dc_inst.x7.net6 0
C6222 dc_inst.x1.net13 dc_inst.x1.x1/a_27_47# 0
C6223 clknet_1_0__leaf_clk dc_inst.x7.net6 0
C6224 _23_/a_1283_21# dc_inst.net2 0.01304f
C6225 VPWR _15_/a_27_47# 0.011f
C6226 dc_inst.x1.net4 dc_inst.x3.x12/a_27_47# 0
C6227 path_sel[0] dc_inst.x4.net9 0
C6228 clknet_1_1__leaf_clk clkload0/X 0.01011f
C6229 dc_inst.net1 dc_inst.x6.x15/a_27_47# 0
C6230 delay_sel[1] dc_inst.x6.net19 0.00903f
C6231 clk dc_inst.x7.x11/a_27_47# 0.05703f
C6232 _00_ _01_ 0
C6233 dc_inst.net4 dc_inst.x7.x4/a_27_47# 0.00781f
C6234 path_sel[2] _15_/a_27_47# 0.00256f
C6235 _19_/a_193_297# _15_/a_600_345# 0
C6236 dc_inst.x6.net7 dc_inst.x4.net10 0
C6237 _18_/a_535_374# _09_ 0
C6238 _18_/a_76_199# path[2] 0.01355f
C6239 dc_inst.x2.net15 dc_inst.x1.net9 0.0409f
C6240 dc_inst.x6.x18/a_27_47# dc_inst.x6.x15/a_27_47# 0
C6241 dc_inst.x5.net19 dc_inst.x5.net3 0
C6242 dc_inst.x5.x5/a_27_47# path_sel[0] 0.00239f
C6243 dc_inst.x3.net2 dc_inst.x1.net8 0
C6244 _20_/a_470_297# _06_ 0.00306f
C6245 _24_/a_1108_47# dc_inst.x3.net8 0
C6246 dc_inst.x7.net3 dc_inst.x2.x19/a_27_47# 0
C6247 _02_ dc_inst.x3.net9 0.03393f
C6248 dc_inst.x1.x5/a_27_47# _09_ 0.00892f
C6249 dc_inst.x3.x10/a_27_47# dc_inst.x3.net10 0.01674f
C6250 dc_inst.x6.x9/a_27_47# path_sel[1] 0.00294f
C6251 dc_inst.x4.x11/a_27_47# dc_inst.x4.net8 0.01154f
C6252 dc_inst.x6.x19/a_27_47# dc_inst.net7 0
C6253 dc_inst.x1.x5/a_27_47# dc_inst.x1.net6 0.00873f
C6254 _02_ dc_inst.x3.net2 0
C6255 dc_inst.x2.x2/a_27_47# dc_inst.x4.x7/a_27_47# 0.08729f
C6256 dc_inst.net3 dc_inst.x3.net16 0
C6257 dc_inst.net6 dc_inst.x6.x11/a_27_47# 0
C6258 dc_inst.x6.net17 delay_sel[0] 0
C6259 dc_inst.x1.net16 dc_inst.x1.x20/a_27_47# 0
C6260 tdo dc_inst.x1.net15 0
C6261 _04_ dc_inst.x3.x12/a_27_47# 0
C6262 dc_inst.x7.net19 dc_inst.x7.net4 0
C6263 dc_inst.x5.x1/a_27_47# dc_inst.net4 0.03968f
C6264 rst dc_inst.x6.x15/a_27_47# 0
C6265 dc_inst.x4.net15 dc_inst.x5.x7/a_27_47# 0
C6266 path_sel[1] dc_inst.x2.net13 0.00844f
C6267 path[5] dc_inst.x3.net15 0
C6268 dc_inst.x4.net16 dc_inst.x2.net7 0.00178f
C6269 rst clknet_0_clk 0.75023f
C6270 dc_inst.net1 dc_inst.x4.x7/a_27_47# 0
C6271 dc_inst.x2.x1/a_27_47# dc_inst.x4.net7 0.01355f
C6272 _00_ clkload0/X 0
C6273 dc_inst.net8 dc_inst.x8/a_668_97# 0.04751f
C6274 dc_inst.x1.net4 _13_/a_112_47# 0
C6275 dc_inst.x1.x16/a_27_47# dc_inst.x8/a_750_97# 0
C6276 dc_inst.x1.x1/a_27_47# dc_inst.x2.net19 0
C6277 dc_inst.x1.net13 dc_inst.x1.x5/a_27_47# 0
C6278 dc_inst.x1.x11/a_27_47# dc_inst.x1.net11 0.0032f
C6279 dc_inst.x6.x3/a_27_47# dc_inst.x5.net19 0.01646f
C6280 dc_inst.net6 dc_inst.x6.net16 0
C6281 _24_/a_27_47# dc_inst.x8/a_277_47# 0
C6282 dc_inst.x1.x2/a_27_47# dc_inst.x3.x2/a_27_47# 0
C6283 dc_inst.x6.net18 dc_inst.x9/a_1290_413# 0.01236f
C6284 _15_/a_288_47# dc_inst.x1.net7 0
C6285 _15_/a_27_47# dc_inst.x1.net8 0.0015f
C6286 dc_inst.x5.net19 dc_inst.x6.net19 0
C6287 _13_/a_470_47# dc_inst.x3.x4/a_27_47# 0
C6288 clkbuf_1_0__f_clk/a_110_47# dc_inst.x9/a_193_413# 0
C6289 dc_inst.x2.x4/a_27_47# dc_inst.x2.x5/a_27_47# 0.02448f
C6290 dc_inst.x7.x10/a_27_47# dc_inst.x7.x4/a_27_47# 0.08729f
C6291 clkbuf_1_0__f_clk/a_110_47# clknet_0_clk 0.01301f
C6292 dc_inst.x7.net19 dc_inst.net4 0
C6293 dc_inst.x1.x18/a_27_47# VPWR 0.03774f
C6294 _25_/a_1270_413# dc_inst.net7 0
C6295 _25_/a_448_47# delay_sel[1] 0
C6296 tdo dc_inst.x9/a_1290_413# 0.00477f
C6297 dc_inst.x3.net5 dc_inst.x3.net14 0.09654f
C6298 clknet_1_1__leaf_clk dc_inst.net9 0
C6299 _00_ dc_inst.x3.net3 0
C6300 dc_inst.x2.net12 dc_inst.x2.x2/a_27_47# 0
C6301 dc_inst.x1.net17 dc_inst.x6.net14 0.01766f
C6302 dc_inst.x3.x1/a_27_47# shadow_q 0
C6303 VPWR dc_inst.x8/a_1478_413# -0.0104f
C6304 _24_/a_193_47# path[6] 0
C6305 dc_inst.x1.x18/a_27_47# path_sel[2] 0.01275f
C6306 dc_inst.x1.x13/a_27_47# dc_inst.x1.net13 0.015f
C6307 dc_inst.x5.net19 dc_inst.x6.net11 0
C6308 dc_inst.x1.x2/a_27_47# dc_inst.x1.net14 0.00292f
C6309 path_sel[2] dc_inst.x8/a_1478_413# 0.00111f
C6310 dc_inst.x6.net9 dc_inst.x5.net3 0
C6311 dc_inst.x6.net2 dc_inst.x7.x6/a_27_47# 0.04158f
C6312 _25_/a_1283_21# dc_inst.x7.x20/a_27_47# 0
C6313 dc_inst.x7.x13/a_27_47# dc_inst.net5 0.00864f
C6314 dc_inst.x7.x2/a_27_47# delay_sel[2] 0
C6315 dc_inst.x7.net3 dc_inst.x10/a_439_47# 0
C6316 dc_inst.x3.net7 path[7] 0
C6317 dc_inst.x5.x17/a_27_47# dc_inst.x5.x19/a_27_47# 0
C6318 dc_inst.x4.net16 dc_inst.x5.net3 0.12848f
C6319 dc_inst.x7.x1/a_27_47# dc_inst.x7.net7 0
C6320 dc_inst.x7.net2 dc_inst.x7.x6/a_27_47# 0
C6321 dc_inst.x3.net6 path[5] 0.03377f
C6322 dc_inst.x5.x15/a_27_47# dc_inst.x4.net12 0
C6323 dc_inst.x2.net6 dc_inst.x2.x11/a_27_47# 0.00198f
C6324 dc_inst.x4.x2/a_27_47# dc_inst.x4.net3 0.01503f
C6325 dc_inst.x2.x10/a_27_47# dc_inst.x5.net9 0
C6326 dc_inst.net3 _23_/a_1108_47# 0
C6327 dc_inst.x6.net18 delay_sel[0] 0
C6328 path[6] dc_inst.x1.x7/a_27_47# 0
C6329 dc_inst.x1.x14/a_27_47# dc_inst.x2.net10 0
C6330 dc_inst.x9/a_277_47# dc_inst.x9/a_1290_413# -0.00422f
C6331 dc_inst.x9/a_923_363# dc_inst.x9/a_750_97# -0
C6332 dc_inst.x3.net5 dc_inst.x3.x15/a_27_47# 0
C6333 _05_ dc_inst.x3.net5 0
C6334 clknet_1_0__leaf_clk dc_inst.x9/a_1290_413# 0
C6335 clkbuf_1_0__f_clk/a_110_47# dc_inst.x9/a_834_97# 0
C6336 dc_inst.x1.net12 path[7] 0
C6337 _10_ dc_inst.x1.x6/a_27_47# 0
C6338 dc_inst.x3.x5/a_27_47# dc_inst.x3.net8 0.00124f
C6339 dc_inst.x6.net17 dc_inst.x5.net7 0
C6340 dc_inst.x6.net17 dc_inst.x4.x6/a_27_47# 0
C6341 dc_inst.x4.x13/a_27_47# dc_inst.x6.x12/a_27_47# 0
C6342 dc_inst.x3.net13 dc_inst.x3.x10/a_27_47# 0.0065f
C6343 tdo delay_sel[0] 0.02259f
C6344 dc_inst.x3.net16 _23_/a_543_47# 0
C6345 dc_inst.x3.x2/a_27_47# dc_inst.x3.x20/a_27_47# 0
C6346 dc_inst.x7.net19 _23_/a_27_47# 0
C6347 dc_inst.x5.net8 dc_inst.x4.x9/a_27_47# 0.01107f
C6348 dc_inst.x1.x18/a_27_47# dc_inst.x4.net5 0
C6349 dc_inst.x7.net12 dc_inst.x7.x11/a_27_47# 0
C6350 dc_inst.x7.net1 dc_inst.x7.x19/a_27_47# 0.0078f
C6351 dc_inst.x5.net13 dc_inst.x5.x19/a_27_47# 0
C6352 dc_inst.x6.x9/a_27_47# dc_inst.x6.net10 0.00208f
C6353 dc_inst.x1.x17/a_27_47# dc_inst.x5.net6 0.00236f
C6354 dc_inst.x5.net7 dc_inst.x4.net6 0.03762f
C6355 dc_inst.net5 dc_inst.x6.x3/a_27_47# 0
C6356 dc_inst.net1 dc_inst.x8/a_27_413# 0.01733f
C6357 dc_inst.x2.net1 dc_inst.x5.net12 0.02738f
C6358 dc_inst.x4.net6 dc_inst.x4.x6/a_27_47# 0.0403f
C6359 dc_inst.x7.net4 dc_inst.x7.net17 0
C6360 clkbuf_1_1__f_clk/a_110_47# dc_inst.net2 0
C6361 path[0] path[1] 0.24955f
C6362 _01_ delay_sel[1] 0
C6363 path_sel[1] path_sel[0] 0.31364f
C6364 dc_inst.net5 dc_inst.x6.net19 0.02517f
C6365 dc_inst.x6.x18/a_27_47# dc_inst.x8/a_27_413# 0
C6366 dc_inst.x1.net14 dc_inst.x5.net1 0
C6367 dc_inst.x4.x11/a_27_47# dc_inst.x6.x13/a_27_47# 0
C6368 dc_inst.x4.net3 dc_inst.x2.x19/a_27_47# 0
C6369 dc_inst.net3 dc_inst.x3.x3/a_27_47# 0
C6370 dc_inst.x1.net10 _07_ 0
C6371 _24_/a_1108_47# dc_inst.net2 0
C6372 _02_ dc_inst.x8/a_1478_413# 0
C6373 dc_inst.x7.x3/a_27_47# dc_inst.in 0
C6374 dc_inst.x1.net2 _15_/a_600_345# 0.00449f
C6375 dc_inst.x1.net3 _15_/a_372_413# 0.00127f
C6376 VPWR dc_inst.x4.x16/a_27_47# -0.00707f
C6377 dc_inst.x9/a_27_413# delay_sel[1] 0
C6378 dc_inst.x9/a_247_21# dc_inst.net7 0.02504f
C6379 dc_inst.net3 dc_inst.x3.x16/a_27_47# 0
C6380 rst dc_inst.x7.x20/a_27_47# 0.04098f
C6381 dc_inst.x9/a_277_47# delay_sel[0] 0.02799f
C6382 dc_inst.x6.net9 dc_inst.x6.net11 0
C6383 dc_inst.net5 dc_inst.x6.net11 0
C6384 clknet_1_0__leaf_clk delay_sel[0] 0
C6385 dc_inst.x5.net12 dc_inst.x4.net9 0
C6386 dc_inst.net4 dc_inst.x4.net18 0
C6387 VPWR path[0] 0.25473f
C6388 dc_inst.x5.net7 dc_inst.x2.net3 0.02181f
C6389 dc_inst.x2.net12 dc_inst.x2.net10 0.02462f
C6390 dc_inst.x6.x1/a_27_47# dc_inst.x6.net17 0
C6391 dc_inst.x5.net6 dc_inst.x2.x14/a_27_47# 0.00177f
C6392 VPWR dc_inst.x1.x15/a_27_47# -0.00177f
C6393 dc_inst.x10/a_505_21# dc_inst.x3.net16 0
C6394 dc_inst.x5.x5/a_27_47# dc_inst.x5.net12 0
C6395 dc_inst.x5.net4 dc_inst.x2.net12 0
C6396 dc_inst.x2.x10/a_27_47# dc_inst.x5.net1 0.00253f
C6397 dc_inst.x2.net1 dc_inst.x5.x10/a_27_47# 0.01149f
C6398 dc_inst.x6.net4 dc_inst.x7.net10 0
C6399 dc_inst.x5.x20/a_27_47# dc_inst.x7.net5 0
C6400 _10_ _17_/a_27_93# 0
C6401 _19_/a_465_47# _08_ 0
C6402 _18_/a_505_21# path_sel[0] 0.02522f
C6403 dc_inst.x1.x15/a_27_47# path_sel[2] 0.00974f
C6404 se dc_inst.x3.net17 0
C6405 _15_/a_872_316# dc_inst.in 0
C6406 VPWR dc_inst.x2.x4/a_27_47# 0.00937f
C6407 dc_inst.x1.net3 dc_inst.x3.x18/a_27_47# 0
C6408 dc_inst.x5.net14 dc_inst.x5.x15/a_27_47# 0.01884f
C6409 dc_inst.x2.x19/a_27_47# dc_inst.x2.net19 0.04302f
C6410 dc_inst.x5.x15/a_27_47# dc_inst.x5.x13/a_27_47# 0
C6411 dc_inst.x1.net10 dc_inst.x5.x9/a_27_47# 0
C6412 dc_inst.x6.net18 dc_inst.x4.x6/a_27_47# 0
C6413 dc_inst.x4.net7 dc_inst.x4.net8 0.01401f
C6414 dc_inst.x2.x4/a_27_47# path_sel[2] 0.00219f
C6415 dc_inst.x6.x9/a_27_47# dc_inst.x4.x19/a_27_47# 0
C6416 dc_inst.x6.net2 dc_inst.x7.net8 0.0719f
C6417 dc_inst.x1.x10/a_27_47# dc_inst.x1.net12 0
C6418 dc_inst.x2.x5/a_27_47# dc_inst.x2.net13 0.00164f
C6419 dc_inst.x1.net17 dc_inst.x6.net13 0
C6420 _04_ dc_inst.x1.x12/a_27_47# 0
C6421 dc_inst.x1.net2 path[6] 0.10756f
C6422 dc_inst.x7.net3 dc_inst.x6.net17 0
C6423 tdo dc_inst.x4.x6/a_27_47# 0.00826f
C6424 tdo dc_inst.x5.net7 0.20438f
C6425 dc_inst.x9/a_668_97# delay_sel[1] 0.04573f
C6426 dc_inst.x1.net15 dc_inst.x8/a_247_21# 0
C6427 delay_sel[1] dc_inst.x7.net16 0
C6428 dc_inst.x7.net2 dc_inst.x7.net8 0
C6429 dc_inst.x3.net3 delay_sel[1] 0
C6430 dc_inst.x1.x3/a_27_47# dc_inst.x3.x7/a_27_47# 0
C6431 dc_inst.net6 dc_inst.x9/a_750_97# 0.0899f
C6432 dc_inst.x2.net17 dc_inst.x1.net14 0
C6433 delay_sel[2] dc_inst.x3.net17 0.00231f
C6434 dc_inst.x3.x14/a_27_47# dc_inst.x3.net13 0.01907f
C6435 dc_inst.x1.net17 dc_inst.x6.net12 0.02879f
C6436 dc_inst.x1.net5 _19_/a_27_47# 0
C6437 path[6] dc_inst.x3.x11/a_27_47# 0.00326f
C6438 rst dc_inst.x8/a_668_97# 0.00102f
C6439 dc_inst.x1.net15 path[6] 0
C6440 path[3] path_sel[0] 0.57785f
C6441 dc_inst.x1.x12/a_27_47# _18_/a_76_199# 0
C6442 dc_inst.x4.net14 dc_inst.net4 0
C6443 path_sel[1] dc_inst.x1.net7 0.10933f
C6444 dc_inst.net3 VPWR 0.76825f
C6445 dc_inst.x1.x15/a_27_47# dc_inst.x1.net8 0.00623f
C6446 dc_inst.x7.net1 dc_inst.x7.x17/a_27_47# 0.00383f
C6447 path[4] _06_ 0.01425f
C6448 path[7] dc_inst.in 0.0034f
C6449 dc_inst.x1.net18 dc_inst.x2.net16 0
C6450 _14_/a_76_199# _13_/a_470_297# 0
C6451 dc_inst.net3 path_sel[2] 0.00267f
C6452 delay_sel[1] dc_inst.x6.net14 0
C6453 dc_inst.x2.x4/a_27_47# dc_inst.x4.net5 0.00168f
C6454 dc_inst.x9/a_750_97# dc_inst.x8/a_277_47# 0
C6455 dc_inst.x9/a_1290_413# dc_inst.x8/a_247_21# 0.00111f
C6456 dc_inst.x2.x7/a_27_47# path_sel[0] 0
C6457 dc_inst.x3.x7/a_27_47# _15_/a_872_316# 0
C6458 VPWR dc_inst.x7.x19/a_27_47# -0.00961f
C6459 dc_inst.x3.x9/a_27_47# dc_inst.x3.x12/a_27_47# 0
C6460 tdo dc_inst.x6.x1/a_27_47# 0.00127f
C6461 clk delay_sel[2] 0.05579f
C6462 delay_sel[1] dc_inst.net9 0.15641f
C6463 dc_inst.x2.x16/a_27_47# dc_inst.in 0
C6464 _13_/a_470_297# dc_inst.x3.net14 0
C6465 dc_inst.x6.net5 dc_inst.x4.net19 0
C6466 dc_inst.x4.net12 dc_inst.x5.x1/a_27_47# 0.00265f
C6467 dc_inst.x4.x13/a_27_47# dc_inst.net4 0.00573f
C6468 dc_inst.x5.net17 path_sel[1] 0.00636f
C6469 _23_/a_543_47# _03_ 0
C6470 dc_inst.x5.x8/a_27_47# path_sel[1] 0.00395f
C6471 dc_inst.x1.net17 path_sel[1] 0.00212f
C6472 dc_inst.x6.x19/a_27_47# dc_inst.x7.net5 0
C6473 path[6] dc_inst.x3.net19 0.13869f
C6474 VPWR dc_inst.x4.x8/a_27_47# 0.00602f
C6475 dc_inst.x3.net15 _23_/a_193_47# 0
C6476 _01_ dc_inst.net2 0.00126f
C6477 dc_inst.x7.x17/a_27_47# dc_inst.x7.x18/a_27_47# 0.02448f
C6478 dc_inst.x4.net3 dc_inst.x1.x16/a_27_47# 0
C6479 dc_inst.x1.x12/a_27_47# path[2] 0.00154f
C6480 dc_inst.x2.x4/a_27_47# dc_inst.x2.net2 0
C6481 _24_/a_1283_21# dc_inst.x3.net16 0.00161f
C6482 path_sel[2] dc_inst.x4.x8/a_27_47# 0.00212f
C6483 dc_inst.x1.net11 dc_inst.x5.x12/a_27_47# 0
C6484 dc_inst.x1.net5 dc_inst.x1.net12 0.05871f
C6485 se _13_/a_470_47# 0
C6486 dc_inst.x7.x4/a_27_47# dc_inst.x7.net6 0.02965f
C6487 dc_inst.x6.net7 dc_inst.x4.x20/a_27_47# 0.00127f
C6488 dc_inst.x3.net12 dc_inst.x3.x13/a_27_47# 0.04669f
C6489 dc_inst.net3 dc_inst.x1.net8 0
C6490 delay_sel[0] dc_inst.x8/a_247_21# 0.02439f
C6491 dc_inst.x6.net5 dc_inst.x6.net6 0.2845f
C6492 dc_inst.x3.x1/a_27_47# dc_inst.in 0
C6493 dc_inst.x7.net3 tdo 0.03726f
C6494 _23_/a_805_47# shadow_q 0
C6495 delay_sel[2] _23_/a_651_413# 0.00332f
C6496 capture_d _23_/a_639_47# 0.00158f
C6497 dc_inst.net8 _23_/a_448_47# 0
C6498 dc_inst.x3.net2 dc_inst.x8/a_668_97# 0
C6499 dc_inst.x6.x1/a_27_47# dc_inst.x9/a_277_47# 0
C6500 dc_inst.net5 dc_inst.x9/a_27_413# 0.00554f
C6501 _13_/a_470_297# _05_ 0.02426f
C6502 dc_inst.x5.net19 dc_inst.x6.net14 0
C6503 path_sel[1] dc_inst.x2.net14 0.01339f
C6504 path_sel[1] dc_inst.x5.net12 0.0618f
C6505 VPWR dc_inst.x6.x9/a_27_47# 0.00645f
C6506 dc_inst.x4.net4 dc_inst.x7.net2 0
C6507 dc_inst.net6 dc_inst.x6.net2 0.1245f
C6508 dc_inst.x5.x20/a_27_47# dc_inst.x7.net9 0.00177f
C6509 dc_inst.in dc_inst.x7.net10 0
C6510 _02_ dc_inst.net3 0
C6511 rst dc_inst.x3.net5 0
C6512 dc_inst.x2.net7 dc_inst.x5.net3 0.01987f
C6513 dc_inst.x6.x9/a_27_47# path_sel[2] 0.00582f
C6514 dc_inst.x5.x18/a_27_47# dc_inst.x5.net18 0.04365f
C6515 path[3] dc_inst.x1.net7 0.04466f
C6516 dc_inst.x6.x3/a_27_47# dc_inst.x6.x4/a_27_47# 0
C6517 dc_inst.net4 dc_inst.x7.x6/a_27_47# 0.00304f
C6518 dc_inst.x7.net14 dc_inst.x7.net1 0.02173f
C6519 dc_inst.net6 dc_inst.x7.net2 0.21725f
C6520 path_sel[0] dc_inst.x4.x19/a_27_47# 0.00266f
C6521 dc_inst.x3.net15 _23_/a_1462_47# 0
C6522 dc_inst.x1.x10/a_27_47# dc_inst.in 0
C6523 VPWR _23_/a_543_47# 0.03776f
C6524 dc_inst.x6.net14 dc_inst.x8/a_27_47# 0
C6525 VPWR dc_inst.x2.net13 0.01809f
C6526 dc_inst.x1.x3/a_27_47# path[7] 0
C6527 dc_inst.x6.net7 dc_inst.x6.net8 0.00418f
C6528 dc_inst.x4.x9/a_27_47# dc_inst.x4.net10 0.01506f
C6529 clknet_1_1__leaf_clk dc_inst.x3.net16 0
C6530 dc_inst.x6.net3 dc_inst.x5.net18 0
C6531 dc_inst.x1.x17/a_27_47# dc_inst.x2.x15/a_27_47# 0
C6532 dc_inst.x2.x8/a_27_47# path_sel[1] 0.01054f
C6533 dc_inst.x4.net3 dc_inst.x6.net17 0.00309f
C6534 path_sel[2] dc_inst.x2.net13 0.00235f
C6535 VPWR _14_/a_505_21# 0.04283f
C6536 dc_inst.x7.x11/a_27_47# clknet_1_0__leaf_clk 0.00207f
C6537 dc_inst.x3.net4 shadow_q 0
C6538 dc_inst.x7.net3 clknet_1_0__leaf_clk 0
C6539 dc_inst.x2.net11 dc_inst.x5.net9 0
C6540 dc_inst.x5.x10/a_27_47# path_sel[1] 0.00492f
C6541 dc_inst.x1.x13/a_27_47# dc_inst.x1.net16 0
C6542 clkbuf_1_1__f_clk/a_110_47# _23_/a_1283_21# 0.00222f
C6543 delay_sel[1] dc_inst.x8/a_193_47# 0
C6544 dc_inst.net9 dc_inst.x8/a_27_47# 0.10522f
C6545 capture_d shadow_q 0
C6546 dc_inst.x3.net3 dc_inst.net2 0.00735f
C6547 dc_inst.x6.net5 dc_inst.x6.x11/a_27_47# 0
C6548 dc_inst.x6.x4/a_27_47# dc_inst.x6.net11 0
C6549 dc_inst.x1.net10 dc_inst.x1.net11 0
C6550 dc_inst.x7.net19 dc_inst.x7.net6 0
C6551 dc_inst.x2.net10 _08_ 0
C6552 VPWR dc_inst.x7.x17/a_27_47# -0.00756f
C6553 _24_/a_1108_47# _23_/a_1283_21# 0.00515f
C6554 _24_/a_1283_21# _23_/a_1108_47# 0.00363f
C6555 dc_inst.x3.x8/a_27_47# dc_inst.x3.net12 0
C6556 dc_inst.x7.x14/a_27_47# dc_inst.x7.net18 0.03732f
C6557 dc_inst.x5.x19/a_27_47# dc_inst.x5.net6 0
C6558 dc_inst.x6.x6/a_27_47# dc_inst.x6.net7 0.00338f
C6559 _13_/a_112_47# clkbuf_1_1__f_clk/a_110_47# 0.00112f
C6560 _15_/a_872_316# path[7] 0.05277f
C6561 _15_/a_788_316# path[4] 0.03197f
C6562 _15_/a_600_345# path[5] 0.00518f
C6563 dc_inst.x2.x14/a_27_47# dc_inst.x2.x15/a_27_47# 0
C6564 dc_inst.x1.net15 dc_inst.x2.net5 0
C6565 _10_ dc_inst.x3.x14/a_27_47# 0
C6566 dc_inst.x1.net4 dc_inst.x3.net3 0.02338f
C6567 dc_inst.x2.net6 dc_inst.x5.x9/a_27_47# 0
C6568 delay_sel[2] dc_inst.x3.net15 0
C6569 dc_inst.x4.x2/a_27_47# dc_inst.x1.x19/a_27_47# 0
C6570 delay_sel[1] dc_inst.x6.net13 0
C6571 VPWR dc_inst.x10/a_505_21# 0.05891f
C6572 _00_ dc_inst.x3.net16 0.00295f
C6573 dc_inst.x5.net17 dc_inst.x6.net10 0
C6574 dc_inst.x2.net11 dc_inst.x2.x9/a_27_47# 0.03129f
C6575 dc_inst.x2.x11/a_27_47# dc_inst.x2.net10 0.0448f
C6576 dc_inst.x8/a_277_47# dc_inst.x8/a_757_363# -0
C6577 dc_inst.x8/a_247_21# dc_inst.x8/a_750_97# -0.02899f
C6578 dc_inst.net5 dc_inst.x6.net14 0
C6579 dc_inst.x7.net13 dc_inst.x7.net18 0.01026f
C6580 dc_inst.x7.x10/a_27_47# dc_inst.x7.x6/a_27_47# 0.01254f
C6581 dc_inst.x7.net12 delay_sel[2] 0
C6582 _24_/a_1283_21# _13_/a_27_297# 0
C6583 _24_/a_1108_47# _13_/a_112_47# 0
C6584 dc_inst.x2.net19 dc_inst.x6.net17 0
C6585 delay_sel[1] dc_inst.x7.x9/a_27_47# 0
C6586 dc_inst.x7.x2/a_27_47# dc_inst.net7 0.03242f
C6587 VPWR tdi 0.01035f
C6588 dc_inst.x3.net2 dc_inst.x3.net5 0
C6589 dc_inst.x4.x15/a_27_47# path_sel[0] 0.00256f
C6590 dc_inst.x4.net12 dc_inst.x4.net18 0
C6591 dc_inst.x2.x18/a_27_47# _10_ 0
C6592 se dc_inst.x3.net6 0
C6593 dc_inst.x5.net5 dc_inst.x5.net7 0
C6594 dc_inst.x4.x12/a_27_47# dc_inst.net4 0
C6595 dc_inst.x7.x3/a_27_47# dc_inst.x3.x1/a_27_47# 0.04629f
C6596 dc_inst.x3.x11/a_27_47# dc_inst.x3.x10/a_27_47# 0
C6597 delay_sel[1] dc_inst.x6.net12 0
C6598 path[6] dc_inst.x8/a_750_97# 0
C6599 _15_/a_288_47# dc_inst.net2 0.00238f
C6600 path_sel[0] path[1] 0.08275f
C6601 dc_inst.net6 dc_inst.x6.x12/a_27_47# 0.0012f
C6602 _06_ dc_inst.x3.net1 0
C6603 dc_inst.x1.net18 dc_inst.x2.net15 0
C6604 dc_inst.x1.net19 dc_inst.x6.x10/a_27_47# 0
C6605 dc_inst.x1.net5 dc_inst.in 0.06056f
C6606 dc_inst.x9/a_247_21# dc_inst.x7.net5 0.00748f
C6607 _24_/a_27_47# shadow_q 0
C6608 _02_ _23_/a_543_47# 0.00248f
C6609 dc_inst.x7.net12 dc_inst.x7.x15/a_27_47# 0.00243f
C6610 _25_/a_1108_47# dc_inst.x7.net1 0.0018f
C6611 dc_inst.x2.net11 dc_inst.x2.net9 0.01471f
C6612 dc_inst.x2.x7/a_27_47# dc_inst.x5.net12 0
C6613 dc_inst.x2.x17/a_27_47# path_sel[1] 0
C6614 path[6] path[5] 0.14723f
C6615 dc_inst.x2.net13 dc_inst.x2.net2 0
C6616 _02_ _14_/a_505_21# 0.04491f
C6617 dc_inst.x1.net4 _15_/a_288_47# 0.00232f
C6618 dc_inst.x7.x8/a_27_47# dc_inst.x7.net6 0
C6619 VPWR path_sel[0] 0.66682f
C6620 dc_inst.x4.net3 tdo 0
C6621 dc_inst.x5.x4/a_27_47# dc_inst.x2.x12/a_27_47# 0
C6622 clknet_1_1__leaf_clk _13_/a_27_297# 0
C6623 dc_inst.x3.x8/a_27_47# shadow_q 0
C6624 _25_/a_761_289# dc_inst.x7.net17 0
C6625 dc_inst.net4 dc_inst.x7.net8 0
C6626 dc_inst.x3.net19 dc_inst.x3.x10/a_27_47# 0
C6627 path_sel[2] path_sel[0] 0.0031f
C6628 dc_inst.x9/a_923_363# dc_inst.net4 0
C6629 dc_inst.x3.net5 _15_/a_27_47# 0
C6630 dc_inst.x6.net4 dc_inst.x6.net6 0
C6631 dc_inst.x7.net14 VPWR 0.01967f
C6632 dc_inst.x6.net11 dc_inst.x5.net3 0
C6633 dc_inst.x5.x17/a_27_47# dc_inst.x4.net19 0
C6634 dc_inst.x4.net16 dc_inst.x4.net9 0.0438f
C6635 dc_inst.x4.net2 dc_inst.in 0.04686f
C6636 dc_inst.x2.x7/a_27_47# dc_inst.x2.x8/a_27_47# 0
C6637 dc_inst.x5.net19 dc_inst.x7.x9/a_27_47# 0.03292f
C6638 dc_inst.x3.net7 dc_inst.x3.x13/a_27_47# 0.01633f
C6639 dc_inst.x2.x4/a_27_47# dc_inst.x2.net12 0.00101f
C6640 dc_inst.x4.net16 dc_inst.x5.x5/a_27_47# 0
C6641 dc_inst.x4.x14/a_27_47# path_sel[1] 0.00451f
C6642 dc_inst.x5.net19 dc_inst.x6.net12 0
C6643 tdo _23_/a_193_47# 0.03504f
C6644 _25_/a_27_47# capture_d 0
C6645 _20_/a_79_21# dc_inst.x3.x14/a_27_47# 0
C6646 dc_inst.x4.net14 dc_inst.x4.net12 0
C6647 delay_sel[0] dc_inst.x7.x4/a_27_47# 0.01187f
C6648 _24_/a_1217_47# shadow_q 0
C6649 _24_/a_1270_413# delay_sel[2] 0
C6650 _24_/a_805_47# capture_d 0
C6651 dc_inst.x2.net1 dc_inst.x1.net9 0
C6652 _00_ dc_inst.x7.net1 0.03796f
C6653 delay_sel[2] dc_inst.x6.net17 0
C6654 clknet_1_1__leaf_clk dc_inst.x3.x16/a_27_47# 0
C6655 dc_inst.x2.net19 dc_inst.x6.net18 0
C6656 dc_inst.x2.x5/a_27_47# dc_inst.x2.net14 0.00103f
C6657 _00_ _14_/a_535_374# 0
C6658 dc_inst.x2.x5/a_27_47# dc_inst.x5.net12 0
C6659 _02_ tdi 0.0433f
C6660 dc_inst.x7.net19 dc_inst.x9/a_1290_413# 0.00356f
C6661 dc_inst.x5.x6/a_27_47# dc_inst.x5.net7 0.00319f
C6662 dc_inst.x4.net17 dc_inst.x4.x20/a_27_47# 0.00185f
C6663 dc_inst.x5.x6/a_27_47# dc_inst.x4.x6/a_27_47# 0
C6664 dc_inst.x1.x4/a_27_47# path[6] 0
C6665 _25_/a_1108_47# _03_ 0.00291f
C6666 dc_inst.x7.net3 dc_inst.x8/a_247_21# 0
C6667 clknet_1_1__leaf_clk _03_ 0
C6668 tdo dc_inst.x2.net19 0
C6669 _01_ _23_/a_1283_21# 0.01276f
C6670 rst _23_/a_448_47# 0
C6671 dc_inst.x7.x11/a_27_47# dc_inst.x7.x12/a_27_47# 0.01013f
C6672 dc_inst.x6.net10 dc_inst.x7.x5/a_27_47# 0
C6673 _00_ _13_/a_27_297# 0.01366f
C6674 dc_inst.x5.net14 dc_inst.x4.net18 0
C6675 dc_inst.x5.net13 dc_inst.x4.net19 0
C6676 dc_inst.x5.x17/a_27_47# dc_inst.x6.net6 0
C6677 dc_inst.x1.net18 dc_inst.x2.net7 0
C6678 dc_inst.net4 dc_inst.x4.net7 0
C6679 clkbuf_0_clk/a_110_47# clkload0/X 0
C6680 dc_inst.x4.x13/a_27_47# dc_inst.x4.net12 0.05174f
C6681 _24_/a_1283_21# VPWR -0.00364f
C6682 dc_inst.x5.net12 dc_inst.x4.x19/a_27_47# 0.00484f
C6683 dc_inst.x5.x13/a_27_47# dc_inst.x4.net18 0.00214f
C6684 dc_inst.x4.x7/a_27_47# dc_inst.x4.x8/a_27_47# 0.01543f
C6685 dc_inst.x3.x4/a_27_47# path[6] 0.01847f
C6686 _14_/a_218_47# rst 0
C6687 _13_/a_112_47# dc_inst.x3.x5/a_27_47# 0
C6688 dc_inst.x5.x20/a_27_47# dc_inst.x7.net7 0.01105f
C6689 dc_inst.x6.x3/a_27_47# dc_inst.x6.net11 0
C6690 path_sel[0] dc_inst.x1.net8 0.00266f
C6691 dc_inst.x7.net12 _25_/a_543_47# 0
C6692 dc_inst.x5.x14/a_27_47# dc_inst.x5.net2 0.00421f
C6693 dc_inst.x5.net13 dc_inst.x5.x2/a_27_47# 0.03174f
C6694 dc_inst.x5.net19 path_sel[1] 0.00134f
C6695 dc_inst.x4.net4 dc_inst.x4.x1/a_27_47# 0
C6696 clknet_0_clk _23_/a_543_47# 0
C6697 clknet_1_0__leaf_clk _23_/a_193_47# 0.00103f
C6698 dc_inst.x4.net4 dc_inst.x7.net4 0
C6699 _24_/a_1108_47# clkbuf_1_1__f_clk/a_110_47# 0.00771f
C6700 dc_inst.x5.net15 path_sel[0] 0
C6701 dc_inst.x3.net8 dc_inst.x3.net16 0
C6702 dc_inst.x4.x18/a_27_47# dc_inst.x4.net19 0
C6703 dc_inst.x4.net17 dc_inst.x6.net8 0
C6704 _00_ dc_inst.x3.x16/a_27_47# 0
C6705 dc_inst.net6 dc_inst.x7.net4 0.04748f
C6706 dc_inst.x5.net16 dc_inst.x6.net7 0.04145f
C6707 dc_inst.x1.net15 dc_inst.x2.x18/a_27_47# 0
C6708 dc_inst.x1.net3 _13_/a_470_297# 0
C6709 VPWR dc_inst.x1.net7 0.03565f
C6710 dc_inst.x3.net7 dc_inst.x3.x8/a_27_47# 0.00109f
C6711 _25_/a_27_47# _24_/a_27_47# 0
C6712 dc_inst.x7.net19 delay_sel[0] 0
C6713 dc_inst.x2.net16 dc_inst.x6.net12 0
C6714 _00_ _03_ 0.09864f
C6715 dc_inst.x4.net16 dc_inst.x6.net13 0
C6716 dc_inst.x5.net9 _16_/a_229_47# 0
C6717 path_sel[2] dc_inst.x1.net7 0.16364f
C6718 dc_inst.x10/a_218_374# _01_ 0
C6719 dc_inst.x1.net16 dc_inst.x1.x16/a_27_47# 0.01914f
C6720 dc_inst.net5 dc_inst.x7.x9/a_27_47# 0.00148f
C6721 dc_inst.x4.x11/a_27_47# dc_inst.x4.net12 0.00194f
C6722 _25_/a_1108_47# VPWR -0.00109f
C6723 dc_inst.x2.net6 dc_inst.x5.net10 0
C6724 dc_inst.x1.net18 dc_inst.x5.net3 0
C6725 dc_inst.net5 dc_inst.x6.net12 0.00273f
C6726 clknet_1_1__leaf_clk VPWR 0.19797f
C6727 _15_/a_788_316# dc_inst.x3.net1 0
C6728 dc_inst.net3 dc_inst.x8/a_27_413# 0
C6729 dc_inst.x3.x14/a_27_47# dc_inst.x3.net19 0
C6730 dc_inst.x7.net4 dc_inst.x8/a_277_47# 0.02539f
C6731 dc_inst.x4.net16 dc_inst.x6.net12 0
C6732 dc_inst.x4.net17 dc_inst.x6.x6/a_27_47# 0
C6733 dc_inst.net6 dc_inst.net4 0.21467f
C6734 dc_inst.x2.net5 dc_inst.x5.net7 0
C6735 dc_inst.x4.net15 dc_inst.x5.net13 0
C6736 dc_inst.x10/a_505_21# clknet_0_clk 0
C6737 VPWR dc_inst.x5.net17 0.40791f
C6738 dc_inst.x1.net17 VPWR 0.23121f
C6739 dc_inst.x7.net1 dc_inst.x9/a_193_47# 0
C6740 tdo delay_sel[2] 0.00435f
C6741 dc_inst.x4.x15/a_27_47# dc_inst.x5.net12 0.00185f
C6742 VPWR dc_inst.x5.x8/a_27_47# 0.06584f
C6743 dc_inst.x5.net17 path_sel[2] 0.00461f
C6744 dc_inst.x2.net16 path_sel[1] 0
C6745 path[1] dc_inst.x5.net12 0
C6746 tdo dc_inst.x6.net7 0
C6747 dc_inst.x1.net17 path_sel[2] 0.03356f
C6748 _25_/a_27_47# _25_/a_193_47# -0.28991f
C6749 clkbuf_1_0__f_clk/a_110_47# dc_inst.x5.x20/a_27_47# 0
C6750 _25_/a_1108_47# _24_/a_448_47# 0
C6751 dc_inst.x6.net5 dc_inst.x6.x14/a_27_47# 0
C6752 dc_inst.x6.x4/a_27_47# dc_inst.x6.net14 0
C6753 _24_/a_1283_21# _02_ 0.05984f
C6754 _24_/a_193_47# capture_q 0
C6755 _24_/a_448_47# clknet_1_1__leaf_clk 0.01492f
C6756 capture_d dc_inst.in 0.20259f
C6757 path_sel[1] dc_inst.net2 0
C6758 dc_inst.x4.x18/a_27_47# dc_inst.x4.net15 0.04066f
C6759 dc_inst.x6.net9 path_sel[1] 0.00282f
C6760 dc_inst.x4.net5 dc_inst.x1.net7 0
C6761 _13_/a_112_47# dc_inst.x3.net3 0
C6762 path[3] _15_/a_1281_47# 0
C6763 tdo dc_inst.x7.x15/a_27_47# 0
C6764 dc_inst.x4.x11/a_27_47# dc_inst.x4.net1 0.02333f
C6765 dc_inst.x1.net7 dc_inst.x1.net8 0.0134f
C6766 dc_inst.x6.net18 dc_inst.x6.x20/a_27_47# 0
C6767 _00_ VPWR 2.27735f
C6768 dc_inst.x4.net16 path_sel[1] 0.04523f
C6769 path[5] dc_inst.x3.x10/a_27_47# 0.00431f
C6770 dc_inst.net3 dc_inst.x8/a_668_97# 0.0011f
C6771 dc_inst.x7.x13/a_27_47# dc_inst.x9/a_27_413# 0.01254f
C6772 dc_inst.x1.net5 path[7] 0
C6773 VPWR dc_inst.x2.net14 0.17534f
C6774 dc_inst.x2.net12 dc_inst.x2.net13 0.19109f
C6775 VPWR dc_inst.x5.net12 0.16255f
C6776 delay_sel[0] dc_inst.x7.x8/a_27_47# 0
C6777 tdo dc_inst.x6.x20/a_27_47# 0
C6778 dc_inst.x1.net4 path_sel[1] 0.07316f
C6779 dc_inst.x4.net13 dc_inst.x5.net8 0.04376f
C6780 dc_inst.x5.net7 dc_inst.x2.x3/a_27_47# 0.00188f
C6781 delay_sel[1] _23_/a_1108_47# 0
C6782 dc_inst.x4.x17/a_27_47# dc_inst.x4.net13 0
C6783 dc_inst.x5.net6 dc_inst.x2.x15/a_27_47# 0
C6784 dc_inst.x1.net6 dc_inst.x1.x6/a_27_47# 0.05353f
C6785 delay_sel[2] clknet_1_0__leaf_clk 0
C6786 dc_inst.x3.x2/a_27_47# shadow_q 0
C6787 path_sel[2] dc_inst.x2.net14 0.00395f
C6788 dc_inst.x7.net15 rst 0
C6789 _17_/a_27_93# dc_inst.x5.net11 0
C6790 path_sel[2] dc_inst.x5.net12 0.00119f
C6791 dc_inst.x7.net1 delay_sel[1] 0.03242f
C6792 dc_inst.x6.x18/a_27_47# dc_inst.x6.x19/a_27_47# 0
C6793 dc_inst.x4.net3 dc_inst.x8/a_247_21# 0
C6794 dc_inst.x7.x6/a_27_47# dc_inst.x7.net6 0.01693f
C6795 dc_inst.x6.net3 dc_inst.x6.x5/a_27_47# 0
C6796 dc_inst.x1.net18 dc_inst.x6.net11 0
C6797 _13_/a_27_297# dc_inst.x3.net8 0
C6798 dc_inst.x5.net8 dc_inst.x4.x5/a_27_47# 0
C6799 dc_inst.x5.x8/a_27_47# dc_inst.x4.net5 0
C6800 dc_inst.x5.net19 dc_inst.x6.net10 0
C6801 dc_inst.x1.net17 dc_inst.x4.net5 0.22053f
C6802 dc_inst.x5.x20/a_27_47# dc_inst.x9/a_27_47# 0
C6803 dc_inst.x2.net10 _07_ 0
C6804 path[0] _08_ 0
C6805 _00_ _24_/a_448_47# 0.01619f
C6806 tdo _24_/a_761_289# 0
C6807 dc_inst.x5.x14/a_27_47# dc_inst.x5.x16/a_27_47# 0
C6808 dc_inst.x1.net17 dc_inst.x1.net8 0
C6809 dc_inst.x1.net10 dc_inst.x5.x11/a_27_47# 0
C6810 clknet_1_1__leaf_clk _02_ 0.00742f
C6811 dc_inst.x4.x12/a_27_47# dc_inst.x4.net12 0.01506f
C6812 _01_ clkbuf_1_1__f_clk/a_110_47# 0
C6813 VPWR dc_inst.x7.x7/a_27_47# -0.00759f
C6814 dc_inst.x7.x15/a_27_47# dc_inst.x9/a_277_47# 0
C6815 dc_inst.x7.net15 clkbuf_1_0__f_clk/a_110_47# 0.00603f
C6816 dc_inst.x7.x15/a_27_47# clknet_1_0__leaf_clk 0.00123f
C6817 dc_inst.x2.net19 _15_/a_600_345# 0
C6818 path_sel[1] dc_inst.x1.net9 0.01419f
C6819 delay_sel[0] dc_inst.x7.net17 0
C6820 VPWR dc_inst.x2.x8/a_27_47# 0
C6821 VPWR dc_inst.x5.x10/a_27_47# -0.00799f
C6822 dc_inst.x5.net15 dc_inst.x5.net17 0
C6823 dc_inst.x1.net1 path_sel[1] 0.0282f
C6824 dc_inst.x6.net2 dc_inst.x6.net5 0
C6825 path_sel[2] dc_inst.x7.x7/a_27_47# 0.00669f
C6826 dc_inst.x6.x3/a_27_47# dc_inst.x9/a_27_413# 0
C6827 _04_ path_sel[1] 0.00118f
C6828 dc_inst.x1.net11 _19_/a_465_47# 0
C6829 _23_/a_27_47# dc_inst.x8/a_277_47# 0
C6830 _24_/a_27_47# dc_inst.in 0.00382f
C6831 dc_inst.x1.x1/a_27_47# dc_inst.x2.x20/a_27_47# 0
C6832 dc_inst.x1.net19 dc_inst.x4.x5/a_27_47# 0
C6833 dc_inst.x9/a_277_47# dc_inst.x6.x20/a_27_47# 0
C6834 _15_/a_788_316# dc_inst.x3.net14 0
C6835 path_sel[2] dc_inst.x2.x8/a_27_47# 0
C6836 clknet_1_0__leaf_clk dc_inst.x6.x20/a_27_47# 0
C6837 _24_/a_1108_47# _01_ 0
C6838 _24_/a_651_413# rst 0
C6839 rst dc_inst.x6.x19/a_27_47# 0
C6840 dc_inst.x5.net6 dc_inst.x2.net8 0.01844f
C6841 dc_inst.x2.net7 dc_inst.x2.net1 0
C6842 dc_inst.x1.x13/a_27_47# dc_inst.x5.x12/a_27_47# 0
C6843 dc_inst.x4.net1 dc_inst.x5.net9 0
C6844 delay_sel[1] dc_inst.x7.x18/a_27_47# 0
C6845 dc_inst.x1.net17 dc_inst.x2.net2 0.0051f
C6846 dc_inst.x10/a_439_47# dc_inst.net7 0
C6847 dc_inst.x2.net14 dc_inst.x4.net5 0.00506f
C6848 path[6] _23_/a_193_47# 0
C6849 dc_inst.x5.x18/a_27_47# dc_inst.x6.net8 0
C6850 VPWR dc_inst.x7.x5/a_27_47# 0.05328f
C6851 dc_inst.x2.net10 dc_inst.x5.x9/a_27_47# 0
C6852 _09_ _17_/a_27_93# 0.00109f
C6853 _18_/a_76_199# path_sel[1] 0.00218f
C6854 dc_inst.x2.net14 dc_inst.x1.net8 0
C6855 dc_inst.x3.x7/a_27_47# dc_inst.x3.x13/a_27_47# 0
C6856 dc_inst.x3.net16 dc_inst.net2 0.03238f
C6857 dc_inst.x3.net18 dc_inst.x3.net12 0
C6858 path_sel[2] dc_inst.x7.x5/a_27_47# 0.00254f
C6859 dc_inst.x7.x3/a_27_47# dc_inst.x3.net4 0
C6860 dc_inst.x5.net19 dc_inst.x7.net1 0.00377f
C6861 _25_/a_651_413# _00_ 0.00153f
C6862 _25_/a_543_47# tdo 0
C6863 delay_sel[1] _03_ 0
C6864 dc_inst.x6.net3 dc_inst.x6.net8 0
C6865 _00_ _02_ 0.09234f
C6866 dc_inst.x2.net7 dc_inst.x4.net9 0
C6867 dc_inst.x3.x14/a_27_47# dc_inst.x8/a_750_97# 0
C6868 dc_inst.x1.net1 _18_/a_505_21# 0
C6869 dc_inst.x2.net15 dc_inst.x6.net13 0
C6870 _04_ _18_/a_505_21# 0
C6871 dc_inst.x2.net19 path[6] 0.00241f
C6872 dc_inst.x5.net18 dc_inst.x7.net9 0
C6873 VPWR dc_inst.x9/a_193_47# -0
C6874 path[4] dc_inst.x3.net11 0.01078f
C6875 dc_inst.x5.net6 dc_inst.x2.x6/a_27_47# 0.02421f
C6876 dc_inst.x5.x5/a_27_47# dc_inst.x2.net7 0.12349f
C6877 dc_inst.x1.net5 dc_inst.x1.x10/a_27_47# 0
C6878 dc_inst.x4.x10/a_27_47# dc_inst.x4.net1 0.00882f
C6879 dc_inst.x2.net14 dc_inst.x2.net2 0
C6880 _23_/a_543_47# dc_inst.x8/a_668_97# 0
C6881 dc_inst.x5.net12 dc_inst.x2.net2 0
C6882 tdo dc_inst.x1.net16 0
C6883 dc_inst.x2.x8/a_27_47# dc_inst.x4.net5 0
C6884 dc_inst.x7.net12 dc_inst.net7 0
C6885 path[5] dc_inst.x3.x14/a_27_47# 0.01018f
C6886 dc_inst.x1.net19 dc_inst.net1 0.00208f
C6887 dc_inst.x2.net12 path_sel[0] 0
C6888 dc_inst.x4.net17 dc_inst.x5.net16 0
C6889 dc_inst.x6.net9 dc_inst.x6.net10 0.00377f
C6890 dc_inst.x5.net1 dc_inst.x1.x7/a_27_47# 0
C6891 dc_inst.net5 dc_inst.x6.net10 0
C6892 tdi dc_inst.x3.x18/a_27_47# 0
C6893 dc_inst.x7.net3 dc_inst.x7.net19 0.23399f
C6894 VPWR dc_inst.x2.x17/a_27_47# -0.00355f
C6895 path[2] path_sel[1] 0
C6896 dc_inst.x1.x13/a_27_47# dc_inst.x1.net10 0
C6897 dc_inst.x1.x19/a_27_47# tdo 0
C6898 _25_/a_1108_47# clknet_0_clk 0.02283f
C6899 _25_/a_543_47# dc_inst.x9/a_277_47# 0
C6900 _25_/a_543_47# clknet_1_0__leaf_clk 0.00137f
C6901 clknet_1_1__leaf_clk clknet_0_clk 0.22218f
C6902 dc_inst.x3.x19/a_27_47# shadow_q 0
C6903 dc_inst.x2.x17/a_27_47# path_sel[2] 0.01175f
C6904 se path[6] 0.10529f
C6905 VPWR dc_inst.x3.net8 0.03333f
C6906 dc_inst.x6.x3/a_27_47# dc_inst.x6.net14 0
C6907 dc_inst.x6.net17 dc_inst.x9/a_1478_413# 0
C6908 dc_inst.x4.net9 dc_inst.x5.net3 0
C6909 dc_inst.x1.net1 path[3] 0
C6910 dc_inst.x4.x3/a_27_47# VPWR 0.01464f
C6911 dc_inst.x1.x14/a_27_47# dc_inst.x1.net7 0
C6912 _04_ path[3] 0.0034f
C6913 _15_/a_872_316# dc_inst.x3.x13/a_27_47# 0
C6914 dc_inst.x6.x4/a_27_47# dc_inst.x6.net12 0
C6915 dc_inst.x6.net5 dc_inst.x6.x12/a_27_47# 0.00124f
C6916 dc_inst.x7.net6 dc_inst.x7.net8 0
C6917 dc_inst.x1.net17 dc_inst.x6.x15/a_27_47# 0
C6918 VPWR delay_sel[1] 0.41048f
C6919 dc_inst.x5.x5/a_27_47# dc_inst.x5.net3 0.04903f
C6920 dc_inst.x1.net12 dc_inst.x1.net14 0.1711f
C6921 dc_inst.x7.net12 dc_inst.x6.net3 0
C6922 dc_inst.x9/a_247_21# dc_inst.x7.net7 0
C6923 path_sel[1] dc_inst.x2.net15 0.0016f
C6924 dc_inst.x4.x3/a_27_47# path_sel[2] 0.00687f
C6925 dc_inst.x1.x2/a_27_47# dc_inst.x1.net2 0.01169f
C6926 dc_inst.x7.x3/a_27_47# _24_/a_27_47# 0
C6927 dc_inst.net8 dc_inst.x8/a_193_413# 0.0011f
C6928 _23_/a_1108_47# dc_inst.net2 0
C6929 path_sel[2] delay_sel[1] 0.00158f
C6930 dc_inst.x7.x12/a_27_47# delay_sel[2] 0
C6931 dc_inst.x2.net18 dc_inst.x8/a_834_97# 0
C6932 dc_inst.x4.x14/a_27_47# VPWR 0.05988f
C6933 dc_inst.x6.net11 dc_inst.x6.net14 0.00149f
C6934 path_sel[2] _15_/a_193_369# 0
C6935 tdo dc_inst.x4.net17 0
C6936 _18_/a_505_21# path[2] 0.01266f
C6937 _20_/a_384_47# _06_ 0.00172f
C6938 _18_/a_76_199# path[3] 0.00709f
C6939 dc_inst.net5 dc_inst.x7.net1 0.17975f
C6940 dc_inst.x5.net4 dc_inst.x5.net8 0.00122f
C6941 delay_sel[2] path[6] 0.00495f
C6942 dc_inst.x6.net6 dc_inst.x5.net6 0
C6943 _07_ _15_/a_1064_47# 0
C6944 dc_inst.x1.net15 dc_inst.x1.x2/a_27_47# 0
C6945 dc_inst.x6.net15 delay_sel[1] 0
C6946 dc_inst.x1.x20/a_27_47# dc_inst.x2.x2/a_27_47# 0
C6947 _00_ clknet_0_clk 0.03682f
C6948 dc_inst.x7.x14/a_27_47# dc_inst.x7.net11 0
C6949 dc_inst.x4.net1 dc_inst.x4.net7 0.00367f
C6950 dc_inst.x6.net9 dc_inst.x4.x19/a_27_47# 0
C6951 dc_inst.x2.x17/a_27_47# dc_inst.x4.net5 0.00135f
C6952 dc_inst.x1.net3 _06_ 0
C6953 dc_inst.x2.net17 _10_ 0
C6954 dc_inst.x6.x4/a_27_47# path_sel[1] 0
C6955 capture_q dc_inst.x3.net19 0
C6956 dc_inst.x1.net11 _20_/a_384_47# 0
C6957 dc_inst.x5.x8/a_27_47# dc_inst.x4.x7/a_27_47# 0
C6958 dc_inst.x1.net17 dc_inst.x4.x7/a_27_47# 0
C6959 dc_inst.x5.x15/a_27_47# dc_inst.x6.net7 0.03595f
C6960 dc_inst.x3.x3/a_27_47# dc_inst.net2 0
C6961 dc_inst.x4.net14 dc_inst.x5.net7 0
C6962 dc_inst.x6.net2 dc_inst.x6.net4 0
C6963 dc_inst.x1.x20/a_27_47# dc_inst.net1 0.01484f
C6964 dc_inst.x7.net13 dc_inst.x7.net11 0.00242f
C6965 dc_inst.x2.x19/a_27_47# dc_inst.x2.x20/a_27_47# 0.00104f
C6966 dc_inst.x4.x3/a_27_47# dc_inst.x4.net5 0.00151f
C6967 dc_inst.net8 dc_inst.x8/a_834_97# 0.03005f
C6968 delay_sel[1] dc_inst.x4.net5 0
C6969 dc_inst.x4.net15 dc_inst.x5.net6 0
C6970 dc_inst.x3.x17/a_27_47# dc_inst.x3.net17 0.00875f
C6971 dc_inst.net5 dc_inst.x7.x18/a_27_47# 0
C6972 dc_inst.x1.net3 dc_inst.x1.net11 0.00128f
C6973 VPWR dc_inst.x5.net19 0.1906f
C6974 dc_inst.x4.x4/a_27_47# dc_inst.x2.net18 0
C6975 path[2] path[3] 0.11116f
C6976 dc_inst.x3.net17 dc_inst.x3.net1 0
C6977 dc_inst.x6.net18 dc_inst.x9/a_1478_413# 0
C6978 _02_ dc_inst.x3.net8 0.13594f
C6979 _24_/a_193_47# dc_inst.x8/a_277_47# 0
C6980 dc_inst.x5.net19 path_sel[2] 0.04733f
C6981 dc_inst.x1.net2 dc_inst.x3.x20/a_27_47# 0
C6982 dc_inst.x3.net7 dc_inst.x3.x19/a_27_47# 0
C6983 clkload0/a_27_47# dc_inst.in 0.00159f
C6984 dc_inst.x6.net1 dc_inst.x7.net5 0
C6985 clkbuf_1_0__f_clk/a_110_47# dc_inst.x9/a_247_21# 0.00138f
C6986 dc_inst.x5.net6 dc_inst.x6.x11/a_27_47# 0
C6987 dc_inst.x4.net13 dc_inst.x4.net10 0
C6988 dc_inst.x2.x11/a_27_47# dc_inst.x2.net13 0
C6989 tdo dc_inst.x9/a_1478_413# 0.01619f
C6990 dc_inst.x3.x1/a_27_47# dc_inst.x3.net4 0
C6991 dc_inst.x7.net3 dc_inst.x7.net17 0
C6992 dc_inst.x5.net12 dc_inst.x4.x7/a_27_47# 0
C6993 _02_ delay_sel[1] 0
C6994 dc_inst.x2.net7 path_sel[1] 0.02503f
C6995 VPWR dc_inst.x8/a_27_47# 0.00296f
C6996 dc_inst.x6.x5/a_27_47# dc_inst.x7.net5 0
C6997 _24_/a_761_289# path[6] 0
C6998 dc_inst.x3.net7 dc_inst.x3.net18 0.00283f
C6999 dc_inst.x2.net10 dc_inst.x5.net10 0
C7000 dc_inst.x7.x13/a_27_47# dc_inst.x7.x9/a_27_47# 0
C7001 dc_inst.x1.net15 dc_inst.x3.x20/a_27_47# 0
C7002 dc_inst.x5.net9 dc_inst.x2.x12/a_27_47# 0
C7003 dc_inst.x9/a_750_97# dc_inst.in 0
C7004 dc_inst.x1.x1/a_27_47# dc_inst.x2.net18 0
C7005 dc_inst.x4.x2/a_27_47# dc_inst.x2.net4 0
C7006 dc_inst.x5.net4 dc_inst.x5.net10 0.10069f
C7007 dc_inst.x3.x2/a_27_47# dc_inst.in 0
C7008 dc_inst.x7.net10 dc_inst.x7.net18 0
C7009 clknet_0_clk dc_inst.x7.x5/a_27_47# 0
C7010 dc_inst.x3.net3 _01_ 0
C7011 dc_inst.x1.net18 dc_inst.x6.net14 0
C7012 dc_inst.x6.net5 dc_inst.x7.net4 0
C7013 dc_inst.net6 dc_inst.x7.net6 0.03924f
C7014 dc_inst.x5.x16/a_27_47# dc_inst.x5.net18 0
C7015 dc_inst.x4.net16 dc_inst.x4.x15/a_27_47# 0
C7016 dc_inst.x3.x8/a_27_47# path[7] 0
C7017 dc_inst.x3.net11 dc_inst.x3.net1 0.04049f
C7018 dc_inst.x3.net12 dc_inst.x3.net10 0.25729f
C7019 dc_inst.x6.x10/a_27_47# dc_inst.x6.net1 0.01371f
C7020 dc_inst.x9/a_757_363# dc_inst.x9/a_750_97# -0.0095f
C7021 dc_inst.x9/a_277_47# dc_inst.x9/a_1478_413# -0.00848f
C7022 _25_/a_27_47# dc_inst.x7.net11 0.0046f
C7023 dc_inst.x6.net3 dc_inst.x5.net16 0
C7024 clknet_1_0__leaf_clk dc_inst.x9/a_1478_413# 0
C7025 dc_inst.x4.net11 dc_inst.x4.net10 0.00132f
C7026 VPWR dc_inst.x2.net16 0.00201f
C7027 dc_inst.x1.net14 dc_inst.in 0
C7028 dc_inst.x4.net10 dc_inst.x2.x2/a_27_47# 0
C7029 dc_inst.x6.net19 dc_inst.x6.net13 0
C7030 dc_inst.x4.x11/a_27_47# dc_inst.x4.x6/a_27_47# 0
C7031 dc_inst.x2.net12 dc_inst.x2.net14 0.04686f
C7032 tdo dc_inst.net7 0.00245f
C7033 dc_inst.x2.x12/a_27_47# dc_inst.x2.x9/a_27_47# 0
C7034 dc_inst.x2.net12 dc_inst.x5.net12 0.07285f
C7035 dc_inst.x3.net16 _23_/a_1283_21# 0.00319f
C7036 VPWR dc_inst.net2 0.20633f
C7037 dc_inst.x1.net6 dc_inst.x3.x14/a_27_47# 0
C7038 path_sel[1] dc_inst.x5.net3 0.01861f
C7039 dc_inst.x1.net17 dc_inst.x8/a_27_413# 0
C7040 dc_inst.x2.net16 path_sel[2] 0.01411f
C7041 dc_inst.x3.x20/a_27_47# dc_inst.x3.net19 0.00819f
C7042 dc_inst.x1.x1/a_27_47# dc_inst.net8 0
C7043 dc_inst.x5.net15 dc_inst.x5.net19 0
C7044 dc_inst.x6.net9 VPWR 0.05639f
C7045 dc_inst.x1.net2 dc_inst.x2.net17 0
C7046 VPWR dc_inst.net5 0.32552f
C7047 dc_inst.x6.net5 dc_inst.net4 0.03609f
C7048 dc_inst.x6.x3/a_27_47# dc_inst.x6.net12 0
C7049 path_sel[2] dc_inst.net2 0.00152f
C7050 dc_inst.x1.net16 dc_inst.x5.net5 0
C7051 _14_/a_76_199# dc_inst.x3.net17 0
C7052 dc_inst.x4.net10 dc_inst.net1 0
C7053 dc_inst.x6.net19 dc_inst.x6.net12 0
C7054 dc_inst.net1 dc_inst.x8/a_193_413# 0.00553f
C7055 dc_inst.x4.net16 VPWR 0.20286f
C7056 dc_inst.x6.net9 path_sel[2] 0.0057f
C7057 dc_inst.x6.net11 dc_inst.x6.net13 0.01085f
C7058 dc_inst.net5 dc_inst.x6.x16/a_27_47# 0.0012f
C7059 _15_/a_27_47# _06_ 0.00619f
C7060 dc_inst.x3.net5 path_sel[0] 0
C7061 _15_/a_788_316# _20_/a_384_47# 0
C7062 path[0] _07_ 0.00483f
C7063 _08_ path_sel[0] 0.11966f
C7064 dc_inst.net5 path_sel[2] 0.00714f
C7065 _01_ dc_inst.net9 0
C7066 dc_inst.x5.net6 dc_inst.x2.x1/a_27_47# 0.02471f
C7067 dc_inst.x4.net4 dc_inst.x1.net2 0
C7068 dc_inst.x6.x8/a_27_47# dc_inst.x5.net18 0
C7069 dc_inst.x4.net16 path_sel[2] 0.00124f
C7070 dc_inst.x1.net4 VPWR 0.55318f
C7071 dc_inst.x1.net15 dc_inst.x2.net17 0.07311f
C7072 tdo dc_inst.x4.x9/a_27_47# 0.0177f
C7073 dc_inst.x2.x8/a_27_47# dc_inst.x2.net12 0
C7074 dc_inst.x2.net9 dc_inst.x2.x12/a_27_47# 0.00145f
C7075 dc_inst.x3.net14 dc_inst.x3.net17 0.02671f
C7076 clknet_1_1__leaf_clk dc_inst.x8/a_668_97# 0
C7077 dc_inst.x2.net12 dc_inst.x5.x10/a_27_47# 0
C7078 dc_inst.x1.x19/a_27_47# dc_inst.x5.net5 0
C7079 delay_sel[0] dc_inst.x7.net8 0
C7080 dc_inst.x6.net11 dc_inst.x6.net12 0.00591f
C7081 delay_sel[1] dc_inst.x6.x15/a_27_47# 0
C7082 dc_inst.net5 dc_inst.x6.net15 0
C7083 dc_inst.x1.net4 path_sel[2] 0.00964f
C7084 dc_inst.x1.net2 _15_/a_193_47# 0.00186f
C7085 dc_inst.x1.net3 _15_/a_788_316# 0.00737f
C7086 dc_inst.x2.x5/a_27_47# dc_inst.x2.net15 0
C7087 dc_inst.x9/a_668_97# dc_inst.x7.net16 0
C7088 dc_inst.x9/a_277_47# dc_inst.net7 0.06299f
C7089 dc_inst.x9/a_923_363# delay_sel[0] 0.00152f
C7090 clknet_1_0__leaf_clk dc_inst.net7 0
C7091 dc_inst.x1.net11 _15_/a_27_47# 0
C7092 clknet_0_clk delay_sel[1] 0
C7093 dc_inst.x2.x11/a_27_47# path_sel[0] 0
C7094 clkbuf_0_clk/a_110_47# dc_inst.x7.net1 0.1085f
C7095 delay_sel[0] dc_inst.x3.x20/a_27_47# 0
C7096 dc_inst.x2.x17/a_27_47# dc_inst.x1.x14/a_27_47# 0
C7097 dc_inst.x4.net4 dc_inst.x1.net15 0
C7098 dc_inst.x6.x3/a_27_47# path_sel[1] 0
C7099 dc_inst.x2.net16 dc_inst.x4.net5 0.00199f
C7100 dc_inst.x5.net7 dc_inst.x5.net9 0.04202f
C7101 _18_/a_218_374# path_sel[0] 0
C7102 dc_inst.x6.net8 dc_inst.x6.x10/a_27_47# 0
C7103 dc_inst.x4.x2/a_27_47# dc_inst.x2.net18 0
C7104 dc_inst.x4.net3 dc_inst.x2.x18/a_27_47# 0.01317f
C7105 VPWR dc_inst.x1.net9 0.16492f
C7106 dc_inst.x1.x3/a_27_47# dc_inst.x3.x2/a_27_47# 0
C7107 dc_inst.x2.x6/a_27_47# dc_inst.x2.net8 0.01149f
C7108 dc_inst.x2.net7 dc_inst.x2.x7/a_27_47# 0.06006f
C7109 VPWR dc_inst.x1.net1 0.04707f
C7110 VPWR _04_ 0.10399f
C7111 dc_inst.net5 dc_inst.x4.net5 0
C7112 _15_/a_1064_47# _06_ 0
C7113 dc_inst.x7.net2 dc_inst.in 0
C7114 path_sel[2] dc_inst.x1.net9 0.04627f
C7115 dc_inst.x5.x20/a_27_47# dc_inst.x7.x19/a_27_47# 0.00109f
C7116 dc_inst.x1.net19 dc_inst.x1.x18/a_27_47# 0.00338f
C7117 dc_inst.x1.net1 path_sel[2] 0.00191f
C7118 dc_inst.x7.x1/a_27_47# dc_inst.x7.x5/a_27_47# 0.01018f
C7119 _04_ path_sel[2] 0.03499f
C7120 dc_inst.x3.x15/a_27_47# dc_inst.x3.net17 0
C7121 _05_ dc_inst.x3.net17 0
C7122 path_sel[1] dc_inst.x6.net11 0.00188f
C7123 dc_inst.x7.x2/a_27_47# _25_/a_1283_21# 0
C7124 dc_inst.x6.net7 dc_inst.x5.x1/a_27_47# 0
C7125 dc_inst.x4.x12/a_27_47# dc_inst.x5.net7 0
C7126 VPWR _18_/a_76_199# 0.00146f
C7127 _02_ dc_inst.net2 0
C7128 dc_inst.x3.net9 _15_/a_788_316# 0
C7129 dc_inst.x3.net15 dc_inst.x3.net1 0
C7130 dc_inst.net9 dc_inst.x7.net16 0
C7131 dc_inst.x9/a_834_97# delay_sel[1] 0.03317f
C7132 dc_inst.x3.net12 dc_inst.x3.net13 0.16698f
C7133 dc_inst.x3.net11 dc_inst.x3.net14 0
C7134 dc_inst.x4.x20/a_27_47# dc_inst.x6.x7/a_27_47# 0.03129f
C7135 dc_inst.x1.net4 dc_inst.x1.net8 0.13142f
C7136 dc_inst.x4.x10/a_27_47# dc_inst.x5.net7 0.02914f
C7137 dc_inst.net6 dc_inst.x9/a_1290_413# 0.00159f
C7138 dc_inst.x7.net2 dc_inst.x9/a_757_363# 0.00156f
C7139 delay_sel[2] dc_inst.x7.net19 0.00312f
C7140 dc_inst.x1.net5 _19_/a_109_297# 0
C7141 rst dc_inst.x8/a_834_97# 0
C7142 clkbuf_0_clk/a_110_47# _03_ 0.01525f
C7143 dc_inst.x2.net18 dc_inst.x2.x19/a_27_47# 0.05126f
C7144 path[2] path[1] 0.09164f
C7145 dc_inst.x1.net4 _02_ 0
C7146 dc_inst.x2.x17/a_27_47# dc_inst.x2.net12 0
C7147 dc_inst.x1.net18 dc_inst.x6.net13 0.00359f
C7148 _08_ dc_inst.x1.net7 0
C7149 dc_inst.x7.net13 dc_inst.net4 0
C7150 dc_inst.x2.x7/a_27_47# dc_inst.x5.net3 0
C7151 dc_inst.x4.x4/a_27_47# dc_inst.net1 0.00899f
C7152 dc_inst.x1.net9 dc_inst.x4.net5 0.00828f
C7153 dc_inst.x1.x1/a_27_47# dc_inst.x1.x8/a_27_47# 0.01018f
C7154 dc_inst.x6.net1 dc_inst.x5.net2 0
C7155 dc_inst.x6.net10 dc_inst.x5.net3 0
C7156 dc_inst.net9 dc_inst.x6.net14 0
C7157 dc_inst.x1.net9 dc_inst.x1.net8 0.19881f
C7158 dc_inst.x9/a_1290_413# dc_inst.x8/a_277_47# 0
C7159 dc_inst.x9/a_1478_413# dc_inst.x8/a_247_21# 0
C7160 dc_inst.x7.net15 dc_inst.x7.x19/a_27_47# 0
C7161 capture_q dc_inst.x3.x4/a_27_47# 0
C7162 dc_inst.x7.x15/a_27_47# dc_inst.x7.net19 0.14241f
C7163 dc_inst.x6.x7/a_27_47# dc_inst.x6.net8 0.0147f
C7164 dc_inst.x1.net18 dc_inst.x6.net12 0
C7165 _23_/a_27_47# shadow_q 0
C7166 _05_ dc_inst.x3.net11 0
C7167 _13_/a_112_47# _13_/a_27_297# -0.00287f
C7168 dc_inst.x3.net19 dc_inst.x8/a_277_47# 0
C7169 dc_inst.x3.x20/a_27_47# dc_inst.x8/a_750_97# 0
C7170 VPWR path[2] 0.11243f
C7171 dc_inst.x6.x5/a_27_47# dc_inst.x5.net2 0
C7172 dc_inst.x4.net4 delay_sel[0] 0
C7173 dc_inst.x3.x16/a_27_47# _23_/a_1283_21# 0.00795f
C7174 dc_inst.x4.x16/a_27_47# dc_inst.x5.net8 0
C7175 _13_/a_470_47# dc_inst.x3.net14 0
C7176 dc_inst.x4.x17/a_27_47# dc_inst.x4.x16/a_27_47# 0
C7177 dc_inst.x7.net19 dc_inst.x6.x20/a_27_47# 0
C7178 clkbuf_1_1__f_clk/a_110_47# dc_inst.x3.net16 0
C7179 dc_inst.x3.net6 dc_inst.x3.net1 0.17106f
C7180 dc_inst.x3.net7 dc_inst.x3.net10 0
C7181 _23_/a_1283_21# _03_ 0
C7182 dc_inst.net6 delay_sel[0] 0.02988f
C7183 _13_/a_112_47# dc_inst.x3.x3/a_27_47# 0
C7184 dc_inst.x3.x2/a_27_47# path[7] 0
C7185 dc_inst.net8 dc_inst.x2.x19/a_27_47# 0
C7186 dc_inst.x7.x2/a_27_47# rst 0.00176f
C7187 _15_/a_27_47# _15_/a_788_316# -0
C7188 dc_inst.x4.x20/a_27_47# dc_inst.x5.net2 0
C7189 _14_/a_218_47# tdi 0
C7190 dc_inst.x3.net15 _23_/a_761_289# 0
C7191 dc_inst.x6.net4 dc_inst.net4 0.00376f
C7192 dc_inst.x1.x18/a_27_47# dc_inst.x1.x20/a_27_47# 0.01771f
C7193 dc_inst.x1.x12/a_27_47# path[3] 0.00507f
C7194 dc_inst.x7.x20/a_27_47# delay_sel[1] 0
C7195 dc_inst.x4.net9 dc_inst.x6.net14 0
C7196 dc_inst.x5.net9 dc_inst.x1.x9/a_27_47# 0
C7197 _13_/a_112_47# dc_inst.x3.x16/a_27_47# 0
C7198 VPWR dc_inst.x2.net15 0.05007f
C7199 dc_inst.x6.x2/a_27_47# dc_inst.x5.x18/a_27_47# 0
C7200 tdi _13_/a_470_297# 0
C7201 _14_/a_439_47# _05_ 0
C7202 dc_inst.x1.net16 dc_inst.x2.net5 0.00213f
C7203 clkbuf_0_clk/a_110_47# VPWR 0.05861f
C7204 dc_inst.x5.net6 dc_inst.x6.x14/a_27_47# 0
C7205 dc_inst.x1.net18 path_sel[1] 0.00153f
C7206 dc_inst.x5.net7 dc_inst.x4.net7 0.05027f
C7207 path_sel[2] dc_inst.x2.net15 0.03093f
C7208 dc_inst.x7.x13/a_27_47# dc_inst.x7.net1 0
C7209 _00_ dc_inst.x3.net5 0
C7210 delay_sel[0] dc_inst.x8/a_277_47# 0.00876f
C7211 delay_sel[1] dc_inst.x8/a_27_413# 0.00635f
C7212 dc_inst.x4.x6/a_27_47# dc_inst.x4.net7 0.00203f
C7213 dc_inst.x6.x2/a_27_47# dc_inst.x6.net3 0.02762f
C7214 dc_inst.x9/a_757_363# dc_inst.x6.x12/a_27_47# 0
C7215 _23_/a_1217_47# shadow_q 0
C7216 delay_sel[2] _23_/a_1270_413# 0
C7217 capture_d _23_/a_805_47# 0
C7218 dc_inst.x3.net2 dc_inst.x8/a_834_97# 0
C7219 dc_inst.net5 dc_inst.x6.x15/a_27_47# 0
C7220 _25_/a_27_47# dc_inst.net4 0
C7221 dc_inst.net5 dc_inst.x9/a_193_413# 0
C7222 VPWR dc_inst.x3.x12/a_27_47# 0.0415f
C7223 _08_ dc_inst.x5.net12 0
C7224 dc_inst.x2.net10 _17_/a_174_21# 0
C7225 dc_inst.x3.x5/a_27_47# path_sel[1] 0
C7226 dc_inst.x5.net3 dc_inst.x4.x19/a_27_47# 0.03779f
C7227 dc_inst.x6.net8 dc_inst.x5.net2 0
C7228 dc_inst.x3.net14 dc_inst.x3.net15 0.02526f
C7229 VPWR dc_inst.x6.x4/a_27_47# 0.00515f
C7230 dc_inst.x6.net2 dc_inst.x5.x19/a_27_47# 0
C7231 dc_inst.x6.net10 dc_inst.x6.net11 0.02531f
C7232 dc_inst.x2.x20/a_27_47# dc_inst.x6.net18 0
C7233 dc_inst.x2.net16 dc_inst.x1.x14/a_27_47# 0.00145f
C7234 dc_inst.x2.x16/a_27_47# dc_inst.x1.net14 0
C7235 dc_inst.x7.x3/a_27_47# dc_inst.x8/a_757_363# 0
C7236 dc_inst.x2.net17 dc_inst.x8/a_750_97# 0
C7237 dc_inst.x7.x1/a_27_47# dc_inst.x5.net19 0
C7238 dc_inst.x1.x13/a_27_47# dc_inst.x1.x8/a_27_47# 0
C7239 dc_inst.x6.x4/a_27_47# path_sel[2] 0.01402f
C7240 VPWR _23_/a_1283_21# 0.01534f
C7241 delay_sel[2] dc_inst.x7.net17 0
C7242 dc_inst.x2.net11 dc_inst.x2.x14/a_27_47# 0
C7243 dc_inst.x2.x11/a_27_47# dc_inst.x2.net14 0
C7244 dc_inst.x6.net6 dc_inst.x4.net19 0.26049f
C7245 dc_inst.x6.net7 dc_inst.x4.net18 0
C7246 dc_inst.x2.x11/a_27_47# dc_inst.x5.net12 0.01018f
C7247 dc_inst.x3.net17 dc_inst.x1.x8/a_27_47# 0
C7248 dc_inst.x1.x16/a_27_47# dc_inst.x2.net6 0
C7249 dc_inst.x6.x3/a_27_47# dc_inst.x7.net1 0
C7250 dc_inst.x6.net4 dc_inst.x7.x10/a_27_47# 0
C7251 VPWR _14_/a_218_374# -0
C7252 dc_inst.x6.x10/a_27_47# dc_inst.x4.net6 0
C7253 dc_inst.x2.net15 dc_inst.x4.net5 0.01484f
C7254 dc_inst.x2.net10 dc_inst.x5.x11/a_27_47# 0.03319f
C7255 dc_inst.net9 dc_inst.x8/a_193_47# 0.00117f
C7256 delay_sel[1] dc_inst.x8/a_668_97# 0
C7257 dc_inst.x6.x6/a_27_47# dc_inst.x5.net2 0.13659f
C7258 dc_inst.x7.net1 dc_inst.x6.net19 0
C7259 capture_d dc_inst.x7.net18 0.00223f
C7260 dc_inst.x2.net15 dc_inst.x1.net8 0.00364f
C7261 dc_inst.x3.x15/a_27_47# dc_inst.x3.net15 0.04362f
C7262 dc_inst.x7.net15 dc_inst.x7.x17/a_27_47# 0
C7263 dc_inst.x7.x15/a_27_47# dc_inst.x7.net17 0
C7264 VPWR _13_/a_112_47# 0.04023f
C7265 dc_inst.x4.net16 dc_inst.x4.x7/a_27_47# 0
C7266 dc_inst.x6.net18 dc_inst.x7.net5 0.00512f
C7267 dc_inst.x7.net2 dc_inst.x5.net6 0
C7268 VPWR dc_inst.x2.net7 0.31187f
C7269 dc_inst.x6.net13 dc_inst.x6.net14 0.23201f
C7270 _24_/a_651_413# _23_/a_543_47# 0
C7271 dc_inst.x4.net15 dc_inst.x4.net19 0.00161f
C7272 dc_inst.x1.x19/a_27_47# dc_inst.x2.x3/a_27_47# 0.01013f
C7273 dc_inst.x4.x2/a_27_47# dc_inst.net1 0.00213f
C7274 dc_inst.x3.net7 dc_inst.x3.net13 0.00251f
C7275 dc_inst.x3.net6 dc_inst.x3.net14 0.13667f
C7276 dc_inst.x6.x20/a_27_47# dc_inst.x7.net17 0
C7277 dc_inst.x2.x11/a_27_47# dc_inst.x5.x10/a_27_47# 0
C7278 _13_/a_27_297# clkbuf_1_1__f_clk/a_110_47# 0.00102f
C7279 _25_/a_651_413# clkbuf_0_clk/a_110_47# 0
C7280 _15_/a_600_345# path[4] 0
C7281 dc_inst.x5.x15/a_27_47# dc_inst.x6.net3 0
C7282 dc_inst.x4.x15/a_27_47# dc_inst.x5.net3 0.03552f
C7283 dc_inst.x4.net15 dc_inst.x5.x2/a_27_47# 0
C7284 VPWR dc_inst.x10/a_218_374# -0.00163f
C7285 dc_inst.x4.x1/a_27_47# dc_inst.in 0.03752f
C7286 dc_inst.x4.x17/a_27_47# dc_inst.x4.x8/a_27_47# 0.04629f
C7287 dc_inst.x2.net3 dc_inst.x2.net4 0.03433f
C7288 dc_inst.x1.net6 dc_inst.x1.x2/a_27_47# 0
C7289 dc_inst.x1.x5/a_27_47# dc_inst.x1.net3 0.11122f
C7290 dc_inst.x4.net17 dc_inst.x5.x1/a_27_47# 0.00616f
C7291 dc_inst.x5.net1 dc_inst.x5.net11 0.00693f
C7292 dc_inst.x6.net12 dc_inst.x6.net14 0.11713f
C7293 dc_inst.x1.x14/a_27_47# dc_inst.x1.net9 0.01274f
C7294 dc_inst.x1.x1/a_27_47# dc_inst.x3.net2 0
C7295 dc_inst.x8/a_247_21# dc_inst.x8/a_1290_413# -0.00452f
C7296 dc_inst.in dc_inst.x7.net4 0.48195f
C7297 dc_inst.x8/a_277_47# dc_inst.x8/a_750_97# -0.08341f
C7298 dc_inst.x7.net14 dc_inst.x5.x20/a_27_47# 0
C7299 dc_inst.x1.x10/a_27_47# dc_inst.x1.net14 0
C7300 dc_inst.x5.x7/a_27_47# dc_inst.x5.net7 0.03084f
C7301 dc_inst.x3.x5/a_27_47# dc_inst.x3.net16 0
C7302 dc_inst.x3.net3 path_sel[1] 0
C7303 clkbuf_1_1__f_clk/a_110_47# dc_inst.x3.x16/a_27_47# 0
C7304 path[6] dc_inst.x8/a_1290_413# 0
C7305 _15_/a_372_413# dc_inst.net2 0
C7306 dc_inst.x3.net18 path[7] 0
C7307 path_sel[0] _07_ 0.29135f
C7308 _01_ dc_inst.x3.net16 0.03127f
C7309 rst dc_inst.x3.net17 0
C7310 dc_inst.x7.x1/a_27_47# dc_inst.net5 0
C7311 dc_inst.x1.net13 dc_inst.x1.x2/a_27_47# 0
C7312 dc_inst.net6 dc_inst.x6.x1/a_27_47# 0.03087f
C7313 dc_inst.x3.x9/a_27_47# VPWR 0.00426f
C7314 dc_inst.x9/a_277_47# dc_inst.x7.net5 0
C7315 dc_inst.x3.net6 dc_inst.x3.x15/a_27_47# 0
C7316 _05_ dc_inst.x3.net6 0
C7317 dc_inst.x2.x19/a_27_47# dc_inst.net1 0
C7318 clknet_1_0__leaf_clk dc_inst.x7.net5 0
C7319 _24_/a_193_47# shadow_q 0
C7320 _02_ _23_/a_1283_21# 0.0012f
C7321 _24_/a_27_47# capture_d 0.03177f
C7322 tdo dc_inst.x6.x10/a_27_47# 0.00176f
C7323 dc_inst.in dc_inst.net4 0
C7324 VPWR dc_inst.x5.net3 0.90866f
C7325 _25_/a_448_47# dc_inst.x7.net1 0.01331f
C7326 dc_inst.x1.net3 dc_inst.x3.net17 0.01379f
C7327 dc_inst.x4.net4 dc_inst.x1.x4/a_27_47# 0
C7328 dc_inst.x7.x13/a_27_47# VPWR 0.02398f
C7329 dc_inst.x10/a_76_199# dc_inst.x6.net17 0
C7330 path[6] path[4] 0
C7331 dc_inst.x6.net5 dc_inst.x7.net6 0
C7332 dc_inst.x2.net7 dc_inst.x4.net5 0.00181f
C7333 dc_inst.x6.net6 dc_inst.x6.x11/a_27_47# 0.01335f
C7334 path_sel[1] dc_inst.x6.net14 0
C7335 clknet_1_1__leaf_clk _14_/a_218_47# 0
C7336 _02_ _14_/a_218_374# 0
C7337 dc_inst.x2.net18 dc_inst.x6.net17 0
C7338 dc_inst.x5.net6 dc_inst.x6.x13/a_27_47# 0
C7339 dc_inst.x3.net5 dc_inst.x3.net8 0
C7340 dc_inst.x7.x13/a_27_47# path_sel[2] 0
C7341 dc_inst.x6.net7 dc_inst.x4.x13/a_27_47# 0
C7342 dc_inst.x6.x6/a_27_47# dc_inst.x4.net13 0
C7343 path[4] dc_inst.x1.x6/a_27_47# 0
C7344 dc_inst.x1.x13/a_27_47# dc_inst.x2.net10 0
C7345 dc_inst.x5.net16 dc_inst.x6.x7/a_27_47# 0.01547f
C7346 dc_inst.x1.x1/a_27_47# _15_/a_27_47# 0
C7347 dc_inst.x4.net9 dc_inst.x6.net12 0
C7348 _02_ _13_/a_112_47# 0.09469f
C7349 clknet_1_1__leaf_clk _13_/a_470_297# 0
C7350 _25_/a_543_47# dc_inst.x7.net17 0
C7351 clk rst 0
C7352 dc_inst.x1.net5 dc_inst.x3.x2/a_27_47# 0
C7353 dc_inst.x5.x9/a_27_47# path_sel[0] 0.0029f
C7354 dc_inst.x7.net14 dc_inst.x7.net15 0.03448f
C7355 dc_inst.x9/a_757_363# dc_inst.net4 0.00906f
C7356 dc_inst.x2.net12 dc_inst.x1.net9 0.00152f
C7357 path_sel[1] _15_/a_288_47# 0.01753f
C7358 dc_inst.x1.net1 dc_inst.x2.net12 0
C7359 dc_inst.x2.net1 path_sel[1] 0.02686f
C7360 dc_inst.x2.net6 dc_inst.x2.net3 0
C7361 dc_inst.x6.net8 dc_inst.x7.net7 0
C7362 rst dc_inst.x3.net11 0
C7363 _25_/a_193_47# dc_inst.x7.net18 0
C7364 dc_inst.x3.x8/a_27_47# dc_inst.x3.x13/a_27_47# 0.01254f
C7365 VPWR dc_inst.x3.x6/a_27_47# -0.00759f
C7366 _24_/a_1462_47# shadow_q 0
C7367 _24_/a_639_47# delay_sel[2] 0.0015f
C7368 VPWR dc_inst.x6.x3/a_27_47# 0.01938f
C7369 clkbuf_0_clk/a_110_47# clknet_0_clk 0.09759f
C7370 clk clkbuf_1_0__f_clk/a_110_47# 0.00266f
C7371 dc_inst.x3.x5/a_27_47# _23_/a_1108_47# 0
C7372 dc_inst.x1.net5 dc_inst.x1.net14 0
C7373 VPWR dc_inst.x6.net19 0.00429f
C7374 VPWR clkbuf_1_1__f_clk/a_110_47# -0.00132f
C7375 dc_inst.x5.net3 dc_inst.x4.net5 0
C7376 dc_inst.x6.x3/a_27_47# path_sel[2] 0.01495f
C7377 capture_q se 0
C7378 dc_inst.in _23_/a_27_47# 0.08123f
C7379 dc_inst.x7.net19 dc_inst.x9/a_1478_413# 0
C7380 dc_inst.x6.net7 dc_inst.x4.x11/a_27_47# 0
C7381 dc_inst.x6.x6/a_27_47# dc_inst.x4.net11 0
C7382 path_sel[1] dc_inst.x4.net9 0.0375f
C7383 _19_/a_27_47# _10_ 0.0423f
C7384 dc_inst.x3.net3 dc_inst.x3.net16 0.0221f
C7385 _25_/a_448_47# _03_ 0
C7386 dc_inst.x3.net2 dc_inst.x3.net17 0.00664f
C7387 dc_inst.x2.x20/a_27_47# _15_/a_600_345# 0
C7388 dc_inst.x7.net3 dc_inst.x8/a_277_47# 0
C7389 VPWR dc_inst.x1.x12/a_27_47# 0.003f
C7390 path_sel[2] dc_inst.x6.net19 0.00257f
C7391 dc_inst.x7.x10/a_27_47# dc_inst.in 0
C7392 _01_ _23_/a_1108_47# 0.02042f
C7393 dc_inst.x8/a_668_97# dc_inst.net2 0
C7394 dc_inst.x6.x8/a_27_47# dc_inst.x6.net8 0.02031f
C7395 _19_/a_27_47# dc_inst.x1.x7/a_27_47# 0.00168f
C7396 dc_inst.x7.x3/a_27_47# dc_inst.x7.net4 0.00296f
C7397 dc_inst.x5.x5/a_27_47# path_sel[1] 0.0015f
C7398 _00_ _13_/a_470_297# 0
C7399 dc_inst.x1.x14/a_27_47# dc_inst.x2.net15 0.00332f
C7400 dc_inst.x6.x4/a_27_47# dc_inst.x9/a_193_413# 0
C7401 dc_inst.x6.net7 dc_inst.x7.x6/a_27_47# 0
C7402 VPWR dc_inst.x6.net11 0.01358f
C7403 dc_inst.x1.x12/a_27_47# path_sel[2] 0
C7404 _24_/a_1108_47# VPWR -0.01283f
C7405 tdo dc_inst.x2.net6 0
C7406 dc_inst.x1.x5/a_27_47# _15_/a_27_47# 0
C7407 _14_/a_439_47# rst 0
C7408 dc_inst.x5.net16 dc_inst.x5.net2 0.02302f
C7409 dc_inst.x5.net15 dc_inst.x5.net3 0
C7410 _07_ dc_inst.x1.net7 0
C7411 dc_inst.x7.net12 _25_/a_1283_21# 0
C7412 dc_inst.x1.net11 dc_inst.x2.net13 0
C7413 path_sel[2] dc_inst.x6.net11 0.0186f
C7414 dc_inst.x2.net18 dc_inst.x6.net18 0.00256f
C7415 dc_inst.x2.net2 dc_inst.x5.net3 0
C7416 dc_inst.x7.net1 dc_inst.x9/a_27_413# 0.00337f
C7417 dc_inst.x5.net10 dc_inst.x2.net13 0
C7418 tdo dc_inst.x10/a_76_199# 0.00623f
C7419 capture_q delay_sel[2] 0.00188f
C7420 dc_inst.x4.net17 dc_inst.x4.net18 0.00442f
C7421 tdo dc_inst.x2.net18 0
C7422 dc_inst.x5.x14/a_27_47# path_sel[0] 0.00271f
C7423 dc_inst.x1.net6 dc_inst.x2.net17 0
C7424 dc_inst.x1.x1/a_27_47# dc_inst.x8/a_1478_413# 0
C7425 dc_inst.x6.net12 dc_inst.x6.net13 0.24025f
C7426 dc_inst.x3.net9 dc_inst.x3.net11 0.20751f
C7427 dc_inst.x1.net3 _13_/a_470_47# 0
C7428 dc_inst.x2.net12 path[2] 0
C7429 _25_/a_27_47# _24_/a_193_47# 0
C7430 dc_inst.net9 dc_inst.x3.net16 0
C7431 dc_inst.x7.net19 dc_inst.net7 0.0703f
C7432 _01_ dc_inst.x3.x3/a_27_47# 0
C7433 dc_inst.x2.x20/a_27_47# path[6] 0
C7434 _15_/a_27_47# dc_inst.x3.net17 0
C7435 dc_inst.x9/a_247_21# dc_inst.x7.x17/a_27_47# 0.00993f
C7436 dc_inst.x3.net2 dc_inst.x3.net11 0
C7437 dc_inst.x10/a_535_374# _01_ 0
C7438 dc_inst.x5.net8 path_sel[0] 0.00257f
C7439 dc_inst.x3.net12 dc_inst.x3.net19 0
C7440 dc_inst.x6.x17/a_27_47# dc_inst.x6.net17 0.00211f
C7441 _01_ dc_inst.x3.x16/a_27_47# 0.00124f
C7442 dc_inst.x1.net12 _10_ 0.01622f
C7443 dc_inst.net3 dc_inst.x8/a_193_413# 0
C7444 dc_inst.x1.net13 dc_inst.x2.net17 0.03783f
C7445 dc_inst.x1.net12 dc_inst.x1.x7/a_27_47# 0
C7446 _02_ dc_inst.x3.x6/a_27_47# 0
C7447 dc_inst.x1.x16/a_27_47# dc_inst.net1 0
C7448 dc_inst.x7.net4 dc_inst.x8/a_923_363# 0
C7449 dc_inst.x6.net11 dc_inst.x4.net5 0
C7450 _01_ _03_ 0
C7451 dc_inst.x4.x1/a_27_47# dc_inst.x5.net6 0
C7452 dc_inst.x4.net3 dc_inst.x2.net17 0.00676f
C7453 _02_ clkbuf_1_1__f_clk/a_110_47# 0.00626f
C7454 dc_inst.x6.net17 dc_inst.x4.x5/a_27_47# 0
C7455 dc_inst.x7.net1 dc_inst.x9/a_668_97# 0.00146f
C7456 tdo dc_inst.net8 0
C7457 dc_inst.x4.net13 dc_inst.x4.net6 0
C7458 path_sel[1] dc_inst.x6.net13 0
C7459 rst dc_inst.x3.net15 0
C7460 dc_inst.x7.net1 dc_inst.x7.net16 0.00564f
C7461 dc_inst.x4.x1/a_27_47# path[7] 0
C7462 dc_inst.x3.x11/a_27_47# shadow_q 0
C7463 dc_inst.x6.net7 dc_inst.x4.x12/a_27_47# 0
C7464 _19_/a_27_47# _20_/a_79_21# 0
C7465 dc_inst.x5.x20/a_27_47# dc_inst.x7.x7/a_27_47# 0.01191f
C7466 dc_inst.x6.net4 dc_inst.x7.net6 0.01044f
C7467 _07_ dc_inst.x5.net12 0
C7468 _17_/a_174_21# path[0] 0.00959f
C7469 _25_/a_27_47# _25_/a_761_289# -0.01661f
C7470 dc_inst.x4.net3 dc_inst.x4.net4 0.30472f
C7471 dc_inst.x3.net5 dc_inst.net2 0
C7472 dc_inst.x4.x5/a_27_47# dc_inst.x4.net6 0.00873f
C7473 _24_/a_651_413# clknet_1_1__leaf_clk 0.00722f
C7474 _24_/a_1108_47# _02_ 0.00457f
C7475 _24_/a_761_289# capture_q 0
C7476 path_sel[0] _06_ 0.23342f
C7477 path_sel[1] dc_inst.x6.net12 0.00101f
C7478 clkload0/a_27_47# capture_d 0.015f
C7479 path[6] dc_inst.x3.x17/a_27_47# 0.00161f
C7480 dc_inst.x2.x19/a_27_47# _15_/a_27_47# 0
C7481 dc_inst.x4.net17 dc_inst.x4.net14 0.05279f
C7482 _13_/a_27_297# dc_inst.x3.net3 0
C7483 dc_inst.x6.net11 dc_inst.x2.net2 0
C7484 dc_inst.x4.net2 dc_inst.x7.net2 0
C7485 dc_inst.x1.net18 VPWR 0.11811f
C7486 path[6] dc_inst.x3.net1 0.00385f
C7487 path[7] dc_inst.x3.net10 0
C7488 path[4] dc_inst.x3.x10/a_27_47# 0.00368f
C7489 dc_inst.x5.net6 dc_inst.net4 0.00209f
C7490 dc_inst.x6.net5 delay_sel[0] 0
C7491 dc_inst.net3 dc_inst.x8/a_834_97# 0.00515f
C7492 dc_inst.x1.net18 path_sel[2] 0.01192f
C7493 dc_inst.x7.net12 clkbuf_1_0__f_clk/a_110_47# 0.02215f
C7494 dc_inst.x5.x5/a_27_47# dc_inst.x2.x7/a_27_47# 0
C7495 VPWR dc_inst.x3.x5/a_27_47# 0.06445f
C7496 dc_inst.x1.net4 dc_inst.x3.net5 0
C7497 dc_inst.x3.net3 dc_inst.x3.x3/a_27_47# 0.01688f
C7498 dc_inst.x6.net17 dc_inst.x7.net7 0
C7499 dc_inst.x7.net16 dc_inst.x7.x18/a_27_47# 0.00156f
C7500 dc_inst.x7.x16/a_27_47# dc_inst.x7.net18 0.01547f
C7501 dc_inst.x1.net11 path_sel[0] 0.00231f
C7502 dc_inst.x1.x3/a_27_47# dc_inst.x3.net13 0
C7503 capture_d dc_inst.x7.x16/a_27_47# 0
C7504 dc_inst.x5.net5 dc_inst.x2.net4 0
C7505 dc_inst.x5.net10 path_sel[0] 0.00313f
C7506 path[0] dc_inst.x5.x11/a_27_47# 0
C7507 dc_inst.x3.net7 _20_/a_79_21# 0
C7508 shadow_q dc_inst.x3.net19 0
C7509 dc_inst.x4.x18/a_27_47# dc_inst.x4.net12 0.01151f
C7510 dc_inst.x4.net17 dc_inst.x4.x13/a_27_47# 0.0263f
C7511 dc_inst.x5.x9/a_27_47# dc_inst.x5.net12 0.01959f
C7512 dc_inst.x6.net17 dc_inst.net1 0.31441f
C7513 VPWR _01_ 0.20183f
C7514 dc_inst.x4.net3 dc_inst.x8/a_277_47# 0
C7515 dc_inst.x3.net3 dc_inst.x3.x16/a_27_47# 0.0013f
C7516 _13_/a_470_297# dc_inst.x3.net8 0.00166f
C7517 dc_inst.x5.x16/a_27_47# dc_inst.x5.net16 0.01526f
C7518 dc_inst.x6.net17 dc_inst.x6.x18/a_27_47# 0.01469f
C7519 dc_inst.x3.net9 dc_inst.x3.net15 0
C7520 dc_inst.x4.net19 dc_inst.x4.net8 0
C7521 _00_ _24_/a_651_413# 0.02637f
C7522 tdo _24_/a_543_47# 0
C7523 dc_inst.x5.net16 dc_inst.x4.net11 0
C7524 dc_inst.x1.net12 _20_/a_79_21# 0
C7525 dc_inst.x1.net3 dc_inst.x3.net6 0
C7526 dc_inst.x3.x1/a_27_47# dc_inst.x7.net4 0
C7527 dc_inst.net1 dc_inst.x4.net6 0
C7528 dc_inst.x2.net7 dc_inst.x2.net12 0
C7529 tdo dc_inst.x6.x17/a_27_47# 0.00353f
C7530 dc_inst.x2.net19 _15_/a_193_47# 0
C7531 tdo dc_inst.x4.net13 0.11331f
C7532 VPWR dc_inst.x9/a_27_413# -0
C7533 dc_inst.net7 dc_inst.x7.net17 0.05019f
C7534 dc_inst.x5.net3 dc_inst.x4.x7/a_27_47# 0
C7535 dc_inst.x3.net2 dc_inst.x3.net15 0
C7536 dc_inst.x1.net1 _08_ 0
C7537 _24_/a_193_47# dc_inst.in 0.00225f
C7538 _23_/a_193_47# dc_inst.x8/a_277_47# 0
C7539 dc_inst.x1.net18 dc_inst.x4.net5 0.26433f
C7540 dc_inst.x7.net12 dc_inst.x9/a_27_47# 0.00235f
C7541 dc_inst.x2.x2/a_27_47# dc_inst.x2.net3 0.04368f
C7542 path_sel[2] dc_inst.x9/a_27_413# 0
C7543 dc_inst.x7.net10 dc_inst.x7.net4 0.10381f
C7544 _24_/a_27_47# clkload0/a_27_47# 0.0055f
C7545 _15_/a_872_316# dc_inst.x3.net13 0
C7546 dc_inst.x1.net2 dc_inst.x1.net12 0.08933f
C7547 dc_inst.x6.net6 dc_inst.x6.x14/a_27_47# 0
C7548 dc_inst.x6.net3 dc_inst.x7.x8/a_27_47# 0
C7549 dc_inst.x6.x2/a_27_47# dc_inst.x7.net9 0
C7550 clknet_0_clk clkbuf_1_1__f_clk/a_110_47# 0.00955f
C7551 dc_inst.x5.x9/a_27_47# dc_inst.x5.x10/a_27_47# 0.02448f
C7552 tdo dc_inst.x4.x5/a_27_47# 0.0139f
C7553 rst dc_inst.x6.net17 0
C7554 dc_inst.x6.net6 dc_inst.x4.net8 0
C7555 dc_inst.x1.net10 dc_inst.x2.net5 0
C7556 clkload0/X VPWR 0.01232f
C7557 dc_inst.x2.net19 dc_inst.x8/a_277_47# 0
C7558 dc_inst.x5.x8/a_27_47# dc_inst.x5.net8 0.043f
C7559 dc_inst.x1.net16 dc_inst.x5.net9 0
C7560 _18_/a_76_199# _08_ 0.02265f
C7561 dc_inst.net1 dc_inst.x2.net3 0
C7562 _10_ dc_inst.in 0.00555f
C7563 _13_/a_112_47# dc_inst.x3.x18/a_27_47# 0
C7564 dc_inst.x1.net15 dc_inst.x1.net12 0.07107f
C7565 dc_inst.in dc_inst.x1.x7/a_27_47# 0
C7566 _06_ dc_inst.x1.net7 0
C7567 dc_inst.x5.x20/a_27_47# delay_sel[1] 0
C7568 _14_/a_76_199# path[6] 0.02059f
C7569 dc_inst.x6.net2 dc_inst.x4.net19 0
C7570 dc_inst.x7.x14/a_27_47# delay_sel[0] 0
C7571 _25_/a_1270_413# _00_ 0
C7572 _25_/a_1283_21# tdo 0.0091f
C7573 dc_inst.x1.net16 dc_inst.x1.x2/a_27_47# 0
C7574 dc_inst.x1.net18 dc_inst.x2.net2 0.02427f
C7575 dc_inst.x1.x1/a_27_47# dc_inst.net3 0
C7576 dc_inst.x7.net10 dc_inst.net4 0
C7577 dc_inst.x5.net13 dc_inst.x5.net14 0.23431f
C7578 tdo dc_inst.x4.net11 0.00174f
C7579 dc_inst.x3.net6 dc_inst.x3.net9 0
C7580 tdo dc_inst.x2.x2/a_27_47# 0.00181f
C7581 _02_ dc_inst.x3.x5/a_27_47# 0
C7582 VPWR dc_inst.x9/a_668_97# 0
C7583 dc_inst.x5.x14/a_27_47# dc_inst.x5.net12 0.00297f
C7584 dc_inst.x5.net13 dc_inst.x5.x13/a_27_47# 0.01506f
C7585 dc_inst.x5.net5 dc_inst.x2.net6 0.07421f
C7586 path[5] dc_inst.x3.net12 0.03855f
C7587 VPWR dc_inst.x7.net16 -0.00264f
C7588 dc_inst.x1.x19/a_27_47# dc_inst.x5.net9 0
C7589 dc_inst.x5.x6/a_27_47# dc_inst.x6.x10/a_27_47# 0.08729f
C7590 dc_inst.x1.net19 dc_inst.x1.net17 0.23844f
C7591 VPWR dc_inst.x3.net3 0.08425f
C7592 dc_inst.x10/a_76_199# dc_inst.x8/a_247_21# 0
C7593 dc_inst.x6.net16 dc_inst.x9/a_750_97# 0
C7594 dc_inst.x7.net13 delay_sel[0] 0.03281f
C7595 dc_inst.x6.net18 dc_inst.net1 0.00101f
C7596 dc_inst.x1.net11 dc_inst.x1.net7 0.3774f
C7597 path[6] dc_inst.x3.net14 0.03775f
C7598 path[4] dc_inst.x3.x14/a_27_47# 0.00167f
C7599 path[7] dc_inst.x3.net13 0
C7600 dc_inst.x3.net7 dc_inst.x3.net19 0
C7601 dc_inst.x3.net3 path_sel[2] 0
C7602 _02_ _01_ 0
C7603 dc_inst.x2.x18/a_27_47# dc_inst.x8/a_1290_413# 0
C7604 dc_inst.x6.net10 dc_inst.x6.net12 0
C7605 dc_inst.x1.net15 dc_inst.x1.x17/a_27_47# 0
C7606 dc_inst.x6.x18/a_27_47# dc_inst.x6.net18 0.02631f
C7607 dc_inst.x1.net16 dc_inst.x2.x9/a_27_47# 0
C7608 dc_inst.x5.net8 dc_inst.x5.net12 0
C7609 dc_inst.x1.x13/a_27_47# dc_inst.x1.x15/a_27_47# 0
C7610 tdo dc_inst.net1 0.13106f
C7611 dc_inst.x4.x17/a_27_47# dc_inst.x5.net12 0
C7612 dc_inst.x1.net16 dc_inst.x5.x3/a_27_47# 0
C7613 dc_inst.x6.net2 dc_inst.x6.net6 0
C7614 dc_inst.x7.net2 dc_inst.x7.net18 0
C7615 dc_inst.in dc_inst.x7.net6 0
C7616 path[3] path_sel[1] 0
C7617 path[2] _08_ 0.06259f
C7618 dc_inst.x7.net2 capture_d 0
C7619 tdo dc_inst.x6.x18/a_27_47# 0.01108f
C7620 dc_inst.x7.x4/a_27_47# dc_inst.x7.net5 0.00873f
C7621 path_sel[0] _15_/a_788_316# 0.05362f
C7622 dc_inst.x2.net18 path[6] 0
C7623 _25_/a_1283_21# dc_inst.x9/a_277_47# 0
C7624 dc_inst.x3.net4 dc_inst.x3.x19/a_27_47# 0.00173f
C7625 _25_/a_448_47# clknet_0_clk 0
C7626 _25_/a_1283_21# clknet_1_0__leaf_clk 0
C7627 VPWR dc_inst.x6.net14 0.47778f
C7628 dc_inst.x1.net19 dc_inst.x2.net14 0
C7629 path_sel[2] dc_inst.x6.net14 0.0372f
C7630 dc_inst.x6.x16/a_27_47# dc_inst.x6.net14 0
C7631 dc_inst.x6.net16 dc_inst.x6.x14/a_27_47# 0
C7632 dc_inst.x4.x2/a_27_47# dc_inst.x2.x4/a_27_47# 0
C7633 dc_inst.x5.net19 dc_inst.x5.x20/a_27_47# 0.03436f
C7634 dc_inst.x2.x7/a_27_47# path_sel[1] 0.01307f
C7635 VPWR dc_inst.net9 0.02812f
C7636 rst dc_inst.x6.net18 0
C7637 _05_ path[6] 0.06774f
C7638 dc_inst.x3.net4 dc_inst.x3.net18 0.01333f
C7639 dc_inst.x1.net16 dc_inst.x2.net9 0
C7640 path[6] dc_inst.x3.x15/a_27_47# 0.02093f
C7641 VPWR _15_/a_288_47# 0
C7642 path_sel[1] dc_inst.x6.net10 0.0038f
C7643 dc_inst.x6.net4 delay_sel[0] 0
C7644 dc_inst.x7.x3/a_27_47# _24_/a_193_47# 0
C7645 dc_inst.net8 dc_inst.x8/a_247_21# 0.02309f
C7646 delay_sel[2] dc_inst.x8/a_277_47# 0
C7647 dc_inst.x7.net1 dc_inst.x7.x9/a_27_47# 0
C7648 dc_inst.x7.x10/a_27_47# dc_inst.x7.net10 0.04326f
C7649 path_sel[0] dc_inst.x4.net10 0
C7650 VPWR dc_inst.x2.net1 0
C7651 path_sel[2] dc_inst.net9 0
C7652 dc_inst.x1.x2/a_27_47# dc_inst.x1.x11/a_27_47# 0
C7653 tdo rst 0.20709f
C7654 dc_inst.x3.net6 _15_/a_27_47# 0
C7655 dc_inst.x9/a_277_47# dc_inst.net1 0
C7656 dc_inst.x4.net17 dc_inst.x4.x12/a_27_47# 0.00525f
C7657 dc_inst.x6.net15 dc_inst.x6.net14 0.01391f
C7658 path_sel[2] _15_/a_288_47# 0.00197f
C7659 _18_/a_505_21# path[3] 0.00239f
C7660 dc_inst.net6 dc_inst.x6.x20/a_27_47# 0.01949f
C7661 _20_/a_79_21# dc_inst.in 0.00538f
C7662 dc_inst.x3.net3 dc_inst.x1.net8 0
C7663 dc_inst.x2.net1 path_sel[2] 0
C7664 path[5] shadow_q 0
C7665 dc_inst.net8 path[6] 0.00208f
C7666 dc_inst.x5.x15/a_27_47# dc_inst.x5.net2 0.03049f
C7667 dc_inst.x6.net2 dc_inst.x6.x11/a_27_47# 0
C7668 dc_inst.x3.x10/a_27_47# dc_inst.x3.net1 0.00215f
C7669 dc_inst.x2.net11 dc_inst.x2.x15/a_27_47# 0
C7670 dc_inst.x2.net5 dc_inst.x2.net4 0.03371f
C7671 _24_/a_448_47# dc_inst.net9 0
C7672 dc_inst.x1.net11 dc_inst.x2.net14 0.00194f
C7673 dc_inst.x6.x19/a_27_47# delay_sel[1] 0.00746f
C7674 _02_ dc_inst.x3.net3 0
C7675 VPWR dc_inst.x4.net9 0.0923f
C7676 dc_inst.x1.net11 dc_inst.x5.net12 0
C7677 dc_inst.x1.net2 dc_inst.in 0.03106f
C7678 dc_inst.x4.net2 dc_inst.x4.x1/a_27_47# 0.00325f
C7679 dc_inst.x1.net17 dc_inst.x1.x20/a_27_47# 0.04484f
C7680 dc_inst.x3.x6/a_27_47# dc_inst.x3.x18/a_27_47# 0
C7681 dc_inst.x5.net10 dc_inst.x2.net14 0
C7682 dc_inst.x2.x13/a_27_47# dc_inst.x5.net11 0.00166f
C7683 dc_inst.x6.net14 dc_inst.x4.net5 0.00202f
C7684 dc_inst.x5.net10 dc_inst.x5.net12 0.02632f
C7685 dc_inst.x4.net2 dc_inst.x7.net4 0.01882f
C7686 dc_inst.x7.net19 dc_inst.x7.net5 0
C7687 VPWR dc_inst.x5.x5/a_27_47# 0.01267f
C7688 path_sel[2] dc_inst.x4.net9 0.00137f
C7689 dc_inst.x3.net5 _23_/a_1283_21# 0
C7690 dc_inst.x6.net6 dc_inst.x6.x13/a_27_47# 0
C7691 tdo dc_inst.x5.net4 0
C7692 dc_inst.x2.x5/a_27_47# path_sel[1] 0
C7693 dc_inst.x6.net2 dc_inst.x6.net16 0
C7694 _01_ clknet_0_clk 0.00269f
C7695 rst clknet_1_0__leaf_clk 0.14965f
C7696 rst dc_inst.x9/a_277_47# 0
C7697 dc_inst.x1.net15 dc_inst.in 0
C7698 dc_inst.x3.net6 _15_/a_1064_47# 0
C7699 _10_ _15_/a_872_316# 0
C7700 dc_inst.x6.net15 dc_inst.x4.net9 0
C7701 dc_inst.x7.net2 dc_inst.x6.net16 0.06556f
C7702 dc_inst.x6.net6 dc_inst.x6.x12/a_27_47# 0
C7703 path_sel[1] dc_inst.x4.x19/a_27_47# 0.00506f
C7704 dc_inst.x6.x2/a_27_47# dc_inst.x5.x16/a_27_47# 0
C7705 _13_/a_112_47# dc_inst.x3.net5 0
C7706 clkbuf_1_0__f_clk/a_110_47# dc_inst.x9/a_277_47# 0
C7707 dc_inst.x4.x11/a_27_47# dc_inst.x4.x9/a_27_47# 0.08729f
C7708 clkbuf_1_0__f_clk/a_110_47# clknet_1_0__leaf_clk 0.29256f
C7709 dc_inst.x1.net16 dc_inst.x2.net17 0
C7710 dc_inst.net5 dc_inst.x5.x20/a_27_47# 0.02185f
C7711 dc_inst.x5.x10/a_27_47# dc_inst.x5.net10 0.04506f
C7712 dc_inst.x2.x12/a_27_47# dc_inst.x2.x14/a_27_47# 0
C7713 dc_inst.x2.x3/a_27_47# dc_inst.x2.net4 0.04368f
C7714 dc_inst.x5.x4/a_27_47# dc_inst.x2.net6 0.00259f
C7715 VPWR dc_inst.x8/a_193_47# -0
C7716 dc_inst.net3 dc_inst.x2.x19/a_27_47# 0.00747f
C7717 dc_inst.x4.net12 dc_inst.x5.net6 0
C7718 _24_/a_543_47# path[6] 0
C7719 dc_inst.x2.x18/a_27_47# dc_inst.x2.x20/a_27_47# 0.01191f
C7720 dc_inst.x9/a_1290_413# dc_inst.in 0
C7721 dc_inst.x4.net4 dc_inst.x1.net16 0.00146f
C7722 dc_inst.x9/a_247_21# dc_inst.x7.x5/a_27_47# 0.00115f
C7723 _17_/a_174_21# path_sel[0] 0.09483f
C7724 dc_inst.x1.net19 dc_inst.x2.x17/a_27_47# 0
C7725 clkload0/X clknet_0_clk 0.06625f
C7726 dc_inst.in dc_inst.x3.net19 0
C7727 dc_inst.x5.x5/a_27_47# dc_inst.x4.net5 0
C7728 dc_inst.x2.net5 dc_inst.x2.net6 0.28453f
C7729 dc_inst.x5.x15/a_27_47# dc_inst.x4.net13 0
C7730 dc_inst.x2.net7 dc_inst.x2.x11/a_27_47# 0
C7731 dc_inst.x3.net7 path[5] 0.05009f
C7732 dc_inst.x1.x3/a_27_47# _20_/a_79_21# 0
C7733 _10_ path[7] 0
C7734 dc_inst.x4.x14/a_27_47# dc_inst.x5.net8 0.00156f
C7735 VPWR dc_inst.x6.net13 -0.00561f
C7736 dc_inst.x1.x19/a_27_47# dc_inst.x4.net4 0
C7737 dc_inst.x1.x18/a_27_47# dc_inst.x6.net17 0.00109f
C7738 dc_inst.x9/a_277_47# dc_inst.x9/a_27_47# -0.00845f
C7739 clknet_0_clk dc_inst.x9/a_668_97# 0
C7740 _25_/a_193_47# dc_inst.x7.net11 0.00191f
C7741 dc_inst.x1.net12 path[5] 0
C7742 dc_inst.x5.net17 dc_inst.x5.net18 0.02168f
C7743 dc_inst.x4.net9 dc_inst.x2.net2 0
C7744 path_sel[2] dc_inst.x6.net13 0.01705f
C7745 dc_inst.x1.net13 dc_inst.x2.x13/a_27_47# 0
C7746 dc_inst.x3.x14/a_27_47# dc_inst.x3.net1 0.00107f
C7747 VPWR dc_inst.x7.x9/a_27_47# 0.04146f
C7748 dc_inst.x3.net16 _23_/a_1108_47# 0
C7749 dc_inst.x4.net1 dc_inst.x5.net6 0
C7750 dc_inst.x1.net17 dc_inst.x4.net10 0
C7751 VPWR dc_inst.x6.net12 0.11868f
C7752 _25_/a_1462_47# dc_inst.x7.net2 0
C7753 dc_inst.x5.x8/a_27_47# dc_inst.x4.net10 0
C7754 dc_inst.x5.x11/a_27_47# path_sel[0] 0
C7755 dc_inst.x4.x15/a_27_47# path_sel[1] 0.00482f
C7756 dc_inst.x1.x1/a_27_47# path_sel[0] 0.0322f
C7757 path_sel[2] dc_inst.x7.x9/a_27_47# 0.0027f
C7758 dc_inst.x5.x14/a_27_47# dc_inst.x5.net19 0
C7759 delay_sel[0] dc_inst.in 0.04701f
C7760 dc_inst.x5.x15/a_27_47# dc_inst.x5.x16/a_27_47# 0.02448f
C7761 dc_inst.x6.x9/a_27_47# dc_inst.x6.net1 0.03171f
C7762 dc_inst.x6.x16/a_27_47# dc_inst.x6.net12 0
C7763 dc_inst.net1 dc_inst.x8/a_247_21# 0.00179f
C7764 path_sel[2] dc_inst.x6.net12 0.04774f
C7765 dc_inst.x7.net5 dc_inst.x7.net17 0
C7766 _15_/a_872_316# _20_/a_79_21# 0
C7767 dc_inst.x6.net14 dc_inst.x6.x15/a_27_47# 0.01536f
C7768 dc_inst.x5.x15/a_27_47# dc_inst.x4.net11 0
C7769 dc_inst.x2.net6 dc_inst.x2.x3/a_27_47# 0
C7770 dc_inst.x3.net4 dc_inst.x7.net4 0
C7771 dc_inst.x7.net4 dc_inst.x7.net18 0
C7772 dc_inst.x1.net1 _07_ 0.00382f
C7773 dc_inst.x6.net15 dc_inst.x6.net12 0.01302f
C7774 dc_inst.x1.net2 _15_/a_872_316# 0
C7775 _04_ _07_ 0
C7776 dc_inst.x1.net3 _15_/a_600_345# 0.01417f
C7777 capture_q dc_inst.x8/a_1290_413# 0
C7778 dc_inst.net9 dc_inst.x6.x15/a_27_47# 0
C7779 dc_inst.x9/a_247_21# delay_sel[1] 0.02431f
C7780 dc_inst.x9/a_923_363# dc_inst.net7 0
C7781 clknet_0_clk dc_inst.net9 0
C7782 dc_inst.x9/a_757_363# delay_sel[0] 0.07377f
C7783 dc_inst.x4.x10/a_27_47# dc_inst.x4.x9/a_27_47# 0.02448f
C7784 dc_inst.net5 dc_inst.x6.x19/a_27_47# 0
C7785 dc_inst.x6.net13 dc_inst.x4.net5 0
C7786 dc_inst.net4 dc_inst.x4.net19 0.00364f
C7787 dc_inst.x5.net12 dc_inst.x4.net10 0
C7788 dc_inst.x5.net7 dc_inst.x2.x14/a_27_47# 0
C7789 dc_inst.x1.x16/a_27_47# dc_inst.x2.x4/a_27_47# 0
C7790 dc_inst.x3.x3/a_27_47# dc_inst.x3.net16 0.00372f
C7791 VPWR path_sel[1] 1.35649f
C7792 dc_inst.x6.net6 dc_inst.x7.net4 0
C7793 dc_inst.x1.x4/a_27_47# dc_inst.x1.net12 0
C7794 dc_inst.x10/a_76_199# dc_inst.x7.net19 0.01257f
C7795 dc_inst.x10/a_505_21# dc_inst.x3.net17 0
C7796 path_sel[2] path_sel[1] 0.54461f
C7797 rst dc_inst.x8/a_247_21# 0.01183f
C7798 dc_inst.x5.x1/a_27_47# dc_inst.x5.net2 0.00199f
C7799 _18_/a_76_199# _07_ 0.02124f
C7800 _18_/a_505_21# path[1] 0
C7801 _18_/a_535_374# path_sel[0] 0
C7802 dc_inst.net3 dc_inst.x3.net15 0
C7803 dc_inst.x3.x16/a_27_47# dc_inst.x3.net16 0.00266f
C7804 dc_inst.x1.x3/a_27_47# dc_inst.x3.net19 0.00125f
C7805 dc_inst.x6.net12 dc_inst.x4.net5 0
C7806 tdi dc_inst.x3.net17 0
C7807 dc_inst.net4 dc_inst.x7.net18 0
C7808 dc_inst.x6.net14 dc_inst.x4.x7/a_27_47# 0
C7809 path[7] _20_/a_79_21# 0
C7810 _15_/a_1281_47# _06_ 0
C7811 dc_inst.x1.x12/a_27_47# _08_ 0
C7812 rst path[6] 0.0423f
C7813 tdo dc_inst.x1.x18/a_27_47# 0.01323f
C7814 dc_inst.x7.x2/a_27_47# _25_/a_1108_47# 0
C7815 dc_inst.x1.x20/a_27_47# delay_sel[1] 0
C7816 dc_inst.x4.net11 dc_inst.x5.x6/a_27_47# 0
C7817 dc_inst.x6.net3 dc_inst.x7.net8 0
C7818 dc_inst.x6.net6 dc_inst.net4 0.65544f
C7819 dc_inst.x1.x14/a_27_47# dc_inst.x2.net1 0
C7820 dc_inst.x6.net8 dc_inst.x6.x9/a_27_47# 0.00453f
C7821 dc_inst.x7.x12/a_27_47# clkbuf_1_0__f_clk/a_110_47# 0.01013f
C7822 dc_inst.x1.net3 path[6] 0.077f
C7823 VPWR _18_/a_505_21# 0.11143f
C7824 dc_inst.x1.net2 path[7] 0.0178f
C7825 dc_inst.net3 dc_inst.x1.x16/a_27_47# 0
C7826 dc_inst.x7.net12 dc_inst.x7.x19/a_27_47# 0.01108f
C7827 _19_/a_27_47# _09_ 0.00871f
C7828 dc_inst.net6 dc_inst.x9/a_1478_413# 0
C7829 dc_inst.x7.net2 dc_inst.x9/a_750_97# 0.03087f
C7830 dc_inst.x1.x13/a_27_47# path_sel[0] 0
C7831 dc_inst.x1.net3 dc_inst.x1.x6/a_27_47# 0
C7832 dc_inst.in dc_inst.x8/a_750_97# 0
C7833 dc_inst.x5.x11/a_27_47# dc_inst.x1.net7 0
C7834 dc_inst.x1.net15 dc_inst.x5.net6 0
C7835 dc_inst.x3.x14/a_27_47# dc_inst.x3.net14 0.00377f
C7836 dc_inst.x7.net10 dc_inst.x7.net6 0.0396f
C7837 path_sel[0] dc_inst.x3.net17 0
C7838 path_sel[1] dc_inst.x4.net5 0.00224f
C7839 dc_inst.x4.x4/a_27_47# dc_inst.x1.net17 0
C7840 dc_inst.x1.net12 dc_inst.x5.net11 0.00175f
C7841 dc_inst.x1.net6 _19_/a_27_47# 0
C7842 dc_inst.x5.net4 dc_inst.x5.net5 0.29667f
C7843 path[2] _07_ 0.00571f
C7844 path[7] dc_inst.x3.x11/a_27_47# 0.0016f
C7845 dc_inst.x7.x20/a_27_47# dc_inst.x7.net16 0
C7846 dc_inst.x3.x2/a_27_47# dc_inst.x3.x19/a_27_47# 0.01254f
C7847 dc_inst.x4.net15 dc_inst.net4 0
C7848 path_sel[1] dc_inst.x1.net8 0.12726f
C7849 tdi dc_inst.x3.net11 0.00161f
C7850 se dc_inst.x3.net12 0
C7851 path[5] dc_inst.in 0
C7852 dc_inst.x4.net16 dc_inst.x5.net8 0
C7853 dc_inst.x6.x6/a_27_47# dc_inst.x6.x9/a_27_47# 0
C7854 dc_inst.x1.net19 dc_inst.x2.net16 0
C7855 dc_inst.x4.net9 dc_inst.x4.x7/a_27_47# 0.00123f
C7856 dc_inst.x4.net16 dc_inst.x4.x17/a_27_47# 0.0173f
C7857 dc_inst.x5.net15 path_sel[1] 0.04004f
C7858 dc_inst.x9/a_1478_413# dc_inst.x8/a_277_47# 0
C7859 dc_inst.x7.x8/a_27_47# dc_inst.x7.net9 0.00325f
C7860 dc_inst.x6.net16 dc_inst.x7.net4 0
C7861 _23_/a_193_47# shadow_q 0
C7862 dc_inst.x7.x2/a_27_47# _00_ 0
C7863 dc_inst.x7.net2 dc_inst.x6.x14/a_27_47# 0
C7864 VPWR dc_inst.x3.net16 0.32183f
C7865 capture_d _23_/a_27_47# 0.04554f
C7866 dc_inst.x3.x2/a_27_47# dc_inst.x3.net18 0
C7867 dc_inst.x3.net2 dc_inst.x8/a_247_21# 0
C7868 dc_inst.x3.net3 dc_inst.x3.x18/a_27_47# 0
C7869 dc_inst.x10/a_505_21# _23_/a_651_413# 0
C7870 dc_inst.x1.net15 dc_inst.x2.x16/a_27_47# 0.0385f
C7871 dc_inst.x3.x20/a_27_47# dc_inst.x8/a_1290_413# 0
C7872 dc_inst.x6.x11/a_27_47# dc_inst.net4 0.01578f
C7873 dc_inst.x7.net1 dc_inst.x7.x18/a_27_47# 0.00104f
C7874 VPWR path[3] 0.22326f
C7875 dc_inst.x3.x16/a_27_47# _23_/a_1108_47# 0.00179f
C7876 dc_inst.x3.net9 path[6] 0.00197f
C7877 path_sel[1] dc_inst.x2.net2 0.00495f
C7878 dc_inst.x4.net13 dc_inst.x5.x1/a_27_47# 0
C7879 dc_inst.x2.x18/a_27_47# dc_inst.x2.net18 0.00377f
C7880 dc_inst.x2.net1 dc_inst.x2.net12 0.00175f
C7881 path_sel[2] path[3] 0.00651f
C7882 _23_/a_1108_47# _03_ 0
C7883 dc_inst.net6 dc_inst.net7 0.0385f
C7884 dc_inst.x3.net2 path[6] 0.0291f
C7885 path[4] dc_inst.x3.x20/a_27_47# 0
C7886 dc_inst.x2.x19/a_27_47# path_sel[0] 0
C7887 path[7] dc_inst.x3.net19 0.00117f
C7888 dc_inst.net3 dc_inst.x6.net17 0.00287f
C7889 _14_/a_439_47# tdi 0.00123f
C7890 dc_inst.x7.net1 _03_ 0.00313f
C7891 dc_inst.x4.x13/a_27_47# dc_inst.x6.x10/a_27_47# 0
C7892 dc_inst.x1.net5 _10_ 0.05267f
C7893 dc_inst.x3.net15 _23_/a_543_47# 0
C7894 path_sel[0] dc_inst.x3.net11 0.00481f
C7895 VPWR dc_inst.x2.x7/a_27_47# 0.03331f
C7896 dc_inst.x1.net12 _09_ 0
C7897 dc_inst.x7.x20/a_27_47# dc_inst.net9 0
C7898 dc_inst.x6.net16 dc_inst.net4 0.0015f
C7899 dc_inst.x6.net14 dc_inst.x8/a_27_413# 0
C7900 dc_inst.x1.x5/a_27_47# dc_inst.x1.net7 0.03139f
C7901 dc_inst.x1.net10 dc_inst.x5.net9 0
C7902 VPWR dc_inst.x6.net10 0.3752f
C7903 _13_/a_27_297# dc_inst.x3.x16/a_27_47# 0
C7904 dc_inst.x1.net6 dc_inst.x1.net12 0.28932f
C7905 tdo dc_inst.x4.x16/a_27_47# 0.00136f
C7906 dc_inst.x2.net12 dc_inst.x4.net9 0
C7907 dc_inst.x5.net11 dc_inst.x2.x14/a_27_47# 0
C7908 dc_inst.x5.x11/a_27_47# dc_inst.x5.net12 0.00659f
C7909 path_sel[2] dc_inst.x6.net10 0.00685f
C7910 dc_inst.x1.x4/a_27_47# dc_inst.in 0.03315f
C7911 delay_sel[0] dc_inst.x8/a_923_363# 0
C7912 delay_sel[1] dc_inst.x8/a_193_413# 0.00365f
C7913 dc_inst.net9 dc_inst.x8/a_27_413# 0.04336f
C7914 dc_inst.x1.net2 dc_inst.x1.x10/a_27_47# 0
C7915 _23_/a_1462_47# shadow_q 0
C7916 dc_inst.x9/a_750_97# dc_inst.x6.x12/a_27_47# 0
C7917 delay_sel[2] _23_/a_639_47# 0.00107f
C7918 dc_inst.x3.net3 dc_inst.x8/a_668_97# 0
C7919 dc_inst.x6.x1/a_27_47# dc_inst.x9/a_757_363# 0
C7920 dc_inst.net5 dc_inst.x9/a_247_21# 0
C7921 dc_inst.x3.x7/a_27_47# path[5] 0.01921f
C7922 dc_inst.x3.x3/a_27_47# dc_inst.x3.x16/a_27_47# 0
C7923 dc_inst.x1.net19 dc_inst.x1.net9 0
C7924 dc_inst.x3.net5 dc_inst.x3.x5/a_27_47# 0.01975f
C7925 dc_inst.x2.net10 _17_/a_27_93# 0
C7926 dc_inst.x3.x13/a_27_47# dc_inst.x3.net13 0
C7927 dc_inst.x1.x13/a_27_47# dc_inst.x1.net7 0
C7928 dc_inst.x5.net2 dc_inst.x4.net18 0
C7929 dc_inst.x4.net11 dc_inst.x5.x1/a_27_47# 0
C7930 dc_inst.x7.net2 dc_inst.x6.net2 0.22749f
C7931 se shadow_q 0
C7932 _24_/a_27_47# _23_/a_27_47# 0
C7933 dc_inst.x1.x3/a_27_47# dc_inst.x8/a_750_97# 0
C7934 dc_inst.x4.x15/a_27_47# dc_inst.x4.x19/a_27_47# 0
C7935 dc_inst.x6.x13/a_27_47# dc_inst.x6.x14/a_27_47# 0.02448f
C7936 dc_inst.x7.net3 dc_inst.in 0.02796f
C7937 dc_inst.x1.net13 dc_inst.x1.net12 0.02494f
C7938 _01_ dc_inst.x3.net5 0
C7939 dc_inst.x7.x3/a_27_47# dc_inst.x8/a_750_97# 0
C7940 _15_/a_788_316# _15_/a_1281_47# -0
C7941 _15_/a_27_47# path[6] 0.04643f
C7942 dc_inst.x6.x13/a_27_47# dc_inst.x4.net8 0
C7943 dc_inst.x2.net17 dc_inst.x8/a_1290_413# 0
C7944 dc_inst.x1.x9/a_27_47# dc_inst.in 0
C7945 dc_inst.x2.net16 dc_inst.x1.x20/a_27_47# 0
C7946 _04_ _06_ 0.12587f
C7947 VPWR _23_/a_1108_47# 0.00968f
C7948 dc_inst.x2.x2/a_27_47# dc_inst.x2.x3/a_27_47# 0
C7949 dc_inst.x1.x3/a_27_47# path[5] 0.02134f
C7950 dc_inst.x4.net6 dc_inst.x4.x8/a_27_47# 0
C7951 VPWR dc_inst.x2.x5/a_27_47# 0.00877f
C7952 dc_inst.x6.x12/a_27_47# dc_inst.x6.x14/a_27_47# 0
C7953 _02_ dc_inst.x3.net16 0
C7954 capture_q dc_inst.x3.x17/a_27_47# 0
C7955 _25_/a_1283_21# dc_inst.x7.net19 0
C7956 VPWR dc_inst.x7.net1 0.54004f
C7957 dc_inst.x4.x3/a_27_47# dc_inst.x8/a_834_97# 0
C7958 VPWR _14_/a_535_374# -0
C7959 dc_inst.x6.net10 dc_inst.x4.net5 0
C7960 dc_inst.x7.net1 path_sel[2] 0.00134f
C7961 _14_/a_505_21# dc_inst.x3.net6 0
C7962 delay_sel[1] dc_inst.x8/a_834_97# 0.00137f
C7963 delay_sel[2] shadow_q 0.01429f
C7964 VPWR dc_inst.x4.x19/a_27_47# 0.00205f
C7965 dc_inst.x1.net1 dc_inst.x1.net11 0.0047f
C7966 dc_inst.x5.net18 dc_inst.x5.net19 0.01983f
C7967 dc_inst.net3 dc_inst.x6.net18 0
C7968 dc_inst.x4.x2/a_27_47# dc_inst.x1.net17 0
C7969 dc_inst.x4.net3 dc_inst.x1.x17/a_27_47# 0
C7970 _04_ dc_inst.x1.net11 0
C7971 dc_inst.x5.net10 dc_inst.x1.net9 0
C7972 VPWR _13_/a_27_297# 0.02724f
C7973 dc_inst.x5.x4/a_27_47# dc_inst.x2.net10 0
C7974 dc_inst.x1.net10 dc_inst.x5.net1 0.00221f
C7975 dc_inst.x6.x6/a_27_47# path_sel[0] 0
C7976 dc_inst.x5.x19/a_27_47# dc_inst.x5.net7 0
C7977 dc_inst.x1.net5 _20_/a_79_21# 0.00211f
C7978 dc_inst.x5.net4 dc_inst.x5.x4/a_27_47# 0.04991f
C7979 dc_inst.x3.net18 dc_inst.x3.x19/a_27_47# 0.13315f
C7980 tdo dc_inst.net3 0
C7981 rst dc_inst.x3.x10/a_27_47# 0
C7982 dc_inst.x4.net1 dc_inst.x2.net8 0
C7983 dc_inst.x1.x14/a_27_47# path_sel[1] 0
C7984 _15_/a_872_316# path[5] 0.02841f
C7985 _15_/a_1279_413# path[7] 0
C7986 VPWR dc_inst.x3.x3/a_27_47# 0
C7987 dc_inst.x2.net7 dc_inst.x5.x9/a_27_47# 0
C7988 dc_inst.x1.net11 _18_/a_76_199# 0.00188f
C7989 dc_inst.x4.net14 dc_inst.x5.net2 0
C7990 dc_inst.x6.net10 dc_inst.x2.net2 0
C7991 dc_inst.x2.net5 dc_inst.x2.net10 0
C7992 VPWR dc_inst.x7.x18/a_27_47# 0
C7993 VPWR dc_inst.x10/a_535_374# 0.00112f
C7994 dc_inst.x1.net5 dc_inst.x1.net2 0.02033f
C7995 dc_inst.x8/a_923_363# dc_inst.x8/a_750_97# -0
C7996 dc_inst.x8/a_277_47# dc_inst.x8/a_1290_413# -0.00422f
C7997 dc_inst.x5.net4 dc_inst.x2.net5 0
C7998 path_sel[1] dc_inst.x4.x7/a_27_47# 0.00638f
C7999 VPWR dc_inst.x3.x16/a_27_47# 0.01153f
C8000 _24_/a_1108_47# _13_/a_470_297# 0
C8001 dc_inst.x3.net3 dc_inst.x3.net5 0
C8002 dc_inst.x7.x2/a_27_47# delay_sel[1] 0.00424f
C8003 dc_inst.x4.net12 dc_inst.x4.net19 0
C8004 delay_sel[0] dc_inst.x7.net10 0
C8005 tdi dc_inst.x3.net6 0
C8006 se dc_inst.x3.net7 0
C8007 dc_inst.x5.net6 dc_inst.x5.net7 0.17264f
C8008 VPWR _03_ -0.02381f
C8009 dc_inst.x5.net6 dc_inst.x4.x6/a_27_47# 0.03381f
C8010 _09_ dc_inst.in 0
C8011 path[2] _06_ 0
C8012 dc_inst.x1.net5 dc_inst.x1.net15 0
C8013 dc_inst.x6.x3/a_27_47# dc_inst.x5.x20/a_27_47# 0
C8014 path[6] dc_inst.x8/a_1478_413# 0.00209f
C8015 _15_/a_788_316# dc_inst.net2 0
C8016 tdo dc_inst.x4.x8/a_27_47# 0.00679f
C8017 dc_inst.x7.net2 dc_inst.x6.x12/a_27_47# 0
C8018 rst dc_inst.x7.net19 0.00614f
C8019 dc_inst.net3 dc_inst.x9/a_277_47# 0
C8020 dc_inst.x5.x20/a_27_47# dc_inst.x6.net19 0
C8021 dc_inst.x4.x13/a_27_47# dc_inst.x5.net2 0
C8022 dc_inst.x6.x7/a_27_47# dc_inst.x7.x6/a_27_47# 0
C8023 dc_inst.x7.net12 dc_inst.x7.net14 0.04327f
C8024 dc_inst.x1.net19 dc_inst.x2.net15 0.00304f
C8025 dc_inst.x7.net4 dc_inst.x7.x16/a_27_47# 0
C8026 _24_/a_761_289# shadow_q 0
C8027 _02_ _23_/a_1108_47# 0
C8028 _24_/a_193_47# capture_d -0.00973f
C8029 dc_inst.x7.net3 dc_inst.x7.x3/a_27_47# 0.05267f
C8030 dc_inst.x4.net2 dc_inst.x1.net2 0
C8031 _25_/a_651_413# dc_inst.x7.net1 0.00272f
C8032 dc_inst.x2.x18/a_27_47# dc_inst.x1.x8/a_27_47# 0
C8033 _00_ clk 0.01719f
C8034 path[7] path[5] 0.1692f
C8035 dc_inst.x4.x15/a_27_47# VPWR -0.00738f
C8036 dc_inst.x1.net15 dc_inst.x2.x15/a_27_47# 0
C8037 dc_inst.x3.x8/a_27_47# VGND 0.21068f
C8038 dc_inst.x6.net8 VGND 0.20107f
C8039 dc_inst.x6.x7/a_27_47# VGND 0.20759f
C8040 dc_inst.x1.net12 VGND 0.30477f
C8041 dc_inst.x1.x12/a_27_47# VGND 0.20097f
C8042 dc_inst.x4.x20/a_27_47# VGND 0.28418f
C8043 dc_inst.x3.net8 VGND 0.27669f
C8044 dc_inst.x3.x7/a_27_47# VGND 0.20231f
C8045 dc_inst.x6.net7 VGND 0.3538f
C8046 dc_inst.x6.net6 VGND 0.41296f
C8047 dc_inst.x6.x6/a_27_47# VGND 0.20729f
C8048 dc_inst.x5.net19 VGND 0.5141f
C8049 dc_inst.x5.x19/a_27_47# VGND 0.20754f
C8050 dc_inst.x1.net11 VGND 0.23459f
C8051 dc_inst.x1.x11/a_27_47# VGND 0.20914f
C8052 dc_inst.x3.net7 VGND 0.15787f
C8053 dc_inst.x3.net6 VGND 0.16988f
C8054 dc_inst.x3.x6/a_27_47# VGND 0.2053f
C8055 dc_inst.x6.x5/a_27_47# VGND 0.19831f
C8056 dc_inst.x1.net1 VGND 0.19312f
C8057 dc_inst.x1.net10 VGND 0.21657f
C8058 dc_inst.x1.x10/a_27_47# VGND 0.20953f
C8059 dc_inst.x5.net18 VGND 0.16928f
C8060 dc_inst.x5.x18/a_27_47# VGND 0.24624f
C8061 dc_inst.x3.x5/a_27_47# VGND 0.2383f
C8062 dc_inst.x6.net5 VGND 0.19032f
C8063 dc_inst.x6.x4/a_27_47# VGND 0.20717f
C8064 dc_inst.x1.x20/a_27_47# VGND 0.27865f
C8065 dc_inst.x5.net17 VGND 0.32528f
C8066 dc_inst.x5.x17/a_27_47# VGND 0.21182f
C8067 dc_inst.x3.net5 VGND 0.15259f
C8068 dc_inst.x3.x4/a_27_47# VGND 0.20465f
C8069 dc_inst.x6.net4 VGND 0.19533f
C8070 dc_inst.x6.x3/a_27_47# VGND 0.20713f
C8071 dc_inst.x2.net19 VGND 0.249f
C8072 dc_inst.x2.x19/a_27_47# VGND 0.2413f
C8073 _04_ VGND 0.23736f
C8074 dc_inst.x5.net16 VGND 0.3721f
C8075 dc_inst.x5.net15 VGND 0.24353f
C8076 dc_inst.x5.x16/a_27_47# VGND 0.2165f
C8077 dc_inst.x3.net4 VGND 0.21272f
C8078 dc_inst.x3.x3/a_27_47# VGND 0.20796f
C8079 dc_inst.x6.net3 VGND 0.24657f
C8080 dc_inst.x6.net2 VGND 0.33046f
C8081 dc_inst.x6.x2/a_27_47# VGND 0.22674f
C8082 _01_ VGND 0.38434f
C8083 rst VGND 1.43716f
C8084 dc_inst.x2.net18 VGND 0.42072f
C8085 dc_inst.x2.x18/a_27_47# VGND 0.21232f
C8086 dc_inst.x5.x15/a_27_47# VGND 0.20695f
C8087 dc_inst.x3.net3 VGND 0.65415f
C8088 dc_inst.x3.net2 VGND 0.48008f
C8089 dc_inst.x3.x2/a_27_47# VGND 0.20355f
C8090 _05_ VGND 0.18963f
C8091 _13_/a_470_47# VGND 0
C8092 _13_/a_470_297# VGND 0.02004f
C8093 _13_/a_27_297# VGND 0.00302f
C8094 _13_/a_112_47# VGND 0.27287f
C8095 dc_inst.net5 VGND 0.46469f
C8096 dc_inst.x6.x1/a_27_47# VGND 0.1938f
C8097 dc_inst.x2.net17 VGND 0.20598f
C8098 dc_inst.x2.x17/a_27_47# VGND 0.20869f
C8099 dc_inst.x5.net14 VGND 0.20509f
C8100 dc_inst.x5.net13 VGND 0.23734f
C8101 dc_inst.x5.x14/a_27_47# VGND 0.20388f
C8102 dc_inst.net8 VGND 1.09074f
C8103 delay_sel[2] VGND 1.55915f
C8104 capture_d VGND 0.33487f
C8105 dc_inst.x10/a_439_47# VGND -0
C8106 dc_inst.x10/a_535_374# VGND -0
C8107 dc_inst.x10/a_218_374# VGND -0
C8108 dc_inst.x10/a_505_21# VGND 0.26112f
C8109 dc_inst.x10/a_76_199# VGND 0.13023f
C8110 dc_inst.x3.x1/a_27_47# VGND 0.21088f
C8111 tdi VGND 1.55929f
C8112 se VGND 1.27036f
C8113 _14_/a_439_47# VGND -0
C8114 _14_/a_218_47# VGND 0
C8115 _14_/a_535_374# VGND -0
C8116 _14_/a_218_374# VGND -0
C8117 _14_/a_505_21# VGND 0.25582f
C8118 _14_/a_76_199# VGND 0.1385f
C8119 dc_inst.x2.net16 VGND 0.19833f
C8120 dc_inst.x2.x16/a_27_47# VGND 0.23058f
C8121 dc_inst.x5.net12 VGND 3.43444f
C8122 dc_inst.x5.x13/a_27_47# VGND 0.20644f
C8123 path[4] VGND 0.56334f
C8124 path[5] VGND 0.61905f
C8125 path[7] VGND 1.78095f
C8126 path[6] VGND 0.56785f
C8127 _15_/a_1281_47# VGND -0
C8128 _15_/a_1064_47# VGND -0
C8129 _15_/a_397_47# VGND -0
C8130 _15_/a_1279_413# VGND -0
C8131 _15_/a_872_316# VGND 0.0189f
C8132 _15_/a_193_47# VGND -0
C8133 _15_/a_600_345# VGND 0.16458f
C8134 _15_/a_788_316# VGND 0.20349f
C8135 _15_/a_372_413# VGND 0
C8136 _15_/a_288_47# VGND 0.02175f
C8137 _15_/a_193_369# VGND 0
C8138 _15_/a_27_47# VGND 0.28432f
C8139 dc_inst.x2.net15 VGND 0.45603f
C8140 dc_inst.x2.x15/a_27_47# VGND 0.2123f
C8141 dc_inst.x5.x12/a_27_47# VGND 0.20857f
C8142 clkbuf_1_1__f_clk/a_110_47# VGND 1.74948f
C8143 dc_inst.x2.net14 VGND 0.19832f
C8144 dc_inst.x2.x14/a_27_47# VGND 0.20891f
C8145 _07_ VGND 0.23124f
C8146 path[1] VGND 0.7864f
C8147 path_sel[0] VGND 3.63778f
C8148 _16_/a_229_47# VGND 0.05391f
C8149 _16_/a_27_93# VGND 0.30513f
C8150 dc_inst.x5.net11 VGND 0.29954f
C8151 dc_inst.x5.x11/a_27_47# VGND 0.26214f
C8152 dc_inst.x2.net13 VGND 0.23819f
C8153 dc_inst.x2.x13/a_27_47# VGND 0.20894f
C8154 _08_ VGND 0.2073f
C8155 path_sel[1] VGND 1.8608f
C8156 path[0] VGND 1.46967f
C8157 _17_/a_478_47# VGND 0.08016f
C8158 _17_/a_27_93# VGND 0.21107f
C8159 _17_/a_174_21# VGND 0.20825f
C8160 dc_inst.x5.net1 VGND 0.26285f
C8161 dc_inst.x5.net10 VGND 0.24013f
C8162 dc_inst.x5.x10/a_27_47# VGND 0.20773f
C8163 dc_inst.x5.x9/a_27_47# VGND 0.25008f
C8164 dc_inst.x2.net10 VGND 0.22468f
C8165 dc_inst.x2.x9/a_27_47# VGND 0.24025f
C8166 path[3] VGND 0.65298f
C8167 path[2] VGND 0.72545f
C8168 _09_ VGND 0.15879f
C8169 _18_/a_535_374# VGND -0
C8170 _18_/a_505_21# VGND 0.27564f
C8171 _18_/a_76_199# VGND 0.13872f
C8172 dc_inst.x2.net12 VGND 0.35773f
C8173 dc_inst.x2.x12/a_27_47# VGND 0.20911f
C8174 dc_inst.x5.net9 VGND 0.25467f
C8175 dc_inst.x5.net8 VGND 0.23576f
C8176 dc_inst.x5.x8/a_27_47# VGND 0.23978f
C8177 dc_inst.x5.x20/a_27_47# VGND 0.28019f
C8178 dc_inst.x2.net9 VGND 0.19744f
C8179 dc_inst.x2.x8/a_27_47# VGND 0.21063f
C8180 _10_ VGND 0.3446f
C8181 path_sel[2] VGND 1.18289f
C8182 _19_/a_465_47# VGND -0
C8183 _19_/a_205_47# VGND 0
C8184 _19_/a_193_297# VGND -0
C8185 _19_/a_109_297# VGND -0.00123f
C8186 _19_/a_27_47# VGND 0.29576f
C8187 dc_inst.x2.net11 VGND 0.21677f
C8188 dc_inst.x2.x11/a_27_47# VGND 0.20893f
C8189 dc_inst.x5.net7 VGND 0.4371f
C8190 dc_inst.x5.x7/a_27_47# VGND 0.20423f
C8191 dc_inst.x6.x19/a_27_47# VGND 0.22386f
C8192 dc_inst.x2.net8 VGND 0.18618f
C8193 dc_inst.x2.x7/a_27_47# VGND 0.20644f
C8194 dc_inst.x5.x6/a_27_47# VGND 0.20376f
C8195 dc_inst.x2.net1 VGND 0.18796f
C8196 dc_inst.x2.x10/a_27_47# VGND 0.20777f
C8197 dc_inst.x6.net18 VGND 0.27521f
C8198 dc_inst.x6.x18/a_27_47# VGND 0.25032f
C8199 dc_inst.x2.net7 VGND 0.18137f
C8200 dc_inst.x2.net6 VGND 0.40452f
C8201 dc_inst.x2.x6/a_27_47# VGND 0.20157f
C8202 dc_inst.x2.x20/a_27_47# VGND 0.28865f
C8203 dc_inst.x5.net6 VGND 0.76626f
C8204 dc_inst.x5.net5 VGND 0.17356f
C8205 dc_inst.x5.x5/a_27_47# VGND 0.19483f
C8206 dc_inst.x6.net17 VGND 0.35001f
C8207 dc_inst.x6.x17/a_27_47# VGND 0.19549f
C8208 dc_inst.x2.x5/a_27_47# VGND 0.24403f
C8209 dc_inst.x5.x4/a_27_47# VGND 0.20862f
C8210 dc_inst.x3.x19/a_27_47# VGND 0.20416f
C8211 clknet_1_0__leaf_clk VGND 0.71268f
C8212 clknet_0_clk VGND 1.29001f
C8213 clkbuf_1_0__f_clk/a_110_47# VGND 1.7332f
C8214 dc_inst.x6.net16 VGND 0.17943f
C8215 dc_inst.x6.x16/a_27_47# VGND 0.20634f
C8216 dc_inst.x2.net5 VGND 0.24881f
C8217 dc_inst.x2.x4/a_27_47# VGND 0.21192f
C8218 dc_inst.x3.net18 VGND 0.21285f
C8219 dc_inst.x3.x18/a_27_47# VGND 0.20575f
C8220 dc_inst.x5.net4 VGND 0.25489f
C8221 dc_inst.x5.x3/a_27_47# VGND 0.23795f
C8222 dc_inst.x6.net15 VGND 0.18641f
C8223 dc_inst.x6.x15/a_27_47# VGND 0.24885f
C8224 dc_inst.x2.net4 VGND 0.18144f
C8225 dc_inst.x2.x3/a_27_47# VGND 0.20719f
C8226 dc_inst.x5.net3 VGND 0.33344f
C8227 dc_inst.x5.net2 VGND 0.36417f
C8228 dc_inst.x5.x2/a_27_47# VGND 0.2464f
C8229 dc_inst.x3.net17 VGND 0.26428f
C8230 dc_inst.x3.net16 VGND 0.19571f
C8231 dc_inst.x3.x17/a_27_47# VGND 0.2007f
C8232 dc_inst.x6.net14 VGND 0.24376f
C8233 dc_inst.x6.x14/a_27_47# VGND 0.20368f
C8234 dc_inst.x2.net3 VGND 0.17825f
C8235 dc_inst.x2.net2 VGND 0.16052f
C8236 dc_inst.x2.x2/a_27_47# VGND 0.20726f
C8237 dc_inst.x3.x16/a_27_47# VGND 0.19612f
C8238 dc_inst.net4 VGND 0.53806f
C8239 dc_inst.x5.x1/a_27_47# VGND 0.20528f
C8240 dc_inst.x6.net13 VGND 0.2285f
C8241 dc_inst.x6.x13/a_27_47# VGND 0.24109f
C8242 dc_inst.net1 VGND 0.47471f
C8243 dc_inst.x2.x1/a_27_47# VGND 0.20589f
C8244 dc_inst.x3.net15 VGND 0.17204f
C8245 dc_inst.x3.x15/a_27_47# VGND 0.24565f
C8246 dc_inst.x6.net12 VGND 0.18734f
C8247 dc_inst.x6.x12/a_27_47# VGND 0.2071f
C8248 dc_inst.x3.net14 VGND 0.51411f
C8249 dc_inst.x3.net13 VGND 0.22509f
C8250 dc_inst.x3.x14/a_27_47# VGND 0.20725f
C8251 dc_inst.x6.net11 VGND 0.35355f
C8252 dc_inst.x6.x11/a_27_47# VGND 0.20376f
C8253 dc_inst.x3.x13/a_27_47# VGND 0.2052f
C8254 dc_inst.x6.net1 VGND 0.15449f
C8255 dc_inst.x6.net10 VGND 0.15774f
C8256 dc_inst.x6.x10/a_27_47# VGND 0.20693f
C8257 dc_inst.x7.net10 VGND 0.2101f
C8258 dc_inst.x7.x9/a_27_47# VGND 0.22622f
C8259 dc_inst.x6.net19 VGND 0.20476f
C8260 dc_inst.x6.x20/a_27_47# VGND 0.27876f
C8261 dc_inst.x3.net12 VGND 0.61271f
C8262 dc_inst.x3.net11 VGND 0.4637f
C8263 dc_inst.x3.x12/a_27_47# VGND 0.21271f
C8264 dc_inst.x4.net10 VGND 0.23035f
C8265 dc_inst.x4.net9 VGND 0.38117f
C8266 dc_inst.x4.x9/a_27_47# VGND 0.20508f
C8267 dc_inst.in VGND 1.58291f
C8268 _06_ VGND 0.32619f
C8269 _20_/a_384_47# VGND 0.02697f
C8270 _20_/a_470_297# VGND -0.00158f
C8271 _20_/a_79_21# VGND 0.24052f
C8272 dc_inst.x7.net9 VGND 0.46603f
C8273 dc_inst.x7.x8/a_27_47# VGND 0.21153f
C8274 dc_inst.net9 VGND 0.52407f
C8275 delay_sel[1] VGND 2.11942f
C8276 dc_inst.net7 VGND 0.47585f
C8277 delay_sel[0] VGND 1.36458f
C8278 dc_inst.x9/a_834_97# VGND 0.01584f
C8279 dc_inst.x9/a_668_97# VGND 0.0155f
C8280 dc_inst.x9/a_193_47# VGND -0
C8281 dc_inst.x9/a_27_47# VGND 0.03599f
C8282 dc_inst.x9/a_1478_413# VGND 0.15287f
C8283 dc_inst.x9/a_1290_413# VGND 0.19621f
C8284 dc_inst.x9/a_750_97# VGND 0.03215f
C8285 dc_inst.x9/a_757_363# VGND 0.00666f
C8286 dc_inst.x9/a_277_47# VGND -0.31746f
C8287 dc_inst.x9/a_247_21# VGND 0.33369f
C8288 dc_inst.x9/a_193_413# VGND 0.00305f
C8289 dc_inst.x9/a_27_413# VGND 0.02678f
C8290 dc_inst.x1.net9 VGND 0.29714f
C8291 dc_inst.x1.x9/a_27_47# VGND 0.21021f
C8292 dc_inst.x3.x11/a_27_47# VGND 0.19996f
C8293 dc_inst.x7.net19 VGND 0.25633f
C8294 dc_inst.x7.x19/a_27_47# VGND 0.19351f
C8295 dc_inst.x4.x8/a_27_47# VGND 0.20471f
C8296 dc_inst.x7.net8 VGND 0.17228f
C8297 dc_inst.x7.x7/a_27_47# VGND 0.20696f
C8298 dc_inst.net2 VGND 0.55887f
C8299 dc_inst.x8/a_834_97# VGND 0.02337f
C8300 dc_inst.x8/a_668_97# VGND 0.01733f
C8301 dc_inst.x8/a_193_47# VGND -0
C8302 dc_inst.x8/a_27_47# VGND 0.02685f
C8303 dc_inst.x8/a_1478_413# VGND 0.15507f
C8304 dc_inst.x8/a_1290_413# VGND 0.20594f
C8305 dc_inst.x8/a_750_97# VGND 0.04831f
C8306 dc_inst.x8/a_757_363# VGND 0.01436f
C8307 dc_inst.x8/a_923_363# VGND 0
C8308 dc_inst.x8/a_277_47# VGND -0.28619f
C8309 dc_inst.x8/a_247_21# VGND 0.35678f
C8310 dc_inst.x8/a_193_413# VGND 0.00446f
C8311 dc_inst.x8/a_27_413# VGND 0.02756f
C8312 dc_inst.x1.x8/a_27_47# VGND 0.19661f
C8313 dc_inst.x7.net18 VGND 0.13405f
C8314 dc_inst.x7.x18/a_27_47# VGND 0.20425f
C8315 dc_inst.x3.net1 VGND 0.24381f
C8316 dc_inst.x3.net10 VGND 0.20705f
C8317 dc_inst.x3.x10/a_27_47# VGND 0.22632f
C8318 dc_inst.x4.net8 VGND 0.27819f
C8319 dc_inst.x4.net7 VGND 0.14916f
C8320 dc_inst.x4.x7/a_27_47# VGND 0.20775f
C8321 dc_inst.x7.net7 VGND 0.15558f
C8322 dc_inst.x7.net6 VGND 0.51031f
C8323 dc_inst.x7.x6/a_27_47# VGND 0.20679f
C8324 _03_ VGND 0.44054f
C8325 dc_inst.x3.net19 VGND 0.29348f
C8326 dc_inst.x3.x20/a_27_47# VGND 0.28601f
C8327 dc_inst.x1.net8 VGND 0.31888f
C8328 dc_inst.x1.net7 VGND 0.85799f
C8329 dc_inst.x1.x7/a_27_47# VGND 0.24321f
C8330 dc_inst.x7.net17 VGND 0.254f
C8331 dc_inst.x7.x17/a_27_47# VGND 0.20382f
C8332 dc_inst.x4.x6/a_27_47# VGND 0.20092f
C8333 dc_inst.x7.x5/a_27_47# VGND 0.23948f
C8334 shadow_q VGND 0.72134f
C8335 _23_/a_1462_47# VGND 0.00226f
C8336 _23_/a_1217_47# VGND 0
C8337 _23_/a_1270_413# VGND 0
C8338 _23_/a_651_413# VGND 0.00469f
C8339 _23_/a_448_47# VGND 0.0139f
C8340 _23_/a_1108_47# VGND 0.16902f
C8341 _23_/a_1283_21# VGND 0.4233f
C8342 _23_/a_543_47# VGND 0.15918f
C8343 _23_/a_761_289# VGND 0.12382f
C8344 _23_/a_193_47# VGND 0.27994f
C8345 _23_/a_27_47# VGND 0.53687f
C8346 dc_inst.x1.x6/a_27_47# VGND 0.22481f
C8347 dc_inst.x7.net16 VGND 0.20212f
C8348 dc_inst.x7.x16/a_27_47# VGND 0.20394f
C8349 dc_inst.x4.net6 VGND 0.117f
C8350 dc_inst.x4.net5 VGND 0.37891f
C8351 dc_inst.x4.x5/a_27_47# VGND 0.2018f
C8352 dc_inst.x4.net19 VGND 0.27769f
C8353 dc_inst.x4.net18 VGND 0.34224f
C8354 dc_inst.x4.x19/a_27_47# VGND 0.20098f
C8355 dc_inst.x7.net5 VGND 0.12374f
C8356 dc_inst.x7.net4 VGND 0.54929f
C8357 dc_inst.x7.x4/a_27_47# VGND 0.19352f
C8358 capture_q VGND 0.34702f
C8359 _02_ VGND 1.22976f
C8360 clknet_1_1__leaf_clk VGND 0.93673f
C8361 _24_/a_1462_47# VGND 0
C8362 _24_/a_1217_47# VGND 0.00108f
C8363 _24_/a_805_47# VGND 0
C8364 _24_/a_639_47# VGND 0
C8365 _24_/a_1270_413# VGND 0
C8366 _24_/a_651_413# VGND 0.00548f
C8367 _24_/a_448_47# VGND 0.0139f
C8368 _24_/a_1108_47# VGND 0.17558f
C8369 _24_/a_1283_21# VGND 0.39249f
C8370 _24_/a_543_47# VGND 0.15967f
C8371 _24_/a_761_289# VGND 0.12916f
C8372 _24_/a_193_47# VGND 0.29749f
C8373 _24_/a_27_47# VGND 0.53625f
C8374 dc_inst.x1.net6 VGND 0.18527f
C8375 dc_inst.x1.net5 VGND 0.19323f
C8376 dc_inst.x1.x5/a_27_47# VGND 0.19302f
C8377 dc_inst.x4.net17 VGND 0.31505f
C8378 dc_inst.x4.x18/a_27_47# VGND 0.19683f
C8379 dc_inst.x7.net15 VGND 0.19671f
C8380 dc_inst.x7.x15/a_27_47# VGND 0.20386f
C8381 clk VGND 1.82173f
C8382 clkbuf_0_clk/a_110_47# VGND 1.71828f
C8383 dc_inst.x4.x4/a_27_47# VGND 0.21672f
C8384 dc_inst.x7.x3/a_27_47# VGND 0.24161f
C8385 tdo VGND 2.31003f
C8386 _00_ VGND 0.27905f
C8387 _25_/a_651_413# VGND 0.00469f
C8388 _25_/a_448_47# VGND 0.0139f
C8389 _25_/a_1108_47# VGND 0.13523f
C8390 _25_/a_1283_21# VGND 0.37845f
C8391 _25_/a_543_47# VGND 0.15789f
C8392 _25_/a_761_289# VGND 0.12073f
C8393 _25_/a_193_47# VGND 0.27412f
C8394 _25_/a_27_47# VGND 0.49504f
C8395 dc_inst.x1.net4 VGND 0.24546f
C8396 dc_inst.x1.x4/a_27_47# VGND 0.19744f
C8397 dc_inst.x4.net4 VGND 0.28673f
C8398 dc_inst.x4.x3/a_27_47# VGND 0.23866f
C8399 dc_inst.x4.x17/a_27_47# VGND 0.20773f
C8400 dc_inst.x7.net14 VGND 0.36509f
C8401 dc_inst.x7.x14/a_27_47# VGND 0.22627f
C8402 dc_inst.x7.net3 VGND 0.58813f
C8403 dc_inst.x7.x2/a_27_47# VGND 0.19276f
C8404 dc_inst.x1.x3/a_27_47# VGND 0.20423f
C8405 dc_inst.x1.net19 VGND 0.30043f
C8406 dc_inst.x1.net18 VGND 0.4907f
C8407 dc_inst.x1.x19/a_27_47# VGND 0.20585f
C8408 dc_inst.x7.net13 VGND 0.33414f
C8409 dc_inst.x7.net12 VGND 0.37768f
C8410 dc_inst.x7.x13/a_27_47# VGND 0.20716f
C8411 dc_inst.x4.net3 VGND 0.21365f
C8412 dc_inst.x4.net2 VGND 0.44093f
C8413 dc_inst.x4.x2/a_27_47# VGND 0.20503f
C8414 dc_inst.x4.net16 VGND 0.26883f
C8415 dc_inst.x4.x16/a_27_47# VGND 0.19355f
C8416 dc_inst.x7.net2 VGND 0.60666f
C8417 dc_inst.net6 VGND 0.45945f
C8418 dc_inst.x7.x1/a_27_47# VGND 0.20362f
C8419 dc_inst.x1.net3 VGND 0.31061f
C8420 dc_inst.x1.net2 VGND 0.54956f
C8421 dc_inst.x1.x2/a_27_47# VGND 0.20583f
C8422 VPWR VGND 70.59151f
C8423 dc_inst.net3 VGND 0.31503f
C8424 dc_inst.x4.x1/a_27_47# VGND 0.22074f
C8425 dc_inst.x1.x18/a_27_47# VGND 0.23251f
C8426 dc_inst.x4.net15 VGND 0.12463f
C8427 dc_inst.x4.net14 VGND 0.42455f
C8428 dc_inst.x4.x15/a_27_47# VGND 0.20102f
C8429 dc_inst.x7.net11 VGND 0.26168f
C8430 dc_inst.x7.x12/a_27_47# VGND 0.22667f
C8431 clkload0/X VGND 0.0666f
C8432 clkload0/a_27_47# VGND 0.55937f
C8433 dc_inst.x1.x1/a_27_47# VGND 0.22927f
C8434 dc_inst.x1.net17 VGND 0.36389f
C8435 dc_inst.x1.net16 VGND 0.49263f
C8436 dc_inst.x1.x17/a_27_47# VGND 0.24139f
C8437 dc_inst.x7.x11/a_27_47# VGND 0.22826f
C8438 dc_inst.x4.x14/a_27_47# VGND 0.2424f
C8439 dc_inst.x1.net15 VGND 0.2302f
C8440 dc_inst.x1.x16/a_27_47# VGND 0.20715f
C8441 dc_inst.x4.net13 VGND 0.2101f
C8442 dc_inst.x4.net12 VGND 0.22214f
C8443 dc_inst.x4.x13/a_27_47# VGND 0.20382f
C8444 dc_inst.x7.net1 VGND 0.51083f
C8445 dc_inst.x7.x10/a_27_47# VGND 0.20159f
C8446 dc_inst.x1.x15/a_27_47# VGND 0.20214f
C8447 dc_inst.x7.x20/a_27_47# VGND 0.23968f
C8448 dc_inst.x4.x12/a_27_47# VGND 0.2068f
C8449 dc_inst.x6.x9/a_27_47# VGND 0.20737f
C8450 dc_inst.x1.net14 VGND 0.14545f
C8451 dc_inst.x1.x14/a_27_47# VGND 0.20668f
C8452 dc_inst.x4.net11 VGND 0.16236f
C8453 dc_inst.x4.net1 VGND 0.15396f
C8454 dc_inst.x4.x11/a_27_47# VGND 0.20686f
C8455 dc_inst.x3.net9 VGND 0.28655f
C8456 dc_inst.x3.x9/a_27_47# VGND 0.2114f
C8457 dc_inst.x1.net13 VGND 0.22871f
C8458 dc_inst.x1.x13/a_27_47# VGND 0.2069f
C8459 dc_inst.x6.net9 VGND 0.15374f
C8460 dc_inst.x6.x8/a_27_47# VGND 0.20715f
C8461 dc_inst.x4.x10/a_27_47# VGND 0.20385f
.ends

.subckt sky130_fd_sc_hd__conb_1 LO HI VPB VNB VGND VPWR
X0 VPWR HI sky130_fd_pr__res_generic_po w=0.48 l=0.5
X1 LO VGND sky130_fd_pr__res_generic_po w=0.48 l=0.5
C0 VPB VGND 0.00479f
C1 VPB VPWR 0.12754f
C2 VPB HI 0.00473f
C3 VGND LO 0.06047f
C4 LO VPWR 0.20599f
C5 LO HI 0.06803f
C6 VPB LO 0.10357f
C7 VGND VPWR 0.03175f
C8 VGND HI 0.2068f
C9 VPWR HI 0.05153f
C10 VGND VNB 0.40596f
C11 LO VNB 0.14107f
C12 HI VNB 0.24957f
C13 VPWR VNB 0.27461f
C14 VPB VNB 0.33898f
.ends

.subckt sky130_fd_sc_hd__o21bai_4 VNB VPB VGND VPWR A2 A1 B1_N Y a_33_297# a_561_297#
+ a_225_47#
X0 Y a_33_297# VPWR VPB sky130_fd_pr__pfet_01v8_hvt ad=0.135 pd=1.27 as=0.135 ps=1.27 w=1 l=0.15
X1 a_225_47# a_33_297# Y VNB sky130_fd_pr__nfet_01v8 ad=0.08775 pd=0.92 as=0.08775 ps=0.92 w=0.65 l=0.15
X2 VPWR a_33_297# Y VPB sky130_fd_pr__pfet_01v8_hvt ad=0.135 pd=1.27 as=0.135 ps=1.27 w=1 l=0.15
X3 a_33_297# B1_N VGND VNB sky130_fd_pr__nfet_01v8 ad=0.169 pd=1.82 as=0.182 ps=1.86 w=0.65 l=0.15
X4 Y a_33_297# VPWR VPB sky130_fd_pr__pfet_01v8_hvt ad=0.135 pd=1.27 as=0.135 ps=1.27 w=1 l=0.15
X5 Y A2 a_561_297# VPB sky130_fd_pr__pfet_01v8_hvt ad=0.135 pd=1.27 as=0.26 ps=2.52 w=1 l=0.15
X6 Y a_33_297# a_225_47# VNB sky130_fd_pr__nfet_01v8 ad=0.08775 pd=0.92 as=0.169 ps=1.82 w=0.65 l=0.15
X7 Y a_33_297# a_225_47# VNB sky130_fd_pr__nfet_01v8 ad=0.08775 pd=0.92 as=0.08775 ps=0.92 w=0.65 l=0.15
X8 VGND A2 a_225_47# VNB sky130_fd_pr__nfet_01v8 ad=0.08775 pd=0.92 as=0.08775 ps=0.92 w=0.65 l=0.15
X9 VGND A2 a_225_47# VNB sky130_fd_pr__nfet_01v8 ad=0.08775 pd=0.92 as=0.08775 ps=0.92 w=0.65 l=0.15
X10 a_561_297# A1 VPWR VPB sky130_fd_pr__pfet_01v8_hvt ad=0.28 pd=2.56 as=0.135 ps=1.27 w=1 l=0.15
X11 a_225_47# a_33_297# Y VNB sky130_fd_pr__nfet_01v8 ad=0.08775 pd=0.92 as=0.08775 ps=0.92 w=0.65 l=0.15
X12 VPWR A1 a_561_297# VPB sky130_fd_pr__pfet_01v8_hvt ad=0.135 pd=1.27 as=0.135 ps=1.27 w=1 l=0.15
X13 a_225_47# A1 VGND VNB sky130_fd_pr__nfet_01v8 ad=0.08775 pd=0.92 as=0.08775 ps=0.92 w=0.65 l=0.15
X14 a_225_47# A1 VGND VNB sky130_fd_pr__nfet_01v8 ad=0.169 pd=1.82 as=0.08775 ps=0.92 w=0.65 l=0.15
X15 a_225_47# A2 VGND VNB sky130_fd_pr__nfet_01v8 ad=0.08775 pd=0.92 as=0.08775 ps=0.92 w=0.65 l=0.15
X16 a_225_47# A2 VGND VNB sky130_fd_pr__nfet_01v8 ad=0.08775 pd=0.92 as=0.08775 ps=0.92 w=0.65 l=0.15
X17 VPWR A1 a_561_297# VPB sky130_fd_pr__pfet_01v8_hvt ad=0.135 pd=1.27 as=0.135 ps=1.27 w=1 l=0.15
X18 a_561_297# A1 VPWR VPB sky130_fd_pr__pfet_01v8_hvt ad=0.135 pd=1.27 as=0.135 ps=1.27 w=1 l=0.15
X19 VPWR B1_N a_33_297# VPB sky130_fd_pr__pfet_01v8_hvt ad=0.135 pd=1.27 as=0.28 ps=2.56 w=1 l=0.15
X20 a_561_297# A2 Y VPB sky130_fd_pr__pfet_01v8_hvt ad=0.135 pd=1.27 as=0.135 ps=1.27 w=1 l=0.15
X21 VGND A1 a_225_47# VNB sky130_fd_pr__nfet_01v8 ad=0.08775 pd=0.92 as=0.08775 ps=0.92 w=0.65 l=0.15
X22 Y A2 a_561_297# VPB sky130_fd_pr__pfet_01v8_hvt ad=0.135 pd=1.27 as=0.135 ps=1.27 w=1 l=0.15
X23 VGND A1 a_225_47# VNB sky130_fd_pr__nfet_01v8 ad=0.08775 pd=0.92 as=0.08775 ps=0.92 w=0.65 l=0.15
X24 a_561_297# A2 Y VPB sky130_fd_pr__pfet_01v8_hvt ad=0.135 pd=1.27 as=0.135 ps=1.27 w=1 l=0.15
X25 VPWR a_33_297# Y VPB sky130_fd_pr__pfet_01v8_hvt ad=0.26 pd=2.52 as=0.135 ps=1.27 w=1 l=0.15
C0 VPWR a_225_47# 0.0095f
C1 A1 a_225_47# 0.21301f
C2 VPWR Y 0.37486f
C3 VPWR VPB 0.14497f
C4 VGND A2 0.05333f
C5 Y A1 0.00215f
C6 A1 VPB 0.14788f
C7 a_561_297# A2 0.06429f
C8 a_33_297# A2 0.03966f
C9 VGND a_225_47# 0.70108f
C10 a_561_297# a_225_47# 0.0062f
C11 Y VGND 0.02586f
C12 Y B1_N 0
C13 VGND VPB 0.01159f
C14 VPB B1_N 0.03664f
C15 a_33_297# a_225_47# 0.0649f
C16 Y a_561_297# 0.26408f
C17 a_561_297# VPB 0.01777f
C18 VPWR A1 0.11051f
C19 Y a_33_297# 0.34029f
C20 a_33_297# VPB 0.15935f
C21 VPWR VGND 0.13406f
C22 VPWR B1_N 0.01772f
C23 VGND A1 0.06516f
C24 VPWR a_561_297# 0.63411f
C25 a_225_47# A2 0.17964f
C26 A1 a_561_297# 0.30934f
C27 VPWR a_33_297# 0.22058f
C28 Y A2 0.18653f
C29 VPB A2 0.1201f
C30 VGND B1_N 0.04269f
C31 VGND a_561_297# 0.00993f
C32 Y a_225_47# 0.15932f
C33 a_225_47# VPB 0
C34 VGND a_33_297# 0.14134f
C35 a_33_297# B1_N 0.12844f
C36 Y VPB 0.02334f
C37 a_33_297# a_561_297# 0
C38 VPWR A2 0.03461f
C39 A1 A2 0.06856f
C40 VGND VNB 0.80207f
C41 Y VNB 0.01612f
C42 VPWR VNB 0.63003f
C43 A1 VNB 0.44102f
C44 A2 VNB 0.35262f
C45 B1_N VNB 0.14408f
C46 VPB VNB 1.40213f
C47 a_225_47# VNB 0.05028f
C48 a_561_297# VNB 0.00161f
C49 a_33_297# VNB 0.46686f
.ends

.subckt sky130_fd_sc_hd__diode_2 DIODE VGND VPWR VPB VNB
X0 VNB DIODE sky130_fd_pr__diode_pw2nd_05v5 perim=2.64e+06 area=4.347e+11
C0 DIODE VPWR 0.10545f
C1 VPB VGND 0.00316f
C2 VPB DIODE 0.04668f
C3 DIODE VGND 0.10707f
C4 VPB VPWR 0.02381f
C5 VPWR VGND 0.01795f
C6 VGND VNB 0.14722f
C7 VPWR VNB 0.12772f
C8 DIODE VNB 0.18399f
C9 VPB VNB 0.25038f
.ends

.subckt sky130_fd_sc_hd__nor2_1 VPB VNB VGND VPWR A B Y a_109_297#
X0 VPWR A a_109_297# VPB sky130_fd_pr__pfet_01v8_hvt ad=0.26 pd=2.52 as=0.105 ps=1.21 w=1 l=0.15
X1 VGND A Y VNB sky130_fd_pr__nfet_01v8 ad=0.169 pd=1.82 as=0.08775 ps=0.92 w=0.65 l=0.15
X2 a_109_297# B Y VPB sky130_fd_pr__pfet_01v8_hvt ad=0.105 pd=1.21 as=0.26 ps=2.52 w=1 l=0.15
X3 Y B VGND VNB sky130_fd_pr__nfet_01v8 ad=0.08775 pd=0.92 as=0.169 ps=1.82 w=0.65 l=0.15
C0 a_109_297# VPWR 0.00638f
C1 VPB B 0.0367f
C2 VGND a_109_297# 0.00128f
C3 B Y 0.08765f
C4 VPB VPWR 0.04486f
C5 VGND VPB 0.00456f
C6 Y VPWR 0.09951f
C7 VGND Y 0.15445f
C8 VPB A 0.04146f
C9 B VPWR 0.01484f
C10 A Y 0.04707f
C11 VGND B 0.04509f
C12 a_109_297# Y 0.01129f
C13 VGND VPWR 0.03144f
C14 B A 0.05841f
C15 VPB Y 0.01392f
C16 A VPWR 0.05282f
C17 VGND A 0.04856f
C18 VGND VNB 0.2632f
C19 VPWR VNB 0.21414f
C20 Y VNB 0.06051f
C21 A VNB 0.14927f
C22 B VNB 0.14312f
C23 VPB VNB 0.33898f
.ends

.subckt sky130_fd_sc_hd__a21boi_2 VNB VPB VPWR VGND B1_N A2 Y A1 a_61_47# a_479_47#
+ a_217_297# a_637_47#
X0 Y a_61_47# VGND VNB sky130_fd_pr__nfet_01v8 ad=0.08775 pd=0.92 as=0.18313 ps=1.24 w=0.65 l=0.15
X1 VPWR A2 a_217_297# VPB sky130_fd_pr__pfet_01v8_hvt ad=0.135 pd=1.27 as=0.135 ps=1.27 w=1 l=0.15
X2 a_217_297# a_61_47# Y VPB sky130_fd_pr__pfet_01v8_hvt ad=0.135 pd=1.27 as=0.135 ps=1.27 w=1 l=0.15
X3 a_479_47# A2 VGND VNB sky130_fd_pr__nfet_01v8 ad=0.06825 pd=0.86 as=0.10725 ps=0.98 w=0.65 l=0.15
X4 a_217_297# A2 VPWR VPB sky130_fd_pr__pfet_01v8_hvt ad=0.285 pd=2.57 as=0.14 ps=1.28 w=1 l=0.15
X5 Y a_61_47# a_217_297# VPB sky130_fd_pr__pfet_01v8_hvt ad=0.135 pd=1.27 as=0.26 ps=2.52 w=1 l=0.15
X6 VPWR A1 a_217_297# VPB sky130_fd_pr__pfet_01v8_hvt ad=0.14 pd=1.28 as=0.14 ps=1.28 w=1 l=0.15
X7 a_61_47# B1_N VPWR VPB sky130_fd_pr__pfet_01v8_hvt ad=0.1113 pd=1.37 as=0.1113 ps=1.37 w=0.42 l=0.15
X8 VGND A2 a_637_47# VNB sky130_fd_pr__nfet_01v8 ad=0.18525 pd=1.87 as=0.091 ps=0.93 w=0.65 l=0.15
X9 VGND a_61_47# Y VNB sky130_fd_pr__nfet_01v8 ad=0.10725 pd=0.98 as=0.08775 ps=0.92 w=0.65 l=0.15
X10 Y A1 a_479_47# VNB sky130_fd_pr__nfet_01v8 ad=0.091 pd=0.93 as=0.06825 ps=0.86 w=0.65 l=0.15
X11 VGND B1_N a_61_47# VNB sky130_fd_pr__nfet_01v8 ad=0.18313 pd=1.24 as=0.126 ps=1.44 w=0.42 l=0.15
X12 a_217_297# A1 VPWR VPB sky130_fd_pr__pfet_01v8_hvt ad=0.14 pd=1.28 as=0.135 ps=1.27 w=1 l=0.15
X13 a_637_47# A1 Y VNB sky130_fd_pr__nfet_01v8 ad=0.091 pd=0.93 as=0.091 ps=0.93 w=0.65 l=0.15
C0 Y VPB 0.00636f
C1 VPWR a_61_47# 0.06819f
C2 Y VGND 0.22564f
C3 VGND a_479_47# 0.00385f
C4 VPWR Y 0.0102f
C5 VPWR a_479_47# 0
C6 VGND a_637_47# 0.011f
C7 VPWR a_637_47# 0.00126f
C8 B1_N A2 0
C9 A1 a_61_47# 0
C10 Y A1 0.05697f
C11 a_61_47# A2 0.05951f
C12 a_217_297# VPB 0.01688f
C13 VGND a_217_297# 0.0144f
C14 Y A2 0.07129f
C15 VGND VPB 0.01161f
C16 A1 a_637_47# 0
C17 a_479_47# A2 0
C18 VPWR a_217_297# 0.37518f
C19 VPWR VPB 0.10245f
C20 a_637_47# A2 0.00296f
C21 VPWR VGND 0.08359f
C22 A1 a_217_297# 0.02373f
C23 A1 VPB 0.05386f
C24 VGND A1 0.03194f
C25 a_217_297# A2 0.16659f
C26 VPB A2 0.06992f
C27 B1_N a_61_47# 0.15315f
C28 VPWR A1 0.02753f
C29 VGND A2 0.06239f
C30 B1_N Y 0.00143f
C31 VPWR A2 0.04033f
C32 Y a_61_47# 0.09684f
C33 Y a_479_47# 0.00798f
C34 A1 A2 0.22525f
C35 Y a_637_47# 0.00432f
C36 B1_N a_217_297# 0.00225f
C37 B1_N VPB 0.09619f
C38 B1_N VGND 0.02149f
C39 B1_N VPWR 0.03971f
C40 a_61_47# a_217_297# 0.08542f
C41 a_61_47# VPB 0.09343f
C42 Y a_217_297# 0.08509f
C43 VGND a_61_47# 0.1698f
C44 VGND VNB 0.52055f
C45 Y VNB 0.01987f
C46 VPWR VNB 0.42386f
C47 B1_N VNB 0.2447f
C48 A1 VNB 0.17307f
C49 A2 VNB 0.2351f
C50 VPB VNB 0.87055f
C51 a_217_297# VNB 0.02474f
C52 a_61_47# VNB 0.24559f
.ends

.subckt rca VGND VPWR a[0] a[10] a[11] a[12] a[13] a[14] a[15] a[1] a[2] a[3] a[4]
+ a[5] a[6] a[7] a[8] a[9] b[0] b[10] b[11] b[12] b[13] b[14] b[15] b[1] b[2] b[3]
+ b[4] b[5] b[6] b[7] b[8] b[9] cin clk cout delay_sel[0] delay_sel[1] delay_sel[2]
+ rst s[0] s[10] s[11] s[12] s[13] s[14] s[15] s[1] s[2] s[3] s[4] s[5] s[6] s[7]
+ s[8] s[9] tdo
XFILLER_39_211 VPWR VGND VPWR VGND sky130_fd_sc_hd__decap_3
XFILLER_39_255 VPWR VGND VPWR VGND sky130_fd_sc_hd__decap_3
XFILLER_54_203 VPWR VGND VPWR VGND sky130_fd_sc_hd__decap_3
XFILLER_39_299 VPWR VGND VPWR VGND sky130_fd_sc_hd__decap_3
XFILLER_54_236 VPWR VGND VPWR VGND sky130_fd_sc_hd__decap_3
XFILLER_22_100 VPWR VGND VPWR VGND sky130_fd_sc_hd__decap_3
XFILLER_62_280 VPWR VGND VPWR VGND sky130_fd_sc_hd__decap_3
XFILLER_22_133 VPWR VGND VPWR VGND sky130_fd_sc_hd__decap_3
XFILLER_52_29 VPWR VGND VPWR VGND sky130_fd_sc_hd__decap_3
XFILLER_22_144 VPWR VGND VPWR VGND sky130_fd_sc_hd__decap_3
XFILLER_22_177 VPWR VGND VPWR VGND sky130_fd_sc_hd__decap_3
XFILLER_45_214 VPWR VGND VPWR VGND sky130_fd_sc_hd__decap_3
XFILLER_45_225 VPWR VGND VPWR VGND sky130_fd_sc_hd__decap_3
XFILLER_26_41 VPWR VGND VPWR VGND sky130_fd_sc_hd__decap_3
XFILLER_45_258 VPWR VGND VPWR VGND sky130_fd_sc_hd__decap_3
XFILLER_60_206 VPWR VGND VPWR VGND sky130_fd_sc_hd__decap_3
XFILLER_60_239 VPWR VGND VPWR VGND sky130_fd_sc_hd__decap_3
XFILLER_13_122 VPWR VGND VPWR VGND sky130_fd_sc_hd__decap_3
XFILLER_26_85 VPWR VGND VPWR VGND sky130_fd_sc_hd__decap_3
XFILLER_13_155 VPWR VGND VPWR VGND sky130_fd_sc_hd__decap_3
XFILLER_9_137 VPWR VGND VPWR VGND sky130_fd_sc_hd__decap_3
X_294_ VGND VPWR VPWR VGND clknet_2_1__leaf_clk_regs net29 _039_ genblk1\[6\].fa_inst.b
+ _294_/a_1462_47# _294_/a_543_47# _294_/a_651_413# _294_/a_193_47# _294_/a_805_47#
+ _294_/a_448_47# _294_/a_639_47# _294_/a_1283_21# _294_/a_761_289# _294_/a_1108_47#
+ _294_/a_1217_47# _294_/a_1270_413# _294_/a_27_47# sky130_fd_sc_hd__dfrtp_1
XFILLER_42_62 VPWR VGND VPWR VGND sky130_fd_sc_hd__decap_3
XFILLER_5_343 VPWR VGND VPWR VGND sky130_fd_sc_hd__decap_3
XFILLER_54_9 VPWR VGND VPWR VGND sky130_fd_sc_hd__decap_3
XFILLER_5_376 VPWR VGND VPWR VGND sky130_fd_sc_hd__decap_3
XFILLER_3_78 VPWR VGND VPWR VGND sky130_fd_sc_hd__decap_3
XFILLER_36_203 VPWR VGND VPWR VGND sky130_fd_sc_hd__decap_3
XPHY_EDGE_ROW_20_1_Right_19 VPWR VGND VPWR VGND sky130_fd_sc_hd__decap_3
XFILLER_36_236 VPWR VGND VPWR VGND sky130_fd_sc_hd__decap_3
XFILLER_51_228 VPWR VGND VPWR VGND sky130_fd_sc_hd__decap_3
XFILLER_51_217 VPWR VGND VPWR VGND sky130_fd_sc_hd__decap_3
XFILLER_44_280 VPWR VGND VPWR VGND sky130_fd_sc_hd__decap_3
XFILLER_59_317 VPWR VGND VPWR VGND sky130_fd_sc_hd__decap_3
XFILLER_47_18 VPWR VGND VPWR VGND sky130_fd_sc_hd__decap_3
XFILLER_27_214 VPWR VGND VPWR VGND sky130_fd_sc_hd__decap_3
XFILLER_27_225 VPWR VGND VPWR VGND sky130_fd_sc_hd__decap_3
XFILLER_27_258 VPWR VGND VPWR VGND sky130_fd_sc_hd__decap_3
XFILLER_63_28 VPWR VGND VPWR VGND sky130_fd_sc_hd__decap_3
XFILLER_42_206 VPWR VGND VPWR VGND sky130_fd_sc_hd__decap_3
XFILLER_42_239 VPWR VGND VPWR VGND sky130_fd_sc_hd__decap_3
XFILLER_10_103 VPWR VGND VPWR VGND sky130_fd_sc_hd__decap_3
XFILLER_50_283 VPWR VGND VPWR VGND sky130_fd_sc_hd__decap_3
XFILLER_10_147 VPWR VGND VPWR VGND sky130_fd_sc_hd__decap_3
XFILLER_10_136 VPWR VGND VPWR VGND sky130_fd_sc_hd__decap_3
XFILLER_6_118 VPWR VGND VPWR VGND sky130_fd_sc_hd__decap_3
XFILLER_12_32 VPWR VGND VPWR VGND sky130_fd_sc_hd__decap_3
XFILLER_12_65 VPWR VGND VPWR VGND sky130_fd_sc_hd__decap_3
XFILLER_2_357 VPWR VGND VPWR VGND sky130_fd_sc_hd__decap_3
XFILLER_2_346 VPWR VGND VPWR VGND sky130_fd_sc_hd__decap_3
XFILLER_58_383 VPWR VGND VPWR VGND sky130_fd_sc_hd__decap_3
XFILLER_37_40 VPWR VGND VPWR VGND sky130_fd_sc_hd__decap_3
XFILLER_37_95 VPWR VGND VPWR VGND sky130_fd_sc_hd__decap_3
XFILLER_33_217 VPWR VGND VPWR VGND sky130_fd_sc_hd__decap_3
XFILLER_26_280 VPWR VGND VPWR VGND sky130_fd_sc_hd__decap_3
XFILLER_33_228 VPWR VGND VPWR VGND sky130_fd_sc_hd__decap_3
XFILLER_53_72 VPWR VGND VPWR VGND sky130_fd_sc_hd__decap_3
XFILLER_41_261 VPWR VGND VPWR VGND sky130_fd_sc_hd__decap_3
X_277_ VGND VPWR VPWR VGND clknet_2_1__leaf_clk_regs net12 _022_ genblk1\[5\].fa_inst.a
+ _277_/a_1462_47# _277_/a_543_47# _277_/a_651_413# _277_/a_193_47# _277_/a_805_47#
+ _277_/a_448_47# _277_/a_639_47# _277_/a_1283_21# _277_/a_761_289# _277_/a_1108_47#
+ _277_/a_1217_47# _277_/a_1270_413# _277_/a_27_47# sky130_fd_sc_hd__dfrtp_1
XFILLER_5_140 VPWR VGND VPWR VGND sky130_fd_sc_hd__decap_3
XFILLER_56_309 VPWR VGND VPWR VGND sky130_fd_sc_hd__decap_3
XFILLER_49_361 VPWR VGND VPWR VGND sky130_fd_sc_hd__decap_3
XFILLER_64_320 VPWR VGND VPWR VGND sky130_fd_sc_hd__decap_3
XFILLER_64_386 VPWR VGND VPWR VGND sky130_fd_sc_hd__decap_3
XFILLER_24_206 VPWR VGND VPWR VGND sky130_fd_sc_hd__decap_3
XFILLER_24_239 VPWR VGND VPWR VGND sky130_fd_sc_hd__decap_3
XFILLER_32_283 VPWR VGND VPWR VGND sky130_fd_sc_hd__decap_3
XFILLER_59_169 VPWR VGND VPWR VGND sky130_fd_sc_hd__decap_3
XFILLER_59_147 VPWR VGND VPWR VGND sky130_fd_sc_hd__decap_3
XFILLER_55_320 VPWR VGND VPWR VGND sky130_fd_sc_hd__decap_3
XFILLER_55_364 VPWR VGND VPWR VGND sky130_fd_sc_hd__decap_3
XPHY_EDGE_ROW_21_Right_42 VPWR VGND VPWR VGND sky130_fd_sc_hd__decap_3
XFILLER_30_209 VPWR VGND VPWR VGND sky130_fd_sc_hd__decap_3
X_200_ VPWR VGND _109_ genblk1\[15\].fa_inst.a genblk1\[15\].fa_inst.b VPWR VGND _200_/a_145_75#
+ _200_/a_59_75# sky130_fd_sc_hd__and2_1
XFILLER_23_261 VPWR VGND VPWR VGND sky130_fd_sc_hd__decap_3
X_131_ VPWR VGND VGND VPWR _054_ genblk1\[1\].fa_inst.b genblk1\[1\].fa_inst.a _131_/a_150_297#
+ _131_/a_68_297# sky130_fd_sc_hd__or2_1
XPHY_EDGE_ROW_30_Right_51 VPWR VGND VPWR VGND sky130_fd_sc_hd__decap_3
XFILLER_2_121 VPWR VGND VPWR VGND sky130_fd_sc_hd__decap_3
XFILLER_2_165 VPWR VGND VPWR VGND sky130_fd_sc_hd__decap_3
XFILLER_38_309 VPWR VGND VPWR VGND sky130_fd_sc_hd__decap_3
XFILLER_48_61 VPWR VGND VPWR VGND sky130_fd_sc_hd__decap_3
XFILLER_17_9 VPWR VGND VPWR VGND sky130_fd_sc_hd__decap_3
XFILLER_58_180 VPWR VGND VPWR VGND sky130_fd_sc_hd__decap_3
XFILLER_46_342 VPWR VGND VPWR VGND sky130_fd_sc_hd__decap_3
XFILLER_0_35 VPWR VGND VPWR VGND sky130_fd_sc_hd__decap_3
XFILLER_0_24 VPWR VGND VPWR VGND sky130_fd_sc_hd__decap_3
XFILLER_0_57 VPWR VGND VPWR VGND sky130_fd_sc_hd__decap_3
XFILLER_61_323 VPWR VGND VPWR VGND sky130_fd_sc_hd__decap_3
XFILLER_64_60 VPWR VGND VPWR VGND sky130_fd_sc_hd__decap_3
XFILLER_46_386 VPWR VGND VPWR VGND sky130_fd_sc_hd__decap_3
XFILLER_61_367 VPWR VGND VPWR VGND sky130_fd_sc_hd__decap_3
XFILLER_21_209 VPWR VGND VPWR VGND sky130_fd_sc_hd__decap_3
XFILLER_9_66 VPWR VGND VPWR VGND sky130_fd_sc_hd__decap_3
XFILLER_9_99 VPWR VGND VPWR VGND sky130_fd_sc_hd__decap_3
XFILLER_56_106 VPWR VGND VPWR VGND sky130_fd_sc_hd__decap_3
XFILLER_37_320 VPWR VGND VPWR VGND sky130_fd_sc_hd__decap_3
XFILLER_64_150 VPWR VGND VPWR VGND sky130_fd_sc_hd__decap_3
XFILLER_52_301 VPWR VGND VPWR VGND sky130_fd_sc_hd__decap_3
XFILLER_37_364 VPWR VGND VPWR VGND sky130_fd_sc_hd__decap_3
XFILLER_64_172 VPWR VGND VPWR VGND sky130_fd_sc_hd__decap_3
XFILLER_52_312 VPWR VGND VPWR VGND sky130_fd_sc_hd__decap_3
XFILLER_52_345 VPWR VGND VPWR VGND sky130_fd_sc_hd__decap_3
XFILLER_52_389 VPWR VGND VPWR VGND sky130_fd_sc_hd__decap_3
XFILLER_47_128 VPWR VGND VPWR VGND sky130_fd_sc_hd__decap_3
XFILLER_28_342 VPWR VGND VPWR VGND sky130_fd_sc_hd__decap_3
XFILLER_62_109 VPWR VGND VPWR VGND sky130_fd_sc_hd__decap_3
XFILLER_55_161 VPWR VGND VPWR VGND sky130_fd_sc_hd__decap_3
XFILLER_43_323 VPWR VGND VPWR VGND sky130_fd_sc_hd__decap_3
XFILLER_18_97 VPWR VGND VPWR VGND sky130_fd_sc_hd__decap_3
XFILLER_28_386 VPWR VGND VPWR VGND sky130_fd_sc_hd__decap_3
XFILLER_55_172 VPWR VGND VPWR VGND sky130_fd_sc_hd__decap_3
XFILLER_43_367 VPWR VGND VPWR VGND sky130_fd_sc_hd__decap_3
XFILLER_34_41 VPWR VGND VPWR VGND sky130_fd_sc_hd__decap_3
XFILLER_34_74 VPWR VGND VPWR VGND sky130_fd_sc_hd__decap_3
XFILLER_34_85 VPWR VGND VPWR VGND sky130_fd_sc_hd__decap_3
XFILLER_50_62 VPWR VGND VPWR VGND sky130_fd_sc_hd__decap_3
XFILLER_59_60 VPWR VGND VPWR VGND sky130_fd_sc_hd__decap_3
XFILLER_59_93 VPWR VGND VPWR VGND sky130_fd_sc_hd__decap_3
XFILLER_38_106 VPWR VGND VPWR VGND sky130_fd_sc_hd__decap_3
XFILLER_15_6 VPWR VGND VPWR VGND sky130_fd_sc_hd__decap_3
XFILLER_19_331 VPWR VGND VPWR VGND sky130_fd_sc_hd__decap_3
XFILLER_19_364 VPWR VGND VPWR VGND sky130_fd_sc_hd__decap_3
XFILLER_46_150 VPWR VGND VPWR VGND sky130_fd_sc_hd__decap_3
XFILLER_34_301 VPWR VGND VPWR VGND sky130_fd_sc_hd__decap_3
XFILLER_34_312 VPWR VGND VPWR VGND sky130_fd_sc_hd__decap_3
XFILLER_19_397 VPWR VGND VPWR VGND sky130_fd_sc_hd__decap_3
XFILLER_46_183 VPWR VGND VPWR VGND sky130_fd_sc_hd__decap_3
XFILLER_61_131 VPWR VGND VPWR VGND sky130_fd_sc_hd__decap_3
XFILLER_34_345 VPWR VGND VPWR VGND sky130_fd_sc_hd__decap_3
XFILLER_61_175 VPWR VGND VPWR VGND sky130_fd_sc_hd__decap_3
XFILLER_61_164 VPWR VGND VPWR VGND sky130_fd_sc_hd__decap_3
XFILLER_34_389 VPWR VGND VPWR VGND sky130_fd_sc_hd__decap_3
XFILLER_29_106 VPWR VGND VPWR VGND sky130_fd_sc_hd__decap_3
XFILLER_29_128 VPWR VGND VPWR VGND sky130_fd_sc_hd__decap_3
XFILLER_37_172 VPWR VGND VPWR VGND sky130_fd_sc_hd__decap_3
XFILLER_37_161 VPWR VGND VPWR VGND sky130_fd_sc_hd__decap_3
XFILLER_25_323 VPWR VGND VPWR VGND sky130_fd_sc_hd__decap_3
XFILLER_25_367 VPWR VGND VPWR VGND sky130_fd_sc_hd__decap_3
XFILLER_52_131 VPWR VGND VPWR VGND sky130_fd_sc_hd__decap_3
XFILLER_52_153 VPWR VGND VPWR VGND sky130_fd_sc_hd__decap_3
XFILLER_40_315 VPWR VGND VPWR VGND sky130_fd_sc_hd__decap_3
XFILLER_40_304 VPWR VGND VPWR VGND sky130_fd_sc_hd__decap_3
XFILLER_52_186 VPWR VGND VPWR VGND sky130_fd_sc_hd__decap_3
XFILLER_40_348 VPWR VGND VPWR VGND sky130_fd_sc_hd__decap_3
XFILLER_52_197 VPWR VGND VPWR VGND sky130_fd_sc_hd__decap_3
XFILLER_20_21 VPWR VGND VPWR VGND sky130_fd_sc_hd__decap_3
XFILLER_20_32 VPWR VGND VPWR VGND sky130_fd_sc_hd__decap_3
XFILLER_20_76 VPWR VGND VPWR VGND sky130_fd_sc_hd__decap_3
XFILLER_0_400 VPWR VGND VPWR VGND sky130_fd_sc_hd__decap_3
XFILLER_48_404 VPWR VGND VPWR VGND sky130_fd_sc_hd__decap_3
XFILLER_29_96 VPWR VGND VPWR VGND sky130_fd_sc_hd__decap_3
XFILLER_35_109 VPWR VGND VPWR VGND sky130_fd_sc_hd__decap_3
XFILLER_28_183 VPWR VGND VPWR VGND sky130_fd_sc_hd__decap_3
XFILLER_16_334 VPWR VGND VPWR VGND sky130_fd_sc_hd__decap_3
XFILLER_45_62 VPWR VGND VPWR VGND sky130_fd_sc_hd__decap_3
XFILLER_45_73 VPWR VGND VPWR VGND sky130_fd_sc_hd__decap_3
XFILLER_43_131 VPWR VGND VPWR VGND sky130_fd_sc_hd__decap_3
XFILLER_16_378 VPWR VGND VPWR VGND sky130_fd_sc_hd__decap_3
XFILLER_31_326 VPWR VGND VPWR VGND sky130_fd_sc_hd__decap_3
XFILLER_43_164 VPWR VGND VPWR VGND sky130_fd_sc_hd__decap_3
XFILLER_43_175 VPWR VGND VPWR VGND sky130_fd_sc_hd__decap_3
XFILLER_31_337 VPWR VGND VPWR VGND sky130_fd_sc_hd__decap_3
XFILLER_61_72 VPWR VGND VPWR VGND sky130_fd_sc_hd__decap_3
XFILLER_6_12 VPWR VGND VPWR VGND sky130_fd_sc_hd__decap_3
XFILLER_6_56 VPWR VGND VPWR VGND sky130_fd_sc_hd__decap_3
XFILLER_13_3 VPWR VGND VPWR VGND sky130_fd_sc_hd__decap_3
XFILLER_26_109 VPWR VGND VPWR VGND sky130_fd_sc_hd__decap_3
XFILLER_19_161 VPWR VGND VPWR VGND sky130_fd_sc_hd__decap_3
XFILLER_19_172 VPWR VGND VPWR VGND sky130_fd_sc_hd__decap_3
XFILLER_34_153 VPWR VGND VPWR VGND sky130_fd_sc_hd__decap_3
XFILLER_22_304 VPWR VGND VPWR VGND sky130_fd_sc_hd__decap_3
XFILLER_22_315 VPWR VGND VPWR VGND sky130_fd_sc_hd__decap_3
XFILLER_34_186 VPWR VGND VPWR VGND sky130_fd_sc_hd__decap_3
XFILLER_34_197 VPWR VGND VPWR VGND sky130_fd_sc_hd__decap_3
XFILLER_22_348 VPWR VGND VPWR VGND sky130_fd_sc_hd__decap_3
XFILLER_30_392 VPWR VGND VPWR VGND sky130_fd_sc_hd__decap_3
XFILLER_57_234 VPWR VGND VPWR VGND sky130_fd_sc_hd__decap_3
XFILLER_57_267 VPWR VGND VPWR VGND sky130_fd_sc_hd__decap_3
XFILLER_17_109 VPWR VGND VPWR VGND sky130_fd_sc_hd__decap_3
XFILLER_25_131 VPWR VGND VPWR VGND sky130_fd_sc_hd__decap_3
XFILLER_25_164 VPWR VGND VPWR VGND sky130_fd_sc_hd__decap_3
XFILLER_25_175 VPWR VGND VPWR VGND sky130_fd_sc_hd__decap_3
XFILLER_13_337 VPWR VGND VPWR VGND sky130_fd_sc_hd__decap_3
XFILLER_15_43 VPWR VGND VPWR VGND sky130_fd_sc_hd__decap_3
XFILLER_15_87 VPWR VGND VPWR VGND sky130_fd_sc_hd__decap_3
XFILLER_40_156 VPWR VGND VPWR VGND sky130_fd_sc_hd__decap_3
XFILLER_40_189 VPWR VGND VPWR VGND sky130_fd_sc_hd__decap_3
XFILLER_31_53 VPWR VGND VPWR VGND sky130_fd_sc_hd__decap_3
XFILLER_31_75 VPWR VGND VPWR VGND sky130_fd_sc_hd__decap_3
Xoutput42 VPWR VGND s[12] net42 VPWR VGND output42/a_27_47# sky130_fd_sc_hd__buf_2
Xoutput53 VPWR VGND s[8] net53 VPWR VGND output53/a_27_47# sky130_fd_sc_hd__buf_2
XFILLER_48_212 VPWR VGND VPWR VGND sky130_fd_sc_hd__decap_3
XFILLER_56_50 VPWR VGND VPWR VGND sky130_fd_sc_hd__decap_3
XFILLER_48_256 VPWR VGND VPWR VGND sky130_fd_sc_hd__decap_3
XFILLER_48_245 VPWR VGND VPWR VGND sky130_fd_sc_hd__decap_3
XFILLER_63_237 VPWR VGND VPWR VGND sky130_fd_sc_hd__decap_3
XFILLER_48_289 VPWR VGND VPWR VGND sky130_fd_sc_hd__decap_3
XFILLER_16_131 VPWR VGND VPWR VGND sky130_fd_sc_hd__decap_3
XFILLER_56_94 VPWR VGND VPWR VGND sky130_fd_sc_hd__decap_3
XFILLER_16_153 VPWR VGND VPWR VGND sky130_fd_sc_hd__decap_3
XFILLER_31_134 VPWR VGND VPWR VGND sky130_fd_sc_hd__decap_3
XFILLER_12_381 VPWR VGND VPWR VGND sky130_fd_sc_hd__decap_3
XFILLER_31_178 VPWR VGND VPWR VGND sky130_fd_sc_hd__decap_3
XFILLER_8_363 VPWR VGND VPWR VGND sky130_fd_sc_hd__decap_3
XFILLER_8_396 VPWR VGND VPWR VGND sky130_fd_sc_hd__decap_3
XFILLER_39_234 VPWR VGND VPWR VGND sky130_fd_sc_hd__decap_3
XFILLER_39_267 VPWR VGND VPWR VGND sky130_fd_sc_hd__decap_3
XFILLER_54_215 VPWR VGND VPWR VGND sky130_fd_sc_hd__decap_3
XFILLER_54_248 VPWR VGND VPWR VGND sky130_fd_sc_hd__decap_3
XFILLER_54_259 VPWR VGND VPWR VGND sky130_fd_sc_hd__decap_3
XFILLER_62_292 VPWR VGND VPWR VGND sky130_fd_sc_hd__decap_3
XFILLER_22_112 VPWR VGND VPWR VGND sky130_fd_sc_hd__decap_3
XFILLER_22_156 VPWR VGND VPWR VGND sky130_fd_sc_hd__decap_3
XFILLER_22_189 VPWR VGND VPWR VGND sky130_fd_sc_hd__decap_3
XFILLER_45_237 VPWR VGND VPWR VGND sky130_fd_sc_hd__decap_3
XFILLER_60_218 VPWR VGND VPWR VGND sky130_fd_sc_hd__decap_3
XFILLER_26_75 VPWR VGND VPWR VGND sky130_fd_sc_hd__decap_3
XFILLER_26_97 VPWR VGND VPWR VGND sky130_fd_sc_hd__decap_3
XFILLER_53_270 VPWR VGND VPWR VGND sky130_fd_sc_hd__decap_3
XFILLER_53_281 VPWR VGND VPWR VGND sky130_fd_sc_hd__decap_3
XFILLER_13_134 VPWR VGND VPWR VGND sky130_fd_sc_hd__decap_3
XFILLER_9_105 VPWR VGND VPWR VGND sky130_fd_sc_hd__decap_3
XFILLER_9_116 VPWR VGND VPWR VGND sky130_fd_sc_hd__decap_3
XFILLER_9_149 VPWR VGND VPWR VGND sky130_fd_sc_hd__decap_3
X_293_ VGND VPWR VPWR VGND clknet_2_1__leaf_clk_regs net28 _038_ genblk1\[5\].fa_inst.b
+ _293_/a_1462_47# _293_/a_543_47# _293_/a_651_413# _293_/a_193_47# _293_/a_805_47#
+ _293_/a_448_47# _293_/a_639_47# _293_/a_1283_21# _293_/a_761_289# _293_/a_1108_47#
+ _293_/a_1217_47# _293_/a_1270_413# _293_/a_27_47# sky130_fd_sc_hd__dfrtp_1
XFILLER_42_41 VPWR VGND VPWR VGND sky130_fd_sc_hd__decap_3
XFILLER_42_74 VPWR VGND VPWR VGND sky130_fd_sc_hd__decap_3
XFILLER_42_85 VPWR VGND VPWR VGND sky130_fd_sc_hd__decap_3
XFILLER_5_355 VPWR VGND VPWR VGND sky130_fd_sc_hd__decap_3
XFILLER_5_388 VPWR VGND VPWR VGND sky130_fd_sc_hd__decap_3
XFILLER_47_9 VPWR VGND VPWR VGND sky130_fd_sc_hd__decap_3
XFILLER_36_215 VPWR VGND VPWR VGND sky130_fd_sc_hd__decap_3
XFILLER_36_248 VPWR VGND VPWR VGND sky130_fd_sc_hd__decap_3
XFILLER_36_259 VPWR VGND VPWR VGND sky130_fd_sc_hd__decap_3
XFILLER_44_292 VPWR VGND VPWR VGND sky130_fd_sc_hd__decap_3
XFILLER_8_171 VPWR VGND VPWR VGND sky130_fd_sc_hd__decap_3
XFILLER_59_329 VPWR VGND VPWR VGND sky130_fd_sc_hd__decap_3
XFILLER_27_237 VPWR VGND VPWR VGND sky130_fd_sc_hd__decap_3
XFILLER_42_218 VPWR VGND VPWR VGND sky130_fd_sc_hd__decap_3
XFILLER_35_270 VPWR VGND VPWR VGND sky130_fd_sc_hd__decap_3
XFILLER_35_281 VPWR VGND VPWR VGND sky130_fd_sc_hd__decap_3
XFILLER_10_115 VPWR VGND VPWR VGND sky130_fd_sc_hd__decap_3
XFILLER_50_262 VPWR VGND VPWR VGND sky130_fd_sc_hd__decap_3
XFILLER_50_295 VPWR VGND VPWR VGND sky130_fd_sc_hd__decap_3
XFILLER_10_159 VPWR VGND VPWR VGND sky130_fd_sc_hd__decap_3
XFILLER_12_44 VPWR VGND VPWR VGND sky130_fd_sc_hd__decap_3
XFILLER_12_88 VPWR VGND VPWR VGND sky130_fd_sc_hd__decap_3
XFILLER_12_77 VPWR VGND VPWR VGND sky130_fd_sc_hd__decap_3
XFILLER_2_369 VPWR VGND VPWR VGND sky130_fd_sc_hd__decap_3
XFILLER_58_351 VPWR VGND VPWR VGND sky130_fd_sc_hd__decap_3
XFILLER_58_395 VPWR VGND VPWR VGND sky130_fd_sc_hd__decap_3
XFILLER_37_74 VPWR VGND VPWR VGND sky130_fd_sc_hd__decap_3
XFILLER_26_292 VPWR VGND VPWR VGND sky130_fd_sc_hd__decap_3
XFILLER_53_40 VPWR VGND VPWR VGND sky130_fd_sc_hd__decap_3
XFILLER_41_240 VPWR VGND VPWR VGND sky130_fd_sc_hd__decap_3
XFILLER_53_84 VPWR VGND VPWR VGND sky130_fd_sc_hd__decap_3
XFILLER_41_273 VPWR VGND VPWR VGND sky130_fd_sc_hd__decap_3
XFILLER_41_284 VPWR VGND VPWR VGND sky130_fd_sc_hd__decap_3
X_276_ VGND VPWR VPWR VGND clknet_2_1__leaf_clk_regs net11 _021_ genblk1\[4\].fa_inst.a
+ _276_/a_1462_47# _276_/a_543_47# _276_/a_651_413# _276_/a_193_47# _276_/a_805_47#
+ _276_/a_448_47# _276_/a_639_47# _276_/a_1283_21# _276_/a_761_289# _276_/a_1108_47#
+ _276_/a_1217_47# _276_/a_1270_413# _276_/a_27_47# sky130_fd_sc_hd__dfrtp_1
XFILLER_5_152 VPWR VGND VPWR VGND sky130_fd_sc_hd__decap_3
XFILLER_45_6 VPWR VGND VPWR VGND sky130_fd_sc_hd__decap_3
XFILLER_49_340 VPWR VGND VPWR VGND sky130_fd_sc_hd__decap_3
XFILLER_1_391 VPWR VGND VPWR VGND sky130_fd_sc_hd__decap_3
XFILLER_49_373 VPWR VGND VPWR VGND sky130_fd_sc_hd__decap_3
XFILLER_64_343 VPWR VGND VPWR VGND sky130_fd_sc_hd__decap_3
XFILLER_64_332 VPWR VGND VPWR VGND sky130_fd_sc_hd__decap_3
XFILLER_64_365 VPWR VGND VPWR VGND sky130_fd_sc_hd__decap_3
XFILLER_24_218 VPWR VGND VPWR VGND sky130_fd_sc_hd__decap_3
XFILLER_32_262 VPWR VGND VPWR VGND sky130_fd_sc_hd__decap_3
XFILLER_20_402 VPWR VGND VPWR VGND sky130_fd_sc_hd__decap_3
XFILLER_32_295 VPWR VGND VPWR VGND sky130_fd_sc_hd__decap_3
XFILLER_58_18 VPWR VGND VPWR VGND sky130_fd_sc_hd__decap_3
XFILLER_59_126 VPWR VGND VPWR VGND sky130_fd_sc_hd__decap_3
XFILLER_59_159 VPWR VGND VPWR VGND sky130_fd_sc_hd__decap_3
XFILLER_55_343 VPWR VGND VPWR VGND sky130_fd_sc_hd__decap_3
XFILLER_55_332 VPWR VGND VPWR VGND sky130_fd_sc_hd__decap_3
XFILLER_55_376 VPWR VGND VPWR VGND sky130_fd_sc_hd__decap_3
XFILLER_23_240 VPWR VGND VPWR VGND sky130_fd_sc_hd__decap_3
XFILLER_23_273 VPWR VGND VPWR VGND sky130_fd_sc_hd__decap_3
X_130_ VGND VPWR VGND VPWR _053_ _050_ cin_q _051_ _130_/a_215_297# _130_/a_27_413#
+ _130_/a_298_297# _130_/a_382_47# sky130_fd_sc_hd__a21bo_1
XFILLER_23_284 VPWR VGND VPWR VGND sky130_fd_sc_hd__decap_3
XFILLER_2_100 VPWR VGND VPWR VGND sky130_fd_sc_hd__decap_3
XFILLER_2_144 VPWR VGND VPWR VGND sky130_fd_sc_hd__decap_3
XFILLER_2_133 VPWR VGND VPWR VGND sky130_fd_sc_hd__decap_3
XFILLER_58_192 VPWR VGND VPWR VGND sky130_fd_sc_hd__decap_3
XFILLER_46_321 VPWR VGND VPWR VGND sky130_fd_sc_hd__decap_3
XFILLER_61_302 VPWR VGND VPWR VGND sky130_fd_sc_hd__decap_3
XFILLER_46_365 VPWR VGND VPWR VGND sky130_fd_sc_hd__decap_3
XFILLER_46_354 VPWR VGND VPWR VGND sky130_fd_sc_hd__decap_3
XFILLER_0_69 VPWR VGND VPWR VGND sky130_fd_sc_hd__decap_3
XFILLER_0_47 VPWR VGND VPWR VGND sky130_fd_sc_hd__decap_3
XFILLER_64_72 VPWR VGND VPWR VGND sky130_fd_sc_hd__decap_3
XFILLER_64_50 VPWR VGND VPWR VGND sky130_fd_sc_hd__decap_3
XFILLER_46_398 VPWR VGND VPWR VGND sky130_fd_sc_hd__decap_3
XFILLER_61_346 VPWR VGND VPWR VGND sky130_fd_sc_hd__decap_3
XFILLER_64_94 VPWR VGND VPWR VGND sky130_fd_sc_hd__decap_3
XFILLER_61_379 VPWR VGND VPWR VGND sky130_fd_sc_hd__decap_3
XFILLER_9_34 VPWR VGND VPWR VGND sky130_fd_sc_hd__decap_3
XFILLER_9_78 VPWR VGND VPWR VGND sky130_fd_sc_hd__decap_3
X_259_ VGND VPWR VPWR VGND clknet_2_0__leaf_clk_regs genblk1\[4\].fa_inst.s _004_
+ net49 _259_/a_1462_47# _259_/a_543_47# _259_/a_651_413# _259_/a_193_47# _259_/a_805_47#
+ _259_/a_448_47# _259_/a_639_47# _259_/a_1283_21# _259_/a_761_289# _259_/a_1108_47#
+ _259_/a_1217_47# _259_/a_1270_413# _259_/a_27_47# sky130_fd_sc_hd__dfrtp_1
XFILLER_43_3 VPWR VGND VPWR VGND sky130_fd_sc_hd__decap_3
XFILLER_56_118 VPWR VGND VPWR VGND sky130_fd_sc_hd__decap_3
XFILLER_37_332 VPWR VGND VPWR VGND sky130_fd_sc_hd__decap_3
XFILLER_49_181 VPWR VGND VPWR VGND sky130_fd_sc_hd__decap_3
XFILLER_37_343 VPWR VGND VPWR VGND sky130_fd_sc_hd__decap_3
XFILLER_37_376 VPWR VGND VPWR VGND sky130_fd_sc_hd__decap_3
XFILLER_64_184 VPWR VGND VPWR VGND sky130_fd_sc_hd__decap_3
XFILLER_64_162 VPWR VGND VPWR VGND sky130_fd_sc_hd__decap_3
XFILLER_52_324 VPWR VGND VPWR VGND sky130_fd_sc_hd__decap_3
XFILLER_52_368 VPWR VGND VPWR VGND sky130_fd_sc_hd__decap_3
XFILLER_52_357 VPWR VGND VPWR VGND sky130_fd_sc_hd__decap_3
XFILLER_18_21 VPWR VGND VPWR VGND sky130_fd_sc_hd__decap_3
XFILLER_18_32 VPWR VGND VPWR VGND sky130_fd_sc_hd__decap_3
XFILLER_28_321 VPWR VGND VPWR VGND sky130_fd_sc_hd__decap_3
XFILLER_28_354 VPWR VGND VPWR VGND sky130_fd_sc_hd__decap_3
XFILLER_28_365 VPWR VGND VPWR VGND sky130_fd_sc_hd__decap_3
XFILLER_55_140 VPWR VGND VPWR VGND sky130_fd_sc_hd__decap_3
XFILLER_43_302 VPWR VGND VPWR VGND sky130_fd_sc_hd__decap_3
XFILLER_28_398 VPWR VGND VPWR VGND sky130_fd_sc_hd__decap_3
XFILLER_55_184 VPWR VGND VPWR VGND sky130_fd_sc_hd__decap_3
XFILLER_43_346 VPWR VGND VPWR VGND sky130_fd_sc_hd__decap_3
XFILLER_43_379 VPWR VGND VPWR VGND sky130_fd_sc_hd__decap_3
XFILLER_34_53 VPWR VGND VPWR VGND sky130_fd_sc_hd__decap_3
XFILLER_34_97 VPWR VGND VPWR VGND sky130_fd_sc_hd__decap_3
XFILLER_50_41 VPWR VGND VPWR VGND sky130_fd_sc_hd__decap_3
XFILLER_50_74 VPWR VGND VPWR VGND sky130_fd_sc_hd__decap_3
XFILLER_50_85 VPWR VGND VPWR VGND sky130_fd_sc_hd__decap_3
XFILLER_59_72 VPWR VGND VPWR VGND sky130_fd_sc_hd__decap_3
XFILLER_38_118 VPWR VGND VPWR VGND sky130_fd_sc_hd__decap_3
XFILLER_19_343 VPWR VGND VPWR VGND sky130_fd_sc_hd__decap_3
XFILLER_19_376 VPWR VGND VPWR VGND sky130_fd_sc_hd__decap_3
XFILLER_34_324 VPWR VGND VPWR VGND sky130_fd_sc_hd__decap_3
XFILLER_46_162 VPWR VGND VPWR VGND sky130_fd_sc_hd__decap_3
XFILLER_61_143 VPWR VGND VPWR VGND sky130_fd_sc_hd__decap_3
XFILLER_34_357 VPWR VGND VPWR VGND sky130_fd_sc_hd__decap_3
XFILLER_34_368 VPWR VGND VPWR VGND sky130_fd_sc_hd__decap_3
XFILLER_61_187 VPWR VGND VPWR VGND sky130_fd_sc_hd__decap_3
XPHY_EDGE_ROW_7_1_Right_6 VPWR VGND VPWR VGND sky130_fd_sc_hd__decap_3
XFILLER_37_140 VPWR VGND VPWR VGND sky130_fd_sc_hd__decap_3
XFILLER_1_90 VPWR VGND VPWR VGND sky130_fd_sc_hd__decap_3
XFILLER_37_184 VPWR VGND VPWR VGND sky130_fd_sc_hd__decap_3
XFILLER_25_302 VPWR VGND VPWR VGND sky130_fd_sc_hd__decap_3
XFILLER_25_346 VPWR VGND VPWR VGND sky130_fd_sc_hd__decap_3
XFILLER_25_379 VPWR VGND VPWR VGND sky130_fd_sc_hd__decap_3
XFILLER_52_165 VPWR VGND VPWR VGND sky130_fd_sc_hd__decap_3
XFILLER_40_327 VPWR VGND VPWR VGND sky130_fd_sc_hd__decap_3
XFILLER_20_44 VPWR VGND VPWR VGND sky130_fd_sc_hd__decap_3
XFILLER_20_88 VPWR VGND VPWR VGND sky130_fd_sc_hd__decap_3
XFILLER_29_42 VPWR VGND VPWR VGND sky130_fd_sc_hd__decap_3
XFILLER_29_75 VPWR VGND VPWR VGND sky130_fd_sc_hd__decap_3
XFILLER_28_162 VPWR VGND VPWR VGND sky130_fd_sc_hd__decap_3
XFILLER_16_357 VPWR VGND VPWR VGND sky130_fd_sc_hd__decap_3
XFILLER_16_346 VPWR VGND VPWR VGND sky130_fd_sc_hd__decap_3
XFILLER_45_41 VPWR VGND VPWR VGND sky130_fd_sc_hd__decap_3
XFILLER_43_143 VPWR VGND VPWR VGND sky130_fd_sc_hd__decap_3
XFILLER_31_305 VPWR VGND VPWR VGND sky130_fd_sc_hd__decap_3
XFILLER_45_85 VPWR VGND VPWR VGND sky130_fd_sc_hd__decap_3
XFILLER_31_349 VPWR VGND VPWR VGND sky130_fd_sc_hd__decap_3
XFILLER_43_187 VPWR VGND VPWR VGND sky130_fd_sc_hd__decap_3
XFILLER_61_51 VPWR VGND VPWR VGND sky130_fd_sc_hd__decap_3
XFILLER_61_84 VPWR VGND VPWR VGND sky130_fd_sc_hd__decap_3
XFILLER_6_24 VPWR VGND VPWR VGND sky130_fd_sc_hd__decap_3
XFILLER_6_35 VPWR VGND VPWR VGND sky130_fd_sc_hd__decap_3
XFILLER_19_140 VPWR VGND VPWR VGND sky130_fd_sc_hd__decap_3
XFILLER_34_121 VPWR VGND VPWR VGND sky130_fd_sc_hd__decap_3
XFILLER_34_165 VPWR VGND VPWR VGND sky130_fd_sc_hd__decap_3
XFILLER_22_327 VPWR VGND VPWR VGND sky130_fd_sc_hd__decap_3
XFILLER_30_360 VPWR VGND VPWR VGND sky130_fd_sc_hd__decap_3
XFILLER_30_371 VPWR VGND VPWR VGND sky130_fd_sc_hd__decap_3
XFILLER_57_202 VPWR VGND VPWR VGND sky130_fd_sc_hd__decap_3
XFILLER_57_246 VPWR VGND VPWR VGND sky130_fd_sc_hd__decap_3
XFILLER_25_143 VPWR VGND VPWR VGND sky130_fd_sc_hd__decap_3
XFILLER_13_349 VPWR VGND VPWR VGND sky130_fd_sc_hd__decap_3
XFILLER_15_66 VPWR VGND VPWR VGND sky130_fd_sc_hd__decap_3
XFILLER_25_187 VPWR VGND VPWR VGND sky130_fd_sc_hd__decap_3
XFILLER_40_124 VPWR VGND VPWR VGND sky130_fd_sc_hd__decap_3
XFILLER_15_99 VPWR VGND VPWR VGND sky130_fd_sc_hd__decap_3
XFILLER_40_168 VPWR VGND VPWR VGND sky130_fd_sc_hd__decap_3
XFILLER_21_371 VPWR VGND VPWR VGND sky130_fd_sc_hd__decap_3
XFILLER_21_393 VPWR VGND VPWR VGND sky130_fd_sc_hd__decap_3
XFILLER_31_87 VPWR VGND VPWR VGND sky130_fd_sc_hd__decap_3
Xoutput43 VPWR VGND s[13] net43 VPWR VGND output43/a_27_47# sky130_fd_sc_hd__buf_2
Xoutput54 VPWR VGND s[9] net54 VPWR VGND output54/a_27_47# sky130_fd_sc_hd__buf_2
XFILLER_48_224 VPWR VGND VPWR VGND sky130_fd_sc_hd__decap_3
XFILLER_48_268 VPWR VGND VPWR VGND sky130_fd_sc_hd__decap_3
XFILLER_63_205 VPWR VGND VPWR VGND sky130_fd_sc_hd__decap_3
XFILLER_56_62 VPWR VGND VPWR VGND sky130_fd_sc_hd__decap_3
XFILLER_63_249 VPWR VGND VPWR VGND sky130_fd_sc_hd__decap_3
XFILLER_16_165 VPWR VGND VPWR VGND sky130_fd_sc_hd__decap_3
XFILLER_31_102 VPWR VGND VPWR VGND sky130_fd_sc_hd__decap_3
XFILLER_31_113 VPWR VGND VPWR VGND sky130_fd_sc_hd__decap_3
XFILLER_31_146 VPWR VGND VPWR VGND sky130_fd_sc_hd__decap_3
XFILLER_12_360 VPWR VGND VPWR VGND sky130_fd_sc_hd__decap_3
XFILLER_12_393 VPWR VGND VPWR VGND sky130_fd_sc_hd__decap_3
XFILLER_8_331 VPWR VGND VPWR VGND sky130_fd_sc_hd__decap_3
XFILLER_8_375 VPWR VGND VPWR VGND sky130_fd_sc_hd__decap_3
XFILLER_39_202 VPWR VGND VPWR VGND sky130_fd_sc_hd__decap_3
XFILLER_39_246 VPWR VGND VPWR VGND sky130_fd_sc_hd__decap_3
XFILLER_54_227 VPWR VGND VPWR VGND sky130_fd_sc_hd__decap_3
XFILLER_47_290 VPWR VGND VPWR VGND sky130_fd_sc_hd__decap_3
XFILLER_62_271 VPWR VGND VPWR VGND sky130_fd_sc_hd__decap_3
XFILLER_22_124 VPWR VGND VPWR VGND sky130_fd_sc_hd__decap_3
XFILLER_22_168 VPWR VGND VPWR VGND sky130_fd_sc_hd__decap_3
XFILLER_7_9 VPWR VGND VPWR VGND sky130_fd_sc_hd__decap_3
XFILLER_45_205 VPWR VGND VPWR VGND sky130_fd_sc_hd__decap_3
XFILLER_26_21 VPWR VGND VPWR VGND sky130_fd_sc_hd__decap_3
XFILLER_26_32 VPWR VGND VPWR VGND sky130_fd_sc_hd__decap_3
XFILLER_45_249 VPWR VGND VPWR VGND sky130_fd_sc_hd__decap_3
XFILLER_53_293 VPWR VGND VPWR VGND sky130_fd_sc_hd__decap_3
XFILLER_13_113 VPWR VGND VPWR VGND sky130_fd_sc_hd__decap_3
XFILLER_13_146 VPWR VGND VPWR VGND sky130_fd_sc_hd__decap_3
XFILLER_9_128 VPWR VGND VPWR VGND sky130_fd_sc_hd__decap_3
X_292_ VGND VPWR VPWR VGND clknet_2_0__leaf_clk_regs net27 _037_ genblk1\[4\].fa_inst.b
+ _292_/a_1462_47# _292_/a_543_47# _292_/a_651_413# _292_/a_193_47# _292_/a_805_47#
+ _292_/a_448_47# _292_/a_639_47# _292_/a_1283_21# _292_/a_761_289# _292_/a_1108_47#
+ _292_/a_1217_47# _292_/a_1270_413# _292_/a_27_47# sky130_fd_sc_hd__dfrtp_1
XFILLER_42_53 VPWR VGND VPWR VGND sky130_fd_sc_hd__decap_3
XFILLER_21_190 VPWR VGND VPWR VGND sky130_fd_sc_hd__decap_3
XFILLER_5_334 VPWR VGND VPWR VGND sky130_fd_sc_hd__decap_3
XPHY_EDGE_ROW_39_Left_145 VPWR VGND VPWR VGND sky130_fd_sc_hd__decap_3
XFILLER_5_367 VPWR VGND VPWR VGND sky130_fd_sc_hd__decap_3
XPHY_EDGE_ROW_1_1_Left_107 VPWR VGND VPWR VGND sky130_fd_sc_hd__decap_3
XFILLER_3_69 VPWR VGND VPWR VGND sky130_fd_sc_hd__decap_3
XFILLER_29_290 VPWR VGND VPWR VGND sky130_fd_sc_hd__decap_3
XFILLER_36_227 VPWR VGND VPWR VGND sky130_fd_sc_hd__decap_3
XPHY_EDGE_ROW_48_Left_154 VPWR VGND VPWR VGND sky130_fd_sc_hd__decap_3
XFILLER_51_208 VPWR VGND VPWR VGND sky130_fd_sc_hd__decap_3
XFILLER_44_271 VPWR VGND VPWR VGND sky130_fd_sc_hd__decap_3
XFILLER_8_150 VPWR VGND VPWR VGND sky130_fd_sc_hd__decap_3
XPHY_EDGE_ROW_57_Left_163 VPWR VGND VPWR VGND sky130_fd_sc_hd__decap_3
XFILLER_59_308 VPWR VGND VPWR VGND sky130_fd_sc_hd__decap_3
XFILLER_27_205 VPWR VGND VPWR VGND sky130_fd_sc_hd__decap_3
XFILLER_27_249 VPWR VGND VPWR VGND sky130_fd_sc_hd__decap_3
XFILLER_63_19 VPWR VGND VPWR VGND sky130_fd_sc_hd__decap_3
XFILLER_35_293 VPWR VGND VPWR VGND sky130_fd_sc_hd__decap_3
XFILLER_50_230 VPWR VGND VPWR VGND sky130_fd_sc_hd__decap_3
XFILLER_50_274 VPWR VGND VPWR VGND sky130_fd_sc_hd__decap_3
XFILLER_10_127 VPWR VGND VPWR VGND sky130_fd_sc_hd__decap_3
XFILLER_6_109 VPWR VGND VPWR VGND sky130_fd_sc_hd__decap_3
XFILLER_12_56 VPWR VGND VPWR VGND sky130_fd_sc_hd__decap_3
XFILLER_2_337 VPWR VGND VPWR VGND sky130_fd_sc_hd__decap_3
XFILLER_5_6 VPWR VGND VPWR VGND sky130_fd_sc_hd__decap_3
XFILLER_58_330 VPWR VGND VPWR VGND sky130_fd_sc_hd__decap_3
XFILLER_58_374 VPWR VGND VPWR VGND sky130_fd_sc_hd__decap_3
XFILLER_37_86 VPWR VGND VPWR VGND sky130_fd_sc_hd__decap_3
XFILLER_33_208 VPWR VGND VPWR VGND sky130_fd_sc_hd__decap_3
XFILLER_26_271 VPWR VGND VPWR VGND sky130_fd_sc_hd__decap_3
XFILLER_53_52 VPWR VGND VPWR VGND sky130_fd_sc_hd__decap_3
XFILLER_53_63 VPWR VGND VPWR VGND sky130_fd_sc_hd__decap_3
XFILLER_53_96 VPWR VGND VPWR VGND sky130_fd_sc_hd__decap_3
XFILLER_41_252 VPWR VGND VPWR VGND sky130_fd_sc_hd__decap_3
XFILLER_41_296 VPWR VGND VPWR VGND sky130_fd_sc_hd__decap_3
X_275_ VGND VPWR VPWR VGND clknet_2_1__leaf_clk_regs net10 _020_ genblk1\[3\].fa_inst.a
+ _275_/a_1462_47# _275_/a_543_47# _275_/a_651_413# _275_/a_193_47# _275_/a_805_47#
+ _275_/a_448_47# _275_/a_639_47# _275_/a_1283_21# _275_/a_761_289# _275_/a_1108_47#
+ _275_/a_1217_47# _275_/a_1270_413# _275_/a_27_47# sky130_fd_sc_hd__dfrtp_1
XFILLER_5_131 VPWR VGND VPWR VGND sky130_fd_sc_hd__decap_3
XFILLER_5_164 VPWR VGND VPWR VGND sky130_fd_sc_hd__decap_3
XFILLER_1_370 VPWR VGND VPWR VGND sky130_fd_sc_hd__decap_3
XFILLER_38_6 VPWR VGND VPWR VGND sky130_fd_sc_hd__decap_3
XFILLER_49_352 VPWR VGND VPWR VGND sky130_fd_sc_hd__decap_3
XFILLER_49_396 VPWR VGND VPWR VGND sky130_fd_sc_hd__decap_3
XFILLER_49_385 VPWR VGND VPWR VGND sky130_fd_sc_hd__decap_3
XFILLER_64_377 VPWR VGND VPWR VGND sky130_fd_sc_hd__decap_3
XFILLER_64_355 VPWR VGND VPWR VGND sky130_fd_sc_hd__decap_3
XFILLER_64_399 VPWR VGND VPWR VGND sky130_fd_sc_hd__decap_3
XFILLER_32_230 VPWR VGND VPWR VGND sky130_fd_sc_hd__decap_3
XFILLER_32_274 VPWR VGND VPWR VGND sky130_fd_sc_hd__decap_3
XFILLER_59_105 VPWR VGND VPWR VGND sky130_fd_sc_hd__decap_3
XFILLER_59_138 VPWR VGND VPWR VGND sky130_fd_sc_hd__decap_3
XFILLER_55_311 VPWR VGND VPWR VGND sky130_fd_sc_hd__decap_3
XFILLER_55_355 VPWR VGND VPWR VGND sky130_fd_sc_hd__decap_3
XFILLER_55_399 VPWR VGND VPWR VGND sky130_fd_sc_hd__decap_3
XFILLER_55_388 VPWR VGND VPWR VGND sky130_fd_sc_hd__decap_3
XFILLER_11_403 VPWR VGND VPWR VGND sky130_fd_sc_hd__decap_3
XFILLER_23_252 VPWR VGND VPWR VGND sky130_fd_sc_hd__decap_3
XFILLER_23_296 VPWR VGND VPWR VGND sky130_fd_sc_hd__decap_3
XFILLER_23_66 VPWR VGND VPWR VGND sky130_fd_sc_hd__decap_3
XFILLER_23_99 VPWR VGND VPWR VGND sky130_fd_sc_hd__decap_3
XFILLER_2_112 VPWR VGND VPWR VGND sky130_fd_sc_hd__decap_3
XFILLER_2_156 VPWR VGND VPWR VGND sky130_fd_sc_hd__decap_3
XFILLER_3_3 VPWR VGND VPWR VGND sky130_fd_sc_hd__decap_3
XFILLER_48_85 VPWR VGND VPWR VGND sky130_fd_sc_hd__decap_3
XFILLER_58_171 VPWR VGND VPWR VGND sky130_fd_sc_hd__decap_3
XFILLER_46_333 VPWR VGND VPWR VGND sky130_fd_sc_hd__decap_3
XFILLER_0_15 VPWR VGND VPWR VGND sky130_fd_sc_hd__decap_3
XFILLER_61_314 VPWR VGND VPWR VGND sky130_fd_sc_hd__decap_3
XFILLER_46_377 VPWR VGND VPWR VGND sky130_fd_sc_hd__decap_3
XFILLER_61_358 VPWR VGND VPWR VGND sky130_fd_sc_hd__decap_3
XFILLER_9_57 VPWR VGND VPWR VGND sky130_fd_sc_hd__decap_3
XFILLER_9_46 VPWR VGND VPWR VGND sky130_fd_sc_hd__decap_3
X_258_ VGND VPWR VPWR VGND clknet_2_0__leaf_clk_regs genblk1\[3\].fa_inst.s _003_
+ net48 _258_/a_1462_47# _258_/a_543_47# _258_/a_651_413# _258_/a_193_47# _258_/a_805_47#
+ _258_/a_448_47# _258_/a_639_47# _258_/a_1283_21# _258_/a_761_289# _258_/a_1108_47#
+ _258_/a_1217_47# _258_/a_1270_413# _258_/a_27_47# sky130_fd_sc_hd__dfrtp_1
X_189_ VGND VPWR _100_ genblk1\[12\].fa_inst.s _099_ VPWR VGND _189_/a_129_47# _189_/a_47_47#
+ _189_/a_285_47# _189_/a_377_297# sky130_fd_sc_hd__xnor2_1
XFILLER_37_311 VPWR VGND VPWR VGND sky130_fd_sc_hd__decap_3
XFILLER_49_193 VPWR VGND VPWR VGND sky130_fd_sc_hd__decap_3
XFILLER_64_141 VPWR VGND VPWR VGND sky130_fd_sc_hd__decap_3
XFILLER_37_355 VPWR VGND VPWR VGND sky130_fd_sc_hd__decap_3
XFILLER_37_388 VPWR VGND VPWR VGND sky130_fd_sc_hd__decap_3
XFILLER_37_399 VPWR VGND VPWR VGND sky130_fd_sc_hd__decap_3
XFILLER_52_336 VPWR VGND VPWR VGND sky130_fd_sc_hd__decap_3
XFILLER_60_380 VPWR VGND VPWR VGND sky130_fd_sc_hd__decap_3
XFILLER_47_108 VPWR VGND VPWR VGND sky130_fd_sc_hd__decap_3
XFILLER_47_119 VPWR VGND VPWR VGND sky130_fd_sc_hd__decap_3
XFILLER_18_44 VPWR VGND VPWR VGND sky130_fd_sc_hd__decap_3
XFILLER_28_333 VPWR VGND VPWR VGND sky130_fd_sc_hd__decap_3
XFILLER_18_77 VPWR VGND VPWR VGND sky130_fd_sc_hd__decap_3
XFILLER_55_152 VPWR VGND VPWR VGND sky130_fd_sc_hd__decap_3
XFILLER_43_314 VPWR VGND VPWR VGND sky130_fd_sc_hd__decap_3
XFILLER_18_88 VPWR VGND VPWR VGND sky130_fd_sc_hd__decap_3
XFILLER_28_377 VPWR VGND VPWR VGND sky130_fd_sc_hd__decap_3
XFILLER_43_358 VPWR VGND VPWR VGND sky130_fd_sc_hd__decap_3
XFILLER_34_21 VPWR VGND VPWR VGND sky130_fd_sc_hd__decap_3
XFILLER_55_196 VPWR VGND VPWR VGND sky130_fd_sc_hd__decap_3
XFILLER_34_32 VPWR VGND VPWR VGND sky130_fd_sc_hd__decap_3
XFILLER_34_65 VPWR VGND VPWR VGND sky130_fd_sc_hd__decap_3
XFILLER_50_53 VPWR VGND VPWR VGND sky130_fd_sc_hd__decap_3
XFILLER_50_97 VPWR VGND VPWR VGND sky130_fd_sc_hd__decap_3
XFILLER_59_51 VPWR VGND VPWR VGND sky130_fd_sc_hd__decap_3
XFILLER_59_84 VPWR VGND VPWR VGND sky130_fd_sc_hd__decap_3
XFILLER_22_9 VPWR VGND VPWR VGND sky130_fd_sc_hd__decap_3
XFILLER_19_355 VPWR VGND VPWR VGND sky130_fd_sc_hd__decap_3
XFILLER_46_130 VPWR VGND VPWR VGND sky130_fd_sc_hd__decap_3
XFILLER_46_141 VPWR VGND VPWR VGND sky130_fd_sc_hd__decap_3
XFILLER_19_388 VPWR VGND VPWR VGND sky130_fd_sc_hd__decap_3
XFILLER_46_174 VPWR VGND VPWR VGND sky130_fd_sc_hd__decap_3
XFILLER_61_122 VPWR VGND VPWR VGND sky130_fd_sc_hd__decap_3
XFILLER_34_336 VPWR VGND VPWR VGND sky130_fd_sc_hd__decap_3
XFILLER_61_155 VPWR VGND VPWR VGND sky130_fd_sc_hd__decap_3
XFILLER_61_199 VPWR VGND VPWR VGND sky130_fd_sc_hd__decap_3
XFILLER_42_380 VPWR VGND VPWR VGND sky130_fd_sc_hd__decap_3
XFILLER_29_119 VPWR VGND VPWR VGND sky130_fd_sc_hd__decap_3
XFILLER_37_152 VPWR VGND VPWR VGND sky130_fd_sc_hd__decap_3
XFILLER_25_314 VPWR VGND VPWR VGND sky130_fd_sc_hd__decap_3
XFILLER_37_196 VPWR VGND VPWR VGND sky130_fd_sc_hd__decap_3
XFILLER_25_358 VPWR VGND VPWR VGND sky130_fd_sc_hd__decap_3
XFILLER_52_122 VPWR VGND VPWR VGND sky130_fd_sc_hd__decap_3
XFILLER_52_144 VPWR VGND VPWR VGND sky130_fd_sc_hd__decap_3
XFILLER_52_177 VPWR VGND VPWR VGND sky130_fd_sc_hd__decap_3
XFILLER_40_339 VPWR VGND VPWR VGND sky130_fd_sc_hd__decap_3
XFILLER_20_12 VPWR VGND VPWR VGND sky130_fd_sc_hd__decap_3
XFILLER_20_56 VPWR VGND VPWR VGND sky130_fd_sc_hd__decap_3
XFILLER_29_87 VPWR VGND VPWR VGND sky130_fd_sc_hd__decap_3
XFILLER_28_174 VPWR VGND VPWR VGND sky130_fd_sc_hd__decap_3
XFILLER_43_122 VPWR VGND VPWR VGND sky130_fd_sc_hd__decap_3
XFILLER_16_369 VPWR VGND VPWR VGND sky130_fd_sc_hd__decap_3
XFILLER_31_317 VPWR VGND VPWR VGND sky130_fd_sc_hd__decap_3
XFILLER_45_97 VPWR VGND VPWR VGND sky130_fd_sc_hd__decap_3
XFILLER_43_155 VPWR VGND VPWR VGND sky130_fd_sc_hd__decap_3
XFILLER_24_380 VPWR VGND VPWR VGND sky130_fd_sc_hd__decap_3
XFILLER_43_199 VPWR VGND VPWR VGND sky130_fd_sc_hd__decap_3
XFILLER_61_30 VPWR VGND VPWR VGND sky130_fd_sc_hd__decap_3
XFILLER_61_63 VPWR VGND VPWR VGND sky130_fd_sc_hd__decap_3
XFILLER_61_96 VPWR VGND VPWR VGND sky130_fd_sc_hd__decap_3
XFILLER_6_47 VPWR VGND VPWR VGND sky130_fd_sc_hd__decap_3
XFILLER_20_6 VPWR VGND VPWR VGND sky130_fd_sc_hd__decap_3
XFILLER_19_152 VPWR VGND VPWR VGND sky130_fd_sc_hd__decap_3
XFILLER_34_100 VPWR VGND VPWR VGND sky130_fd_sc_hd__decap_3
XFILLER_34_133 VPWR VGND VPWR VGND sky130_fd_sc_hd__decap_3
XFILLER_34_144 VPWR VGND VPWR VGND sky130_fd_sc_hd__decap_3
XFILLER_34_177 VPWR VGND VPWR VGND sky130_fd_sc_hd__decap_3
XFILLER_22_339 VPWR VGND VPWR VGND sky130_fd_sc_hd__decap_3
XFILLER_15_391 VPWR VGND VPWR VGND sky130_fd_sc_hd__decap_3
XFILLER_30_383 VPWR VGND VPWR VGND sky130_fd_sc_hd__decap_3
XFILLER_57_225 VPWR VGND VPWR VGND sky130_fd_sc_hd__decap_3
XFILLER_57_214 VPWR VGND VPWR VGND sky130_fd_sc_hd__decap_3
XFILLER_57_258 VPWR VGND VPWR VGND sky130_fd_sc_hd__decap_3
XFILLER_25_100 VPWR VGND VPWR VGND sky130_fd_sc_hd__decap_3
XFILLER_25_122 VPWR VGND VPWR VGND sky130_fd_sc_hd__decap_3
XFILLER_25_155 VPWR VGND VPWR VGND sky130_fd_sc_hd__decap_3
XFILLER_13_328 VPWR VGND VPWR VGND sky130_fd_sc_hd__decap_3
XFILLER_25_199 VPWR VGND VPWR VGND sky130_fd_sc_hd__decap_3
XFILLER_15_78 VPWR VGND VPWR VGND sky130_fd_sc_hd__decap_3
XFILLER_40_136 VPWR VGND VPWR VGND sky130_fd_sc_hd__decap_3
XFILLER_40_147 VPWR VGND VPWR VGND sky130_fd_sc_hd__decap_3
XFILLER_21_361 VPWR VGND VPWR VGND sky130_fd_sc_hd__decap_3
XFILLER_31_44 VPWR VGND VPWR VGND sky130_fd_sc_hd__decap_3
XFILLER_21_383 VPWR VGND VPWR VGND sky130_fd_sc_hd__decap_3
XFILLER_31_66 VPWR VGND VPWR VGND sky130_fd_sc_hd__decap_3
XFILLER_31_99 VPWR VGND VPWR VGND sky130_fd_sc_hd__decap_3
Xoutput44 VPWR VGND s[14] net44 VPWR VGND output44/a_27_47# sky130_fd_sc_hd__buf_2
Xoutput55 VPWR VGND tdo net55 VPWR VGND output55/a_27_47# sky130_fd_sc_hd__buf_2
XFILLER_48_203 VPWR VGND VPWR VGND sky130_fd_sc_hd__decap_3
XFILLER_56_41 VPWR VGND VPWR VGND sky130_fd_sc_hd__decap_3
XFILLER_48_236 VPWR VGND VPWR VGND sky130_fd_sc_hd__decap_3
XFILLER_63_228 VPWR VGND VPWR VGND sky130_fd_sc_hd__decap_3
XFILLER_63_217 VPWR VGND VPWR VGND sky130_fd_sc_hd__decap_3
XFILLER_56_280 VPWR VGND VPWR VGND sky130_fd_sc_hd__decap_3
XFILLER_16_122 VPWR VGND VPWR VGND sky130_fd_sc_hd__decap_3
XFILLER_56_85 VPWR VGND VPWR VGND sky130_fd_sc_hd__decap_3
XFILLER_16_144 VPWR VGND VPWR VGND sky130_fd_sc_hd__decap_3
XFILLER_16_177 VPWR VGND VPWR VGND sky130_fd_sc_hd__decap_3
XFILLER_31_125 VPWR VGND VPWR VGND sky130_fd_sc_hd__decap_3
XFILLER_31_158 VPWR VGND VPWR VGND sky130_fd_sc_hd__decap_3
XFILLER_12_372 VPWR VGND VPWR VGND sky130_fd_sc_hd__decap_3
XFILLER_31_169 VPWR VGND VPWR VGND sky130_fd_sc_hd__decap_3
XFILLER_8_354 VPWR VGND VPWR VGND sky130_fd_sc_hd__decap_3
XFILLER_8_343 VPWR VGND VPWR VGND sky130_fd_sc_hd__decap_3
XFILLER_8_387 VPWR VGND VPWR VGND sky130_fd_sc_hd__decap_3
XFILLER_39_214 VPWR VGND VPWR VGND sky130_fd_sc_hd__decap_3
XFILLER_39_225 VPWR VGND VPWR VGND sky130_fd_sc_hd__decap_3
XFILLER_39_258 VPWR VGND VPWR VGND sky130_fd_sc_hd__decap_3
XFILLER_54_206 VPWR VGND VPWR VGND sky130_fd_sc_hd__decap_3
XFILLER_54_239 VPWR VGND VPWR VGND sky130_fd_sc_hd__decap_3
XFILLER_62_283 VPWR VGND VPWR VGND sky130_fd_sc_hd__decap_3
XFILLER_50_401 VPWR VGND VPWR VGND sky130_fd_sc_hd__decap_3
XFILLER_22_103 VPWR VGND VPWR VGND sky130_fd_sc_hd__decap_3
XFILLER_22_136 VPWR VGND VPWR VGND sky130_fd_sc_hd__decap_3
XFILLER_22_147 VPWR VGND VPWR VGND sky130_fd_sc_hd__decap_3
XFILLER_30_180 VPWR VGND VPWR VGND sky130_fd_sc_hd__decap_3
XFILLER_45_217 VPWR VGND VPWR VGND sky130_fd_sc_hd__decap_3
XFILLER_38_280 VPWR VGND VPWR VGND sky130_fd_sc_hd__decap_3
XFILLER_45_228 VPWR VGND VPWR VGND sky130_fd_sc_hd__decap_3
XFILLER_60_209 VPWR VGND VPWR VGND sky130_fd_sc_hd__decap_3
XFILLER_26_44 VPWR VGND VPWR VGND sky130_fd_sc_hd__decap_3
XFILLER_26_88 VPWR VGND VPWR VGND sky130_fd_sc_hd__decap_3
XFILLER_53_261 VPWR VGND VPWR VGND sky130_fd_sc_hd__decap_3
XFILLER_13_158 VPWR VGND VPWR VGND sky130_fd_sc_hd__decap_3
XFILLER_13_125 VPWR VGND VPWR VGND sky130_fd_sc_hd__decap_3
XFILLER_13_169 VPWR VGND VPWR VGND sky130_fd_sc_hd__decap_3
X_291_ VGND VPWR VPWR VGND clknet_2_1__leaf_clk_regs net26 _036_ genblk1\[3\].fa_inst.b
+ _291_/a_1462_47# _291_/a_543_47# _291_/a_651_413# _291_/a_193_47# _291_/a_805_47#
+ _291_/a_448_47# _291_/a_639_47# _291_/a_1283_21# _291_/a_761_289# _291_/a_1108_47#
+ _291_/a_1217_47# _291_/a_1270_413# _291_/a_27_47# sky130_fd_sc_hd__dfrtp_1
XFILLER_42_21 VPWR VGND VPWR VGND sky130_fd_sc_hd__decap_3
XFILLER_42_32 VPWR VGND VPWR VGND sky130_fd_sc_hd__decap_3
XFILLER_42_65 VPWR VGND VPWR VGND sky130_fd_sc_hd__decap_3
XFILLER_5_346 VPWR VGND VPWR VGND sky130_fd_sc_hd__decap_3
XFILLER_36_206 VPWR VGND VPWR VGND sky130_fd_sc_hd__decap_3
XFILLER_36_239 VPWR VGND VPWR VGND sky130_fd_sc_hd__decap_3
XFILLER_32_401 VPWR VGND VPWR VGND sky130_fd_sc_hd__decap_3
XFILLER_44_283 VPWR VGND VPWR VGND sky130_fd_sc_hd__decap_3
XFILLER_8_162 VPWR VGND VPWR VGND sky130_fd_sc_hd__decap_3
XFILLER_4_390 VPWR VGND VPWR VGND sky130_fd_sc_hd__decap_3
XFILLER_27_217 VPWR VGND VPWR VGND sky130_fd_sc_hd__decap_3
XFILLER_27_228 VPWR VGND VPWR VGND sky130_fd_sc_hd__decap_3
XFILLER_42_209 VPWR VGND VPWR VGND sky130_fd_sc_hd__decap_3
XFILLER_35_261 VPWR VGND VPWR VGND sky130_fd_sc_hd__decap_3
XFILLER_50_242 VPWR VGND VPWR VGND sky130_fd_sc_hd__decap_3
XFILLER_10_106 VPWR VGND VPWR VGND sky130_fd_sc_hd__decap_3
XFILLER_50_253 VPWR VGND VPWR VGND sky130_fd_sc_hd__decap_3
XFILLER_50_286 VPWR VGND VPWR VGND sky130_fd_sc_hd__decap_3
XFILLER_12_35 VPWR VGND VPWR VGND sky130_fd_sc_hd__decap_3
XFILLER_12_68 VPWR VGND VPWR VGND sky130_fd_sc_hd__decap_3
XFILLER_2_349 VPWR VGND VPWR VGND sky130_fd_sc_hd__decap_3
XFILLER_58_342 VPWR VGND VPWR VGND sky130_fd_sc_hd__decap_3
XFILLER_58_386 VPWR VGND VPWR VGND sky130_fd_sc_hd__decap_3
XFILLER_37_43 VPWR VGND VPWR VGND sky130_fd_sc_hd__decap_3
XFILLER_37_98 VPWR VGND VPWR VGND sky130_fd_sc_hd__decap_3
XFILLER_26_283 VPWR VGND VPWR VGND sky130_fd_sc_hd__decap_3
XFILLER_41_231 VPWR VGND VPWR VGND sky130_fd_sc_hd__decap_3
XFILLER_41_220 VPWR VGND VPWR VGND sky130_fd_sc_hd__decap_3
XFILLER_53_75 VPWR VGND VPWR VGND sky130_fd_sc_hd__decap_3
XFILLER_41_264 VPWR VGND VPWR VGND sky130_fd_sc_hd__decap_3
X_274_ VGND VPWR VPWR VGND clknet_2_0__leaf_clk_regs net9 _019_ genblk1\[2\].fa_inst.a
+ _274_/a_1462_47# _274_/a_543_47# _274_/a_651_413# _274_/a_193_47# _274_/a_805_47#
+ _274_/a_448_47# _274_/a_639_47# _274_/a_1283_21# _274_/a_761_289# _274_/a_1108_47#
+ _274_/a_1217_47# _274_/a_1270_413# _274_/a_27_47# sky130_fd_sc_hd__dfrtp_1
XFILLER_5_143 VPWR VGND VPWR VGND sky130_fd_sc_hd__decap_3
XFILLER_49_320 VPWR VGND VPWR VGND sky130_fd_sc_hd__decap_3
XFILLER_1_382 VPWR VGND VPWR VGND sky130_fd_sc_hd__decap_3
XFILLER_49_364 VPWR VGND VPWR VGND sky130_fd_sc_hd__decap_3
XFILLER_64_323 VPWR VGND VPWR VGND sky130_fd_sc_hd__decap_3
XFILLER_24_209 VPWR VGND VPWR VGND sky130_fd_sc_hd__decap_3
XFILLER_64_389 VPWR VGND VPWR VGND sky130_fd_sc_hd__decap_3
XFILLER_32_242 VPWR VGND VPWR VGND sky130_fd_sc_hd__decap_3
XFILLER_32_253 VPWR VGND VPWR VGND sky130_fd_sc_hd__decap_3
XFILLER_32_286 VPWR VGND VPWR VGND sky130_fd_sc_hd__decap_3
XFILLER_4_80 VPWR VGND VPWR VGND sky130_fd_sc_hd__decap_3
XFILLER_4_91 VPWR VGND VPWR VGND sky130_fd_sc_hd__decap_3
XFILLER_55_323 VPWR VGND VPWR VGND sky130_fd_sc_hd__decap_3
XFILLER_55_367 VPWR VGND VPWR VGND sky130_fd_sc_hd__decap_3
XFILLER_23_231 VPWR VGND VPWR VGND sky130_fd_sc_hd__decap_3
XFILLER_23_220 VPWR VGND VPWR VGND sky130_fd_sc_hd__decap_3
XFILLER_23_12 VPWR VGND VPWR VGND sky130_fd_sc_hd__decap_3
XFILLER_23_264 VPWR VGND VPWR VGND sky130_fd_sc_hd__decap_3
XFILLER_2_124 VPWR VGND VPWR VGND sky130_fd_sc_hd__decap_3
XFILLER_2_168 VPWR VGND VPWR VGND sky130_fd_sc_hd__decap_3
XFILLER_58_150 VPWR VGND VPWR VGND sky130_fd_sc_hd__decap_3
XFILLER_58_183 VPWR VGND VPWR VGND sky130_fd_sc_hd__decap_3
XFILLER_46_312 VPWR VGND VPWR VGND sky130_fd_sc_hd__decap_3
XFILLER_46_301 VPWR VGND VPWR VGND sky130_fd_sc_hd__decap_3
XFILLER_46_345 VPWR VGND VPWR VGND sky130_fd_sc_hd__decap_3
XFILLER_0_38 VPWR VGND VPWR VGND sky130_fd_sc_hd__decap_3
XFILLER_61_326 VPWR VGND VPWR VGND sky130_fd_sc_hd__decap_3
XFILLER_64_63 VPWR VGND VPWR VGND sky130_fd_sc_hd__decap_3
XFILLER_64_41 VPWR VGND VPWR VGND sky130_fd_sc_hd__decap_3
XFILLER_46_389 VPWR VGND VPWR VGND sky130_fd_sc_hd__decap_3
XFILLER_61_337 VPWR VGND VPWR VGND sky130_fd_sc_hd__decap_3
XFILLER_64_85 VPWR VGND VPWR VGND sky130_fd_sc_hd__decap_3
XFILLER_9_69 VPWR VGND VPWR VGND sky130_fd_sc_hd__decap_3
X_257_ VGND VPWR VPWR VGND clknet_2_0__leaf_clk_regs genblk1\[2\].fa_inst.s _002_
+ net47 _257_/a_1462_47# _257_/a_543_47# _257_/a_651_413# _257_/a_193_47# _257_/a_805_47#
+ _257_/a_448_47# _257_/a_639_47# _257_/a_1283_21# _257_/a_761_289# _257_/a_1108_47#
+ _257_/a_1217_47# _257_/a_1270_413# _257_/a_27_47# sky130_fd_sc_hd__dfrtp_1
X_188_ VGND VPWR VGND VPWR _100_ _096_ _093_ _094_ _188_/a_215_297# _188_/a_27_413#
+ _188_/a_298_297# _188_/a_382_47# sky130_fd_sc_hd__a21bo_1
XFILLER_50_6 VPWR VGND VPWR VGND sky130_fd_sc_hd__decap_3
XFILLER_29_3 VPWR VGND VPWR VGND sky130_fd_sc_hd__decap_3
XFILLER_56_109 VPWR VGND VPWR VGND sky130_fd_sc_hd__decap_3
XFILLER_37_323 VPWR VGND VPWR VGND sky130_fd_sc_hd__decap_3
XFILLER_49_161 VPWR VGND VPWR VGND sky130_fd_sc_hd__decap_3
XFILLER_49_172 VPWR VGND VPWR VGND sky130_fd_sc_hd__decap_3
XFILLER_64_131 VPWR VGND VPWR VGND sky130_fd_sc_hd__decap_3
XFILLER_37_367 VPWR VGND VPWR VGND sky130_fd_sc_hd__decap_3
XFILLER_64_175 VPWR VGND VPWR VGND sky130_fd_sc_hd__decap_3
XFILLER_64_153 VPWR VGND VPWR VGND sky130_fd_sc_hd__decap_3
XFILLER_52_315 VPWR VGND VPWR VGND sky130_fd_sc_hd__decap_3
XFILLER_52_304 VPWR VGND VPWR VGND sky130_fd_sc_hd__decap_3
XFILLER_64_197 VPWR VGND VPWR VGND sky130_fd_sc_hd__decap_3
XFILLER_52_348 VPWR VGND VPWR VGND sky130_fd_sc_hd__decap_3
XFILLER_60_392 VPWR VGND VPWR VGND sky130_fd_sc_hd__decap_3
XFILLER_18_12 VPWR VGND VPWR VGND sky130_fd_sc_hd__decap_3
XFILLER_28_301 VPWR VGND VPWR VGND sky130_fd_sc_hd__decap_3
XFILLER_28_312 VPWR VGND VPWR VGND sky130_fd_sc_hd__decap_3
XFILLER_28_345 VPWR VGND VPWR VGND sky130_fd_sc_hd__decap_3
XFILLER_55_131 VPWR VGND VPWR VGND sky130_fd_sc_hd__decap_3
XFILLER_43_326 VPWR VGND VPWR VGND sky130_fd_sc_hd__decap_3
XFILLER_28_389 VPWR VGND VPWR VGND sky130_fd_sc_hd__decap_3
XFILLER_55_164 VPWR VGND VPWR VGND sky130_fd_sc_hd__decap_3
XFILLER_55_175 VPWR VGND VPWR VGND sky130_fd_sc_hd__decap_3
XFILLER_43_337 VPWR VGND VPWR VGND sky130_fd_sc_hd__decap_3
XFILLER_34_44 VPWR VGND VPWR VGND sky130_fd_sc_hd__decap_3
XFILLER_51_370 VPWR VGND VPWR VGND sky130_fd_sc_hd__decap_3
XFILLER_34_88 VPWR VGND VPWR VGND sky130_fd_sc_hd__decap_3
XFILLER_34_77 VPWR VGND VPWR VGND sky130_fd_sc_hd__decap_3
XPHY_EDGE_ROW_14_2_Left_35 VPWR VGND VPWR VGND sky130_fd_sc_hd__decap_3
XFILLER_50_21 VPWR VGND VPWR VGND sky130_fd_sc_hd__decap_3
XFILLER_50_32 VPWR VGND VPWR VGND sky130_fd_sc_hd__decap_3
XFILLER_50_65 VPWR VGND VPWR VGND sky130_fd_sc_hd__decap_3
XFILLER_3_400 VPWR VGND VPWR VGND sky130_fd_sc_hd__decap_3
XFILLER_59_30 VPWR VGND VPWR VGND sky130_fd_sc_hd__decap_3
XFILLER_59_63 VPWR VGND VPWR VGND sky130_fd_sc_hd__decap_3
XFILLER_59_96 VPWR VGND VPWR VGND sky130_fd_sc_hd__decap_3
XFILLER_38_109 VPWR VGND VPWR VGND sky130_fd_sc_hd__decap_3
XFILLER_15_9 VPWR VGND VPWR VGND sky130_fd_sc_hd__decap_3
XFILLER_19_334 VPWR VGND VPWR VGND sky130_fd_sc_hd__decap_3
XFILLER_19_367 VPWR VGND VPWR VGND sky130_fd_sc_hd__decap_3
XFILLER_34_304 VPWR VGND VPWR VGND sky130_fd_sc_hd__decap_3
XFILLER_34_315 VPWR VGND VPWR VGND sky130_fd_sc_hd__decap_3
XFILLER_46_153 VPWR VGND VPWR VGND sky130_fd_sc_hd__decap_3
XFILLER_61_134 VPWR VGND VPWR VGND sky130_fd_sc_hd__decap_3
XFILLER_34_348 VPWR VGND VPWR VGND sky130_fd_sc_hd__decap_3
XFILLER_46_186 VPWR VGND VPWR VGND sky130_fd_sc_hd__decap_3
XFILLER_46_197 VPWR VGND VPWR VGND sky130_fd_sc_hd__decap_3
XFILLER_61_178 VPWR VGND VPWR VGND sky130_fd_sc_hd__decap_3
XFILLER_42_392 VPWR VGND VPWR VGND sky130_fd_sc_hd__decap_3
XFILLER_29_109 VPWR VGND VPWR VGND sky130_fd_sc_hd__decap_3
XFILLER_37_131 VPWR VGND VPWR VGND sky130_fd_sc_hd__decap_3
XFILLER_1_81 VPWR VGND VPWR VGND sky130_fd_sc_hd__decap_3
XFILLER_37_175 VPWR VGND VPWR VGND sky130_fd_sc_hd__decap_3
XFILLER_37_164 VPWR VGND VPWR VGND sky130_fd_sc_hd__decap_3
XFILLER_25_326 VPWR VGND VPWR VGND sky130_fd_sc_hd__decap_3
XFILLER_25_337 VPWR VGND VPWR VGND sky130_fd_sc_hd__decap_3
XFILLER_52_134 VPWR VGND VPWR VGND sky130_fd_sc_hd__decap_3
XFILLER_52_156 VPWR VGND VPWR VGND sky130_fd_sc_hd__decap_3
XFILLER_40_318 VPWR VGND VPWR VGND sky130_fd_sc_hd__decap_3
XFILLER_33_370 VPWR VGND VPWR VGND sky130_fd_sc_hd__decap_3
XFILLER_52_189 VPWR VGND VPWR VGND sky130_fd_sc_hd__decap_3
XFILLER_20_24 VPWR VGND VPWR VGND sky130_fd_sc_hd__decap_3
XFILLER_20_35 VPWR VGND VPWR VGND sky130_fd_sc_hd__decap_3
XFILLER_0_403 VPWR VGND VPWR VGND sky130_fd_sc_hd__decap_3
XFILLER_20_79 VPWR VGND VPWR VGND sky130_fd_sc_hd__decap_3
XFILLER_29_66 VPWR VGND VPWR VGND sky130_fd_sc_hd__decap_3
XFILLER_28_120 VPWR VGND VPWR VGND sky130_fd_sc_hd__decap_3
XFILLER_16_337 VPWR VGND VPWR VGND sky130_fd_sc_hd__decap_3
XFILLER_28_186 VPWR VGND VPWR VGND sky130_fd_sc_hd__decap_3
XFILLER_28_197 VPWR VGND VPWR VGND sky130_fd_sc_hd__decap_3
XFILLER_43_134 VPWR VGND VPWR VGND sky130_fd_sc_hd__decap_3
XFILLER_45_76 VPWR VGND VPWR VGND sky130_fd_sc_hd__decap_3
XFILLER_31_329 VPWR VGND VPWR VGND sky130_fd_sc_hd__decap_3
XFILLER_43_178 VPWR VGND VPWR VGND sky130_fd_sc_hd__decap_3
XFILLER_61_42 VPWR VGND VPWR VGND sky130_fd_sc_hd__decap_3
XFILLER_24_392 VPWR VGND VPWR VGND sky130_fd_sc_hd__decap_3
XFILLER_61_75 VPWR VGND VPWR VGND sky130_fd_sc_hd__decap_3
XFILLER_6_15 VPWR VGND VPWR VGND sky130_fd_sc_hd__decap_3
XFILLER_6_59 VPWR VGND VPWR VGND sky130_fd_sc_hd__decap_3
XFILLER_13_6 VPWR VGND VPWR VGND sky130_fd_sc_hd__decap_3
XFILLER_19_131 VPWR VGND VPWR VGND sky130_fd_sc_hd__decap_3
XFILLER_19_164 VPWR VGND VPWR VGND sky130_fd_sc_hd__decap_3
XFILLER_19_175 VPWR VGND VPWR VGND sky130_fd_sc_hd__decap_3
XFILLER_34_112 VPWR VGND VPWR VGND sky130_fd_sc_hd__decap_3
XFILLER_34_156 VPWR VGND VPWR VGND sky130_fd_sc_hd__decap_3
XFILLER_15_370 VPWR VGND VPWR VGND sky130_fd_sc_hd__decap_3
XFILLER_34_189 VPWR VGND VPWR VGND sky130_fd_sc_hd__decap_3
XFILLER_22_318 VPWR VGND VPWR VGND sky130_fd_sc_hd__decap_3
XFILLER_30_351 VPWR VGND VPWR VGND sky130_fd_sc_hd__decap_3
XFILLER_30_395 VPWR VGND VPWR VGND sky130_fd_sc_hd__decap_3
XFILLER_57_237 VPWR VGND VPWR VGND sky130_fd_sc_hd__decap_3
XFILLER_25_134 VPWR VGND VPWR VGND sky130_fd_sc_hd__decap_3
XFILLER_15_46 VPWR VGND VPWR VGND sky130_fd_sc_hd__decap_3
XFILLER_15_57 VPWR VGND VPWR VGND sky130_fd_sc_hd__decap_3
XFILLER_25_178 VPWR VGND VPWR VGND sky130_fd_sc_hd__decap_3
XFILLER_40_115 VPWR VGND VPWR VGND sky130_fd_sc_hd__decap_3
XFILLER_40_159 VPWR VGND VPWR VGND sky130_fd_sc_hd__decap_3
XFILLER_21_340 VPWR VGND VPWR VGND sky130_fd_sc_hd__decap_3
XFILLER_31_12 VPWR VGND VPWR VGND sky130_fd_sc_hd__decap_3
XFILLER_31_78 VPWR VGND VPWR VGND sky130_fd_sc_hd__decap_3
Xoutput45 VPWR VGND s[15] net45 VPWR VGND output45/a_27_47# sky130_fd_sc_hd__buf_2
XFILLER_48_215 VPWR VGND VPWR VGND sky130_fd_sc_hd__decap_3
XFILLER_48_248 VPWR VGND VPWR VGND sky130_fd_sc_hd__decap_3
XFILLER_48_259 VPWR VGND VPWR VGND sky130_fd_sc_hd__decap_3
XFILLER_56_53 VPWR VGND VPWR VGND sky130_fd_sc_hd__decap_3
XFILLER_56_292 VPWR VGND VPWR VGND sky130_fd_sc_hd__decap_3
XFILLER_56_97 VPWR VGND VPWR VGND sky130_fd_sc_hd__decap_3
XFILLER_16_156 VPWR VGND VPWR VGND sky130_fd_sc_hd__decap_3
XFILLER_16_134 VPWR VGND VPWR VGND sky130_fd_sc_hd__decap_3
XFILLER_31_137 VPWR VGND VPWR VGND sky130_fd_sc_hd__decap_3
XFILLER_12_340 VPWR VGND VPWR VGND sky130_fd_sc_hd__decap_3
XFILLER_12_384 VPWR VGND VPWR VGND sky130_fd_sc_hd__decap_3
XFILLER_8_366 VPWR VGND VPWR VGND sky130_fd_sc_hd__decap_3
XFILLER_8_399 VPWR VGND VPWR VGND sky130_fd_sc_hd__decap_3
XPHY_EDGE_ROW_28_Right_49 VPWR VGND VPWR VGND sky130_fd_sc_hd__decap_3
XFILLER_11_3 VPWR VGND VPWR VGND sky130_fd_sc_hd__decap_3
XFILLER_39_237 VPWR VGND VPWR VGND sky130_fd_sc_hd__decap_3
XFILLER_54_218 VPWR VGND VPWR VGND sky130_fd_sc_hd__decap_3
XPHY_EDGE_ROW_37_Right_58 VPWR VGND VPWR VGND sky130_fd_sc_hd__decap_3
XFILLER_47_270 VPWR VGND VPWR VGND sky130_fd_sc_hd__decap_3
XFILLER_47_281 VPWR VGND VPWR VGND sky130_fd_sc_hd__decap_3
XFILLER_62_262 VPWR VGND VPWR VGND sky130_fd_sc_hd__decap_3
XFILLER_22_115 VPWR VGND VPWR VGND sky130_fd_sc_hd__decap_3
XFILLER_62_295 VPWR VGND VPWR VGND sky130_fd_sc_hd__decap_3
XFILLER_22_159 VPWR VGND VPWR VGND sky130_fd_sc_hd__decap_3
XFILLER_30_192 VPWR VGND VPWR VGND sky130_fd_sc_hd__decap_3
XPHY_EDGE_ROW_46_Right_67 VPWR VGND VPWR VGND sky130_fd_sc_hd__decap_3
XFILLER_7_91 VPWR VGND VPWR VGND sky130_fd_sc_hd__decap_3
XPHY_EDGE_ROW_55_Right_76 VPWR VGND VPWR VGND sky130_fd_sc_hd__decap_3
XFILLER_26_12 VPWR VGND VPWR VGND sky130_fd_sc_hd__decap_3
XFILLER_38_292 VPWR VGND VPWR VGND sky130_fd_sc_hd__decap_3
XFILLER_53_240 VPWR VGND VPWR VGND sky130_fd_sc_hd__decap_3
XFILLER_26_78 VPWR VGND VPWR VGND sky130_fd_sc_hd__decap_3
XFILLER_53_273 VPWR VGND VPWR VGND sky130_fd_sc_hd__decap_3
XFILLER_53_284 VPWR VGND VPWR VGND sky130_fd_sc_hd__decap_3
XFILLER_13_137 VPWR VGND VPWR VGND sky130_fd_sc_hd__decap_3
X_290_ VGND VPWR VPWR VGND clknet_2_1__leaf_clk_regs net25 _035_ genblk1\[2\].fa_inst.b
+ _290_/a_1462_47# _290_/a_543_47# _290_/a_651_413# _290_/a_193_47# _290_/a_805_47#
+ _290_/a_448_47# _290_/a_639_47# _290_/a_1283_21# _290_/a_761_289# _290_/a_1108_47#
+ _290_/a_1217_47# _290_/a_1270_413# _290_/a_27_47# sky130_fd_sc_hd__dfrtp_1
XFILLER_9_119 VPWR VGND VPWR VGND sky130_fd_sc_hd__decap_3
XFILLER_9_108 VPWR VGND VPWR VGND sky130_fd_sc_hd__decap_3
XFILLER_42_44 VPWR VGND VPWR VGND sky130_fd_sc_hd__decap_3
XFILLER_21_181 VPWR VGND VPWR VGND sky130_fd_sc_hd__decap_3
XFILLER_42_77 VPWR VGND VPWR VGND sky130_fd_sc_hd__decap_3
XPHY_EDGE_ROW_64_Right_85 VPWR VGND VPWR VGND sky130_fd_sc_hd__decap_3
XFILLER_42_88 VPWR VGND VPWR VGND sky130_fd_sc_hd__decap_3
XFILLER_5_358 VPWR VGND VPWR VGND sky130_fd_sc_hd__decap_3
XFILLER_29_270 VPWR VGND VPWR VGND sky130_fd_sc_hd__decap_3
XFILLER_29_281 VPWR VGND VPWR VGND sky130_fd_sc_hd__decap_3
XFILLER_36_218 VPWR VGND VPWR VGND sky130_fd_sc_hd__decap_3
XFILLER_44_262 VPWR VGND VPWR VGND sky130_fd_sc_hd__decap_3
XFILLER_44_295 VPWR VGND VPWR VGND sky130_fd_sc_hd__decap_3
XFILLER_8_130 VPWR VGND VPWR VGND sky130_fd_sc_hd__decap_3
XFILLER_8_141 VPWR VGND VPWR VGND sky130_fd_sc_hd__decap_3
XFILLER_8_174 VPWR VGND VPWR VGND sky130_fd_sc_hd__decap_3
XFILLER_59_3 VPWR VGND VPWR VGND sky130_fd_sc_hd__decap_3
XFILLER_35_240 VPWR VGND VPWR VGND sky130_fd_sc_hd__decap_3
XFILLER_35_273 VPWR VGND VPWR VGND sky130_fd_sc_hd__decap_3
XFILLER_23_402 VPWR VGND VPWR VGND sky130_fd_sc_hd__decap_3
XFILLER_35_284 VPWR VGND VPWR VGND sky130_fd_sc_hd__decap_3
XFILLER_50_221 VPWR VGND VPWR VGND sky130_fd_sc_hd__decap_3
XFILLER_50_265 VPWR VGND VPWR VGND sky130_fd_sc_hd__decap_3
XFILLER_50_298 VPWR VGND VPWR VGND sky130_fd_sc_hd__decap_3
XFILLER_10_118 VPWR VGND VPWR VGND sky130_fd_sc_hd__decap_3
XFILLER_12_47 VPWR VGND VPWR VGND sky130_fd_sc_hd__decap_3
XFILLER_58_321 VPWR VGND VPWR VGND sky130_fd_sc_hd__decap_3
XFILLER_58_365 VPWR VGND VPWR VGND sky130_fd_sc_hd__decap_3
XFILLER_58_354 VPWR VGND VPWR VGND sky130_fd_sc_hd__decap_3
XFILLER_58_398 VPWR VGND VPWR VGND sky130_fd_sc_hd__decap_3
XFILLER_37_77 VPWR VGND VPWR VGND sky130_fd_sc_hd__decap_3
XFILLER_14_402 VPWR VGND VPWR VGND sky130_fd_sc_hd__decap_3
XFILLER_26_262 VPWR VGND VPWR VGND sky130_fd_sc_hd__decap_3
XFILLER_26_295 VPWR VGND VPWR VGND sky130_fd_sc_hd__decap_3
XFILLER_53_43 VPWR VGND VPWR VGND sky130_fd_sc_hd__decap_3
XFILLER_53_87 VPWR VGND VPWR VGND sky130_fd_sc_hd__decap_3
XFILLER_41_243 VPWR VGND VPWR VGND sky130_fd_sc_hd__decap_3
X_273_ VGND VPWR VPWR VGND clknet_2_1__leaf_clk_regs net8 _018_ genblk1\[1\].fa_inst.a
+ _273_/a_1462_47# _273_/a_543_47# _273_/a_651_413# _273_/a_193_47# _273_/a_805_47#
+ _273_/a_448_47# _273_/a_639_47# _273_/a_1283_21# _273_/a_761_289# _273_/a_1108_47#
+ _273_/a_1217_47# _273_/a_1270_413# _273_/a_27_47# sky130_fd_sc_hd__dfrtp_1
XFILLER_41_276 VPWR VGND VPWR VGND sky130_fd_sc_hd__decap_3
XFILLER_41_287 VPWR VGND VPWR VGND sky130_fd_sc_hd__decap_3
XFILLER_5_122 VPWR VGND VPWR VGND sky130_fd_sc_hd__decap_3
XFILLER_5_100 VPWR VGND VPWR VGND sky130_fd_sc_hd__decap_3
XFILLER_5_155 VPWR VGND VPWR VGND sky130_fd_sc_hd__decap_3
XFILLER_45_9 VPWR VGND VPWR VGND sky130_fd_sc_hd__decap_3
XFILLER_1_361 VPWR VGND VPWR VGND sky130_fd_sc_hd__decap_3
XFILLER_49_332 VPWR VGND VPWR VGND sky130_fd_sc_hd__decap_3
XFILLER_1_394 VPWR VGND VPWR VGND sky130_fd_sc_hd__decap_3
XFILLER_49_343 VPWR VGND VPWR VGND sky130_fd_sc_hd__decap_3
XFILLER_64_302 VPWR VGND VPWR VGND sky130_fd_sc_hd__decap_3
XFILLER_49_376 VPWR VGND VPWR VGND sky130_fd_sc_hd__decap_3
XFILLER_64_368 VPWR VGND VPWR VGND sky130_fd_sc_hd__decap_3
XFILLER_64_346 VPWR VGND VPWR VGND sky130_fd_sc_hd__decap_3
XFILLER_32_221 VPWR VGND VPWR VGND sky130_fd_sc_hd__decap_3
XFILLER_32_265 VPWR VGND VPWR VGND sky130_fd_sc_hd__decap_3
XFILLER_32_298 VPWR VGND VPWR VGND sky130_fd_sc_hd__decap_3
XFILLER_59_129 VPWR VGND VPWR VGND sky130_fd_sc_hd__decap_3
XFILLER_55_302 VPWR VGND VPWR VGND sky130_fd_sc_hd__decap_3
XFILLER_55_346 VPWR VGND VPWR VGND sky130_fd_sc_hd__decap_3
XFILLER_55_379 VPWR VGND VPWR VGND sky130_fd_sc_hd__decap_3
XFILLER_23_243 VPWR VGND VPWR VGND sky130_fd_sc_hd__decap_3
XFILLER_23_276 VPWR VGND VPWR VGND sky130_fd_sc_hd__decap_3
XFILLER_23_287 VPWR VGND VPWR VGND sky130_fd_sc_hd__decap_3
XFILLER_23_57 VPWR VGND VPWR VGND sky130_fd_sc_hd__decap_3
XFILLER_2_103 VPWR VGND VPWR VGND sky130_fd_sc_hd__decap_3
XFILLER_2_147 VPWR VGND VPWR VGND sky130_fd_sc_hd__decap_3
XFILLER_2_136 VPWR VGND VPWR VGND sky130_fd_sc_hd__decap_3
XPHY_EDGE_ROW_2_1_Right_1 VPWR VGND VPWR VGND sky130_fd_sc_hd__decap_3
XFILLER_48_21 VPWR VGND VPWR VGND sky130_fd_sc_hd__decap_3
XFILLER_58_162 VPWR VGND VPWR VGND sky130_fd_sc_hd__decap_3
XFILLER_46_324 VPWR VGND VPWR VGND sky130_fd_sc_hd__decap_3
XFILLER_64_20 VPWR VGND VPWR VGND sky130_fd_sc_hd__decap_3
XFILLER_46_357 VPWR VGND VPWR VGND sky130_fd_sc_hd__decap_3
XFILLER_61_305 VPWR VGND VPWR VGND sky130_fd_sc_hd__decap_3
XFILLER_64_53 VPWR VGND VPWR VGND sky130_fd_sc_hd__decap_3
XFILLER_46_368 VPWR VGND VPWR VGND sky130_fd_sc_hd__decap_3
XFILLER_61_349 VPWR VGND VPWR VGND sky130_fd_sc_hd__decap_3
XFILLER_64_97 VPWR VGND VPWR VGND sky130_fd_sc_hd__decap_3
XFILLER_64_75 VPWR VGND VPWR VGND sky130_fd_sc_hd__decap_3
XFILLER_9_37 VPWR VGND VPWR VGND sky130_fd_sc_hd__decap_3
X_256_ VGND VPWR VPWR VGND clknet_2_0__leaf_clk_regs genblk1\[1\].fa_inst.s _001_
+ net46 _256_/a_1462_47# _256_/a_543_47# _256_/a_651_413# _256_/a_193_47# _256_/a_805_47#
+ _256_/a_448_47# _256_/a_639_47# _256_/a_1283_21# _256_/a_761_289# _256_/a_1108_47#
+ _256_/a_1217_47# _256_/a_1270_413# _256_/a_27_47# sky130_fd_sc_hd__dfrtp_1
X_187_ VPWR VGND VGND VPWR _097_ _099_ _098_ _187_/a_113_47# sky130_fd_sc_hd__nand2_1
XFILLER_43_6 VPWR VGND VPWR VGND sky130_fd_sc_hd__decap_3
XFILLER_49_140 VPWR VGND VPWR VGND sky130_fd_sc_hd__decap_3
XFILLER_37_302 VPWR VGND VPWR VGND sky130_fd_sc_hd__decap_3
XFILLER_49_184 VPWR VGND VPWR VGND sky130_fd_sc_hd__decap_3
XFILLER_37_346 VPWR VGND VPWR VGND sky130_fd_sc_hd__decap_3
XFILLER_64_165 VPWR VGND VPWR VGND sky130_fd_sc_hd__decap_3
XFILLER_37_379 VPWR VGND VPWR VGND sky130_fd_sc_hd__decap_3
XFILLER_64_187 VPWR VGND VPWR VGND sky130_fd_sc_hd__decap_3
XFILLER_52_327 VPWR VGND VPWR VGND sky130_fd_sc_hd__decap_3
XFILLER_60_371 VPWR VGND VPWR VGND sky130_fd_sc_hd__decap_3
XFILLER_60_360 VPWR VGND VPWR VGND sky130_fd_sc_hd__decap_3
XPHY_EDGE_ROW_9_2_Right_95 VPWR VGND VPWR VGND sky130_fd_sc_hd__decap_3
XFILLER_18_24 VPWR VGND VPWR VGND sky130_fd_sc_hd__decap_3
XFILLER_18_35 VPWR VGND VPWR VGND sky130_fd_sc_hd__decap_3
XFILLER_28_324 VPWR VGND VPWR VGND sky130_fd_sc_hd__decap_3
XFILLER_18_57 VPWR VGND VPWR VGND sky130_fd_sc_hd__decap_3
XFILLER_18_68 VPWR VGND VPWR VGND sky130_fd_sc_hd__decap_3
XFILLER_28_357 VPWR VGND VPWR VGND sky130_fd_sc_hd__decap_3
XFILLER_55_143 VPWR VGND VPWR VGND sky130_fd_sc_hd__decap_3
XFILLER_43_305 VPWR VGND VPWR VGND sky130_fd_sc_hd__decap_3
XFILLER_28_368 VPWR VGND VPWR VGND sky130_fd_sc_hd__decap_3
XFILLER_43_349 VPWR VGND VPWR VGND sky130_fd_sc_hd__decap_3
XFILLER_34_12 VPWR VGND VPWR VGND sky130_fd_sc_hd__decap_3
XFILLER_55_187 VPWR VGND VPWR VGND sky130_fd_sc_hd__decap_3
XFILLER_51_382 VPWR VGND VPWR VGND sky130_fd_sc_hd__decap_3
XFILLER_34_56 VPWR VGND VPWR VGND sky130_fd_sc_hd__decap_3
XFILLER_51_393 VPWR VGND VPWR VGND sky130_fd_sc_hd__decap_3
Xclkload0 VGND VPWR VGND VPWR clknet_2_0__leaf_clk_regs clkload0/Y clkload0/a_361_47#
+ clkload0/a_27_47# sky130_fd_sc_hd__bufinv_16
XFILLER_50_44 VPWR VGND VPWR VGND sky130_fd_sc_hd__decap_3
XFILLER_50_77 VPWR VGND VPWR VGND sky130_fd_sc_hd__decap_3
XFILLER_50_88 VPWR VGND VPWR VGND sky130_fd_sc_hd__decap_3
XFILLER_59_42 VPWR VGND VPWR VGND sky130_fd_sc_hd__decap_3
XFILLER_59_75 VPWR VGND VPWR VGND sky130_fd_sc_hd__decap_3
XFILLER_19_346 VPWR VGND VPWR VGND sky130_fd_sc_hd__decap_3
XFILLER_46_121 VPWR VGND VPWR VGND sky130_fd_sc_hd__decap_3
XFILLER_46_165 VPWR VGND VPWR VGND sky130_fd_sc_hd__decap_3
XFILLER_61_113 VPWR VGND VPWR VGND sky130_fd_sc_hd__decap_3
XFILLER_61_102 VPWR VGND VPWR VGND sky130_fd_sc_hd__decap_3
XFILLER_34_327 VPWR VGND VPWR VGND sky130_fd_sc_hd__decap_3
XFILLER_61_146 VPWR VGND VPWR VGND sky130_fd_sc_hd__decap_3
XFILLER_42_371 VPWR VGND VPWR VGND sky130_fd_sc_hd__decap_3
XFILLER_42_360 VPWR VGND VPWR VGND sky130_fd_sc_hd__decap_3
X_239_ net56 _034_ VPWR VGND VPWR VGND sky130_fd_sc_hd__inv_2
XFILLER_41_3 VPWR VGND VPWR VGND sky130_fd_sc_hd__decap_3
XFILLER_1_60 VPWR VGND VPWR VGND sky130_fd_sc_hd__decap_3
XFILLER_37_143 VPWR VGND VPWR VGND sky130_fd_sc_hd__decap_3
XFILLER_25_305 VPWR VGND VPWR VGND sky130_fd_sc_hd__decap_3
XFILLER_1_93 VPWR VGND VPWR VGND sky130_fd_sc_hd__decap_3
XFILLER_37_187 VPWR VGND VPWR VGND sky130_fd_sc_hd__decap_3
XFILLER_25_349 VPWR VGND VPWR VGND sky130_fd_sc_hd__decap_3
XFILLER_18_390 VPWR VGND VPWR VGND sky130_fd_sc_hd__decap_3
XFILLER_52_168 VPWR VGND VPWR VGND sky130_fd_sc_hd__decap_3
XFILLER_33_382 VPWR VGND VPWR VGND sky130_fd_sc_hd__decap_3
XFILLER_33_393 VPWR VGND VPWR VGND sky130_fd_sc_hd__decap_3
XFILLER_20_47 VPWR VGND VPWR VGND sky130_fd_sc_hd__decap_3
XFILLER_29_12 VPWR VGND VPWR VGND sky130_fd_sc_hd__decap_3
XFILLER_29_45 VPWR VGND VPWR VGND sky130_fd_sc_hd__decap_3
XFILLER_29_78 VPWR VGND VPWR VGND sky130_fd_sc_hd__decap_3
XFILLER_28_132 VPWR VGND VPWR VGND sky130_fd_sc_hd__decap_3
XFILLER_28_165 VPWR VGND VPWR VGND sky130_fd_sc_hd__decap_3
XFILLER_16_349 VPWR VGND VPWR VGND sky130_fd_sc_hd__decap_3
XFILLER_45_44 VPWR VGND VPWR VGND sky130_fd_sc_hd__decap_3
XFILLER_43_113 VPWR VGND VPWR VGND sky130_fd_sc_hd__decap_3
XFILLER_31_308 VPWR VGND VPWR VGND sky130_fd_sc_hd__decap_3
XFILLER_45_88 VPWR VGND VPWR VGND sky130_fd_sc_hd__decap_3
XFILLER_43_146 VPWR VGND VPWR VGND sky130_fd_sc_hd__decap_3
XFILLER_24_360 VPWR VGND VPWR VGND sky130_fd_sc_hd__decap_3
XFILLER_24_371 VPWR VGND VPWR VGND sky130_fd_sc_hd__decap_3
XFILLER_61_21 VPWR VGND VPWR VGND sky130_fd_sc_hd__decap_3
XFILLER_51_190 VPWR VGND VPWR VGND sky130_fd_sc_hd__decap_3
XFILLER_61_87 VPWR VGND VPWR VGND sky130_fd_sc_hd__decap_3
XFILLER_6_38 VPWR VGND VPWR VGND sky130_fd_sc_hd__decap_3
XFILLER_10_80 VPWR VGND VPWR VGND sky130_fd_sc_hd__decap_3
XFILLER_10_91 VPWR VGND VPWR VGND sky130_fd_sc_hd__decap_3
XFILLER_59_290 VPWR VGND VPWR VGND sky130_fd_sc_hd__decap_3
XFILLER_19_143 VPWR VGND VPWR VGND sky130_fd_sc_hd__decap_3
XFILLER_34_124 VPWR VGND VPWR VGND sky130_fd_sc_hd__decap_3
XFILLER_34_168 VPWR VGND VPWR VGND sky130_fd_sc_hd__decap_3
XFILLER_15_382 VPWR VGND VPWR VGND sky130_fd_sc_hd__decap_3
XFILLER_30_330 VPWR VGND VPWR VGND sky130_fd_sc_hd__decap_3
XPHY_EDGE_ROW_8_2_Left_29 VPWR VGND VPWR VGND sky130_fd_sc_hd__decap_3
XFILLER_30_374 VPWR VGND VPWR VGND sky130_fd_sc_hd__decap_3
XFILLER_57_205 VPWR VGND VPWR VGND sky130_fd_sc_hd__decap_3
XFILLER_57_249 VPWR VGND VPWR VGND sky130_fd_sc_hd__decap_3
XFILLER_25_113 VPWR VGND VPWR VGND sky130_fd_sc_hd__decap_3
XFILLER_25_146 VPWR VGND VPWR VGND sky130_fd_sc_hd__decap_3
XFILLER_15_69 VPWR VGND VPWR VGND sky130_fd_sc_hd__decap_3
XFILLER_33_190 VPWR VGND VPWR VGND sky130_fd_sc_hd__decap_3
XFILLER_21_330 VPWR VGND VPWR VGND sky130_fd_sc_hd__decap_3
XFILLER_40_127 VPWR VGND VPWR VGND sky130_fd_sc_hd__decap_3
XFILLER_21_352 VPWR VGND VPWR VGND sky130_fd_sc_hd__decap_3
XFILLER_21_374 VPWR VGND VPWR VGND sky130_fd_sc_hd__decap_3
XFILLER_21_396 VPWR VGND VPWR VGND sky130_fd_sc_hd__decap_3
XFILLER_31_57 VPWR VGND VPWR VGND sky130_fd_sc_hd__decap_3
Xoutput46 VPWR VGND s[1] net46 VPWR VGND output46/a_27_47# sky130_fd_sc_hd__buf_2
XFILLER_56_21 VPWR VGND VPWR VGND sky130_fd_sc_hd__decap_3
XFILLER_56_32 VPWR VGND VPWR VGND sky130_fd_sc_hd__decap_3
XFILLER_48_227 VPWR VGND VPWR VGND sky130_fd_sc_hd__decap_3
XFILLER_63_208 VPWR VGND VPWR VGND sky130_fd_sc_hd__decap_3
XFILLER_56_65 VPWR VGND VPWR VGND sky130_fd_sc_hd__decap_3
XFILLER_16_113 VPWR VGND VPWR VGND sky130_fd_sc_hd__decap_3
XFILLER_56_271 VPWR VGND VPWR VGND sky130_fd_sc_hd__decap_3
XFILLER_16_168 VPWR VGND VPWR VGND sky130_fd_sc_hd__decap_3
XFILLER_31_105 VPWR VGND VPWR VGND sky130_fd_sc_hd__decap_3
XFILLER_31_116 VPWR VGND VPWR VGND sky130_fd_sc_hd__decap_3
XFILLER_31_149 VPWR VGND VPWR VGND sky130_fd_sc_hd__decap_3
XFILLER_12_363 VPWR VGND VPWR VGND sky130_fd_sc_hd__decap_3
XFILLER_12_396 VPWR VGND VPWR VGND sky130_fd_sc_hd__decap_3
XFILLER_8_334 VPWR VGND VPWR VGND sky130_fd_sc_hd__decap_3
XFILLER_8_378 VPWR VGND VPWR VGND sky130_fd_sc_hd__decap_3
XFILLER_39_205 VPWR VGND VPWR VGND sky130_fd_sc_hd__decap_3
XFILLER_39_249 VPWR VGND VPWR VGND sky130_fd_sc_hd__decap_3
XFILLER_62_230 VPWR VGND VPWR VGND sky130_fd_sc_hd__decap_3
XFILLER_47_293 VPWR VGND VPWR VGND sky130_fd_sc_hd__decap_3
XFILLER_62_274 VPWR VGND VPWR VGND sky130_fd_sc_hd__decap_3
XFILLER_22_127 VPWR VGND VPWR VGND sky130_fd_sc_hd__decap_3
XFILLER_30_171 VPWR VGND VPWR VGND sky130_fd_sc_hd__decap_3
XFILLER_45_208 VPWR VGND VPWR VGND sky130_fd_sc_hd__decap_3
XFILLER_26_24 VPWR VGND VPWR VGND sky130_fd_sc_hd__decap_3
XFILLER_38_271 VPWR VGND VPWR VGND sky130_fd_sc_hd__decap_3
XFILLER_26_35 VPWR VGND VPWR VGND sky130_fd_sc_hd__decap_3
XFILLER_53_252 VPWR VGND VPWR VGND sky130_fd_sc_hd__decap_3
XFILLER_53_296 VPWR VGND VPWR VGND sky130_fd_sc_hd__decap_3
XFILLER_13_149 VPWR VGND VPWR VGND sky130_fd_sc_hd__decap_3
XFILLER_13_116 VPWR VGND VPWR VGND sky130_fd_sc_hd__decap_3
XFILLER_42_12 VPWR VGND VPWR VGND sky130_fd_sc_hd__decap_3
XFILLER_42_56 VPWR VGND VPWR VGND sky130_fd_sc_hd__decap_3
XFILLER_21_193 VPWR VGND VPWR VGND sky130_fd_sc_hd__decap_3
XFILLER_5_337 VPWR VGND VPWR VGND sky130_fd_sc_hd__decap_3
XFILLER_17_400 VPWR VGND VPWR VGND sky130_fd_sc_hd__decap_3
XFILLER_29_293 VPWR VGND VPWR VGND sky130_fd_sc_hd__decap_3
XFILLER_44_230 VPWR VGND VPWR VGND sky130_fd_sc_hd__decap_3
XFILLER_44_274 VPWR VGND VPWR VGND sky130_fd_sc_hd__decap_3
XFILLER_12_171 VPWR VGND VPWR VGND sky130_fd_sc_hd__decap_3
XFILLER_8_153 VPWR VGND VPWR VGND sky130_fd_sc_hd__decap_3
XFILLER_4_381 VPWR VGND VPWR VGND sky130_fd_sc_hd__decap_3
XPHY_EDGE_ROW_26_Left_132 VPWR VGND VPWR VGND sky130_fd_sc_hd__decap_3
XFILLER_27_208 VPWR VGND VPWR VGND sky130_fd_sc_hd__decap_3
XPHY_EDGE_ROW_35_Left_141 VPWR VGND VPWR VGND sky130_fd_sc_hd__decap_3
XFILLER_35_252 VPWR VGND VPWR VGND sky130_fd_sc_hd__decap_3
XFILLER_50_200 VPWR VGND VPWR VGND sky130_fd_sc_hd__decap_3
XFILLER_35_296 VPWR VGND VPWR VGND sky130_fd_sc_hd__decap_3
XFILLER_50_233 VPWR VGND VPWR VGND sky130_fd_sc_hd__decap_3
XFILLER_50_277 VPWR VGND VPWR VGND sky130_fd_sc_hd__decap_3
XFILLER_12_59 VPWR VGND VPWR VGND sky130_fd_sc_hd__decap_3
XPHY_EDGE_ROW_44_Left_150 VPWR VGND VPWR VGND sky130_fd_sc_hd__decap_3
XFILLER_58_333 VPWR VGND VPWR VGND sky130_fd_sc_hd__decap_3
XFILLER_37_12 VPWR VGND VPWR VGND sky130_fd_sc_hd__decap_3
XFILLER_58_377 VPWR VGND VPWR VGND sky130_fd_sc_hd__decap_3
XFILLER_37_89 VPWR VGND VPWR VGND sky130_fd_sc_hd__decap_3
XFILLER_26_230 VPWR VGND VPWR VGND sky130_fd_sc_hd__decap_3
XFILLER_26_274 VPWR VGND VPWR VGND sky130_fd_sc_hd__decap_3
XFILLER_41_211 VPWR VGND VPWR VGND sky130_fd_sc_hd__decap_3
XFILLER_53_66 VPWR VGND VPWR VGND sky130_fd_sc_hd__decap_3
XFILLER_41_255 VPWR VGND VPWR VGND sky130_fd_sc_hd__decap_3
XFILLER_41_299 VPWR VGND VPWR VGND sky130_fd_sc_hd__decap_3
X_272_ VGND VPWR VPWR VGND clknet_2_0__leaf_clk_regs net1 _017_ genblk1\[0\].fa_inst.a
+ _272_/a_1462_47# _272_/a_543_47# _272_/a_651_413# _272_/a_193_47# _272_/a_805_47#
+ _272_/a_448_47# _272_/a_639_47# _272_/a_1283_21# _272_/a_761_289# _272_/a_1108_47#
+ _272_/a_1217_47# _272_/a_1270_413# _272_/a_27_47# sky130_fd_sc_hd__dfrtp_1
XFILLER_53_99 VPWR VGND VPWR VGND sky130_fd_sc_hd__decap_3
XFILLER_5_134 VPWR VGND VPWR VGND sky130_fd_sc_hd__decap_3
XFILLER_1_340 VPWR VGND VPWR VGND sky130_fd_sc_hd__decap_3
XFILLER_38_9 VPWR VGND VPWR VGND sky130_fd_sc_hd__decap_3
XFILLER_49_311 VPWR VGND VPWR VGND sky130_fd_sc_hd__decap_3
XFILLER_1_373 VPWR VGND VPWR VGND sky130_fd_sc_hd__decap_3
XFILLER_49_355 VPWR VGND VPWR VGND sky130_fd_sc_hd__decap_3
XFILLER_49_388 VPWR VGND VPWR VGND sky130_fd_sc_hd__decap_3
XFILLER_64_358 VPWR VGND VPWR VGND sky130_fd_sc_hd__decap_3
XFILLER_32_200 VPWR VGND VPWR VGND sky130_fd_sc_hd__decap_3
XFILLER_32_233 VPWR VGND VPWR VGND sky130_fd_sc_hd__decap_3
XFILLER_32_277 VPWR VGND VPWR VGND sky130_fd_sc_hd__decap_3
XFILLER_59_108 VPWR VGND VPWR VGND sky130_fd_sc_hd__decap_3
XFILLER_4_71 VPWR VGND VPWR VGND sky130_fd_sc_hd__decap_3
XFILLER_55_314 VPWR VGND VPWR VGND sky130_fd_sc_hd__decap_3
XFILLER_55_358 VPWR VGND VPWR VGND sky130_fd_sc_hd__decap_3
XFILLER_23_211 VPWR VGND VPWR VGND sky130_fd_sc_hd__decap_3
XFILLER_23_255 VPWR VGND VPWR VGND sky130_fd_sc_hd__decap_3
XFILLER_23_299 VPWR VGND VPWR VGND sky130_fd_sc_hd__decap_3
XFILLER_23_69 VPWR VGND VPWR VGND sky130_fd_sc_hd__decap_3
XFILLER_2_115 VPWR VGND VPWR VGND sky130_fd_sc_hd__decap_3
XFILLER_3_6 VPWR VGND VPWR VGND sky130_fd_sc_hd__decap_3
XFILLER_2_159 VPWR VGND VPWR VGND sky130_fd_sc_hd__decap_3
XFILLER_58_141 VPWR VGND VPWR VGND sky130_fd_sc_hd__decap_3
XFILLER_58_174 VPWR VGND VPWR VGND sky130_fd_sc_hd__decap_3
XFILLER_48_77 VPWR VGND VPWR VGND sky130_fd_sc_hd__decap_3
XFILLER_48_88 VPWR VGND VPWR VGND sky130_fd_sc_hd__decap_3
XFILLER_46_336 VPWR VGND VPWR VGND sky130_fd_sc_hd__decap_3
XFILLER_0_29 VPWR VGND VPWR VGND sky130_fd_sc_hd__decap_3
XFILLER_0_18 VPWR VGND VPWR VGND sky130_fd_sc_hd__decap_3
XFILLER_61_317 VPWR VGND VPWR VGND sky130_fd_sc_hd__decap_3
XFILLER_64_32 VPWR VGND VPWR VGND sky130_fd_sc_hd__decap_3
XFILLER_54_380 VPWR VGND VPWR VGND sky130_fd_sc_hd__decap_3
XFILLER_9_49 VPWR VGND VPWR VGND sky130_fd_sc_hd__decap_3
X_255_ VGND VPWR VPWR VGND clknet_2_0__leaf_clk_regs genblk1\[0\].fa_inst.s _000_
+ net39 _255_/a_1462_47# _255_/a_543_47# _255_/a_651_413# _255_/a_193_47# _255_/a_805_47#
+ _255_/a_448_47# _255_/a_639_47# _255_/a_1283_21# _255_/a_761_289# _255_/a_1108_47#
+ _255_/a_1217_47# _255_/a_1270_413# _255_/a_27_47# sky130_fd_sc_hd__dfrtp_1
X_186_ VPWR VGND VGND VPWR genblk1\[12\].fa_inst.b _098_ genblk1\[12\].fa_inst.a _186_/a_113_47#
+ sky130_fd_sc_hd__nand2_1
XFILLER_36_6 VPWR VGND VPWR VGND sky130_fd_sc_hd__decap_3
XFILLER_64_100 VPWR VGND VPWR VGND sky130_fd_sc_hd__decap_3
XFILLER_37_314 VPWR VGND VPWR VGND sky130_fd_sc_hd__decap_3
XFILLER_49_152 VPWR VGND VPWR VGND sky130_fd_sc_hd__decap_3
XFILLER_64_122 VPWR VGND VPWR VGND sky130_fd_sc_hd__decap_3
XFILLER_37_358 VPWR VGND VPWR VGND sky130_fd_sc_hd__decap_3
XFILLER_49_196 VPWR VGND VPWR VGND sky130_fd_sc_hd__decap_3
XFILLER_64_144 VPWR VGND VPWR VGND sky130_fd_sc_hd__decap_3
XFILLER_52_339 VPWR VGND VPWR VGND sky130_fd_sc_hd__decap_3
XFILLER_60_383 VPWR VGND VPWR VGND sky130_fd_sc_hd__decap_3
XFILLER_28_336 VPWR VGND VPWR VGND sky130_fd_sc_hd__decap_3
XFILLER_55_122 VPWR VGND VPWR VGND sky130_fd_sc_hd__decap_3
XFILLER_43_317 VPWR VGND VPWR VGND sky130_fd_sc_hd__decap_3
XFILLER_55_155 VPWR VGND VPWR VGND sky130_fd_sc_hd__decap_3
XFILLER_36_380 VPWR VGND VPWR VGND sky130_fd_sc_hd__decap_3
XFILLER_55_199 VPWR VGND VPWR VGND sky130_fd_sc_hd__decap_3
XFILLER_34_24 VPWR VGND VPWR VGND sky130_fd_sc_hd__decap_3
XFILLER_34_35 VPWR VGND VPWR VGND sky130_fd_sc_hd__decap_3
XFILLER_51_361 VPWR VGND VPWR VGND sky130_fd_sc_hd__decap_3
XFILLER_34_68 VPWR VGND VPWR VGND sky130_fd_sc_hd__decap_3
Xclkload1 VGND VPWR VPWR VGND clknet_2_2__leaf_clk_regs clkload1/Y clkload1/a_110_47#
+ clkload1/a_268_47# sky130_fd_sc_hd__clkinvlp_4
XFILLER_50_12 VPWR VGND VPWR VGND sky130_fd_sc_hd__decap_3
XFILLER_50_56 VPWR VGND VPWR VGND sky130_fd_sc_hd__decap_3
XFILLER_59_21 VPWR VGND VPWR VGND sky130_fd_sc_hd__decap_3
XFILLER_1_3 VPWR VGND VPWR VGND sky130_fd_sc_hd__decap_3
XFILLER_59_87 VPWR VGND VPWR VGND sky130_fd_sc_hd__decap_3
XFILLER_46_100 VPWR VGND VPWR VGND sky130_fd_sc_hd__decap_3
XFILLER_46_133 VPWR VGND VPWR VGND sky130_fd_sc_hd__decap_3
XFILLER_19_358 VPWR VGND VPWR VGND sky130_fd_sc_hd__decap_3
XFILLER_46_144 VPWR VGND VPWR VGND sky130_fd_sc_hd__decap_3
XFILLER_61_125 VPWR VGND VPWR VGND sky130_fd_sc_hd__decap_3
XFILLER_34_339 VPWR VGND VPWR VGND sky130_fd_sc_hd__decap_3
XFILLER_46_177 VPWR VGND VPWR VGND sky130_fd_sc_hd__decap_3
XFILLER_61_169 VPWR VGND VPWR VGND sky130_fd_sc_hd__decap_3
XFILLER_61_158 VPWR VGND VPWR VGND sky130_fd_sc_hd__decap_3
XFILLER_42_383 VPWR VGND VPWR VGND sky130_fd_sc_hd__decap_3
X_238_ net56 _033_ VPWR VGND VPWR VGND sky130_fd_sc_hd__inv_2
X_169_ VGND VPWR _084_ genblk1\[8\].fa_inst.s _083_ VPWR VGND _169_/a_129_47# _169_/a_47_47#
+ _169_/a_285_47# _169_/a_377_297# sky130_fd_sc_hd__xnor2_1
XFILLER_37_122 VPWR VGND VPWR VGND sky130_fd_sc_hd__decap_3
XFILLER_1_72 VPWR VGND VPWR VGND sky130_fd_sc_hd__decap_3
XFILLER_37_155 VPWR VGND VPWR VGND sky130_fd_sc_hd__decap_3
XFILLER_37_199 VPWR VGND VPWR VGND sky130_fd_sc_hd__decap_3
XFILLER_25_317 VPWR VGND VPWR VGND sky130_fd_sc_hd__decap_3
XFILLER_52_125 VPWR VGND VPWR VGND sky130_fd_sc_hd__decap_3
XFILLER_52_147 VPWR VGND VPWR VGND sky130_fd_sc_hd__decap_3
XFILLER_40_309 VPWR VGND VPWR VGND sky130_fd_sc_hd__decap_3
XFILLER_33_361 VPWR VGND VPWR VGND sky130_fd_sc_hd__decap_3
XFILLER_60_180 VPWR VGND VPWR VGND sky130_fd_sc_hd__decap_3
XFILLER_20_15 VPWR VGND VPWR VGND sky130_fd_sc_hd__decap_3
XFILLER_20_59 VPWR VGND VPWR VGND sky130_fd_sc_hd__decap_3
XFILLER_28_111 VPWR VGND VPWR VGND sky130_fd_sc_hd__decap_3
XFILLER_45_12 VPWR VGND VPWR VGND sky130_fd_sc_hd__decap_3
XFILLER_16_328 VPWR VGND VPWR VGND sky130_fd_sc_hd__decap_3
XFILLER_28_177 VPWR VGND VPWR VGND sky130_fd_sc_hd__decap_3
XFILLER_43_125 VPWR VGND VPWR VGND sky130_fd_sc_hd__decap_3
XFILLER_43_158 VPWR VGND VPWR VGND sky130_fd_sc_hd__decap_3
XFILLER_43_169 VPWR VGND VPWR VGND sky130_fd_sc_hd__decap_3
XFILLER_61_33 VPWR VGND VPWR VGND sky130_fd_sc_hd__decap_3
XFILLER_24_383 VPWR VGND VPWR VGND sky130_fd_sc_hd__decap_3
XFILLER_61_66 VPWR VGND VPWR VGND sky130_fd_sc_hd__decap_3
XFILLER_61_99 VPWR VGND VPWR VGND sky130_fd_sc_hd__decap_3
XFILLER_20_9 VPWR VGND VPWR VGND sky130_fd_sc_hd__decap_3
XFILLER_19_122 VPWR VGND VPWR VGND sky130_fd_sc_hd__decap_3
XFILLER_19_155 VPWR VGND VPWR VGND sky130_fd_sc_hd__decap_3
XFILLER_62_401 VPWR VGND VPWR VGND sky130_fd_sc_hd__decap_3
XFILLER_34_103 VPWR VGND VPWR VGND sky130_fd_sc_hd__decap_3
XFILLER_34_136 VPWR VGND VPWR VGND sky130_fd_sc_hd__decap_3
XFILLER_34_147 VPWR VGND VPWR VGND sky130_fd_sc_hd__decap_3
XFILLER_15_361 VPWR VGND VPWR VGND sky130_fd_sc_hd__decap_3
XFILLER_22_309 VPWR VGND VPWR VGND sky130_fd_sc_hd__decap_3
XFILLER_15_394 VPWR VGND VPWR VGND sky130_fd_sc_hd__decap_3
XFILLER_42_180 VPWR VGND VPWR VGND sky130_fd_sc_hd__decap_3
XFILLER_30_342 VPWR VGND VPWR VGND sky130_fd_sc_hd__decap_3
XFILLER_30_386 VPWR VGND VPWR VGND sky130_fd_sc_hd__decap_3
XFILLER_57_217 VPWR VGND VPWR VGND sky130_fd_sc_hd__decap_3
XFILLER_57_228 VPWR VGND VPWR VGND sky130_fd_sc_hd__decap_3
XFILLER_25_103 VPWR VGND VPWR VGND sky130_fd_sc_hd__decap_3
XFILLER_25_125 VPWR VGND VPWR VGND sky130_fd_sc_hd__decap_3
XFILLER_25_158 VPWR VGND VPWR VGND sky130_fd_sc_hd__decap_3
XFILLER_15_37 VPWR VGND VPWR VGND sky130_fd_sc_hd__decap_3
XFILLER_25_169 VPWR VGND VPWR VGND sky130_fd_sc_hd__decap_3
XFILLER_21_386 VPWR VGND VPWR VGND sky130_fd_sc_hd__decap_3
XFILLER_31_47 VPWR VGND VPWR VGND sky130_fd_sc_hd__decap_3
XFILLER_31_69 VPWR VGND VPWR VGND sky130_fd_sc_hd__decap_3
Xoutput47 VPWR VGND s[2] net47 VPWR VGND output47/a_27_47# sky130_fd_sc_hd__buf_2
XFILLER_48_206 VPWR VGND VPWR VGND sky130_fd_sc_hd__decap_3
XFILLER_48_239 VPWR VGND VPWR VGND sky130_fd_sc_hd__decap_3
XFILLER_56_44 VPWR VGND VPWR VGND sky130_fd_sc_hd__decap_3
XFILLER_44_401 VPWR VGND VPWR VGND sky130_fd_sc_hd__decap_3
XFILLER_56_283 VPWR VGND VPWR VGND sky130_fd_sc_hd__decap_3
XFILLER_56_88 VPWR VGND VPWR VGND sky130_fd_sc_hd__decap_3
XFILLER_16_147 VPWR VGND VPWR VGND sky130_fd_sc_hd__decap_3
XFILLER_16_125 VPWR VGND VPWR VGND sky130_fd_sc_hd__decap_3
XFILLER_24_180 VPWR VGND VPWR VGND sky130_fd_sc_hd__decap_3
XFILLER_31_128 VPWR VGND VPWR VGND sky130_fd_sc_hd__decap_3
XFILLER_12_331 VPWR VGND VPWR VGND sky130_fd_sc_hd__decap_3
XFILLER_12_375 VPWR VGND VPWR VGND sky130_fd_sc_hd__decap_3
XFILLER_8_346 VPWR VGND VPWR VGND sky130_fd_sc_hd__decap_3
XFILLER_8_357 VPWR VGND VPWR VGND sky130_fd_sc_hd__decap_3
XFILLER_21_80 VPWR VGND VPWR VGND sky130_fd_sc_hd__decap_3
XFILLER_39_228 VPWR VGND VPWR VGND sky130_fd_sc_hd__decap_3
XFILLER_39_217 VPWR VGND VPWR VGND sky130_fd_sc_hd__decap_3
XFILLER_54_209 VPWR VGND VPWR VGND sky130_fd_sc_hd__decap_3
XFILLER_47_261 VPWR VGND VPWR VGND sky130_fd_sc_hd__decap_3
XFILLER_62_242 VPWR VGND VPWR VGND sky130_fd_sc_hd__decap_3
XFILLER_62_253 VPWR VGND VPWR VGND sky130_fd_sc_hd__decap_3
XFILLER_50_404 VPWR VGND VPWR VGND sky130_fd_sc_hd__decap_3
XFILLER_22_106 VPWR VGND VPWR VGND sky130_fd_sc_hd__decap_3
XFILLER_62_286 VPWR VGND VPWR VGND sky130_fd_sc_hd__decap_3
XFILLER_30_150 VPWR VGND VPWR VGND sky130_fd_sc_hd__decap_3
XFILLER_30_183 VPWR VGND VPWR VGND sky130_fd_sc_hd__decap_3
XFILLER_7_82 VPWR VGND VPWR VGND sky130_fd_sc_hd__decap_3
XFILLER_26_401 VPWR VGND VPWR VGND sky130_fd_sc_hd__decap_3
XFILLER_26_47 VPWR VGND VPWR VGND sky130_fd_sc_hd__decap_3
XFILLER_38_283 VPWR VGND VPWR VGND sky130_fd_sc_hd__decap_3
XFILLER_53_231 VPWR VGND VPWR VGND sky130_fd_sc_hd__decap_3
XFILLER_53_220 VPWR VGND VPWR VGND sky130_fd_sc_hd__decap_3
XFILLER_26_69 VPWR VGND VPWR VGND sky130_fd_sc_hd__decap_3
XFILLER_26_58 VPWR VGND VPWR VGND sky130_fd_sc_hd__decap_3
XFILLER_53_264 VPWR VGND VPWR VGND sky130_fd_sc_hd__decap_3
XFILLER_13_128 VPWR VGND VPWR VGND sky130_fd_sc_hd__decap_3
XFILLER_42_24 VPWR VGND VPWR VGND sky130_fd_sc_hd__decap_3
XFILLER_42_35 VPWR VGND VPWR VGND sky130_fd_sc_hd__decap_3
XFILLER_21_150 VPWR VGND VPWR VGND sky130_fd_sc_hd__decap_3
XFILLER_21_172 VPWR VGND VPWR VGND sky130_fd_sc_hd__decap_3
XFILLER_42_68 VPWR VGND VPWR VGND sky130_fd_sc_hd__decap_3
XFILLER_5_349 VPWR VGND VPWR VGND sky130_fd_sc_hd__decap_3
XFILLER_29_261 VPWR VGND VPWR VGND sky130_fd_sc_hd__decap_3
XFILLER_36_209 VPWR VGND VPWR VGND sky130_fd_sc_hd__decap_3
XFILLER_32_404 VPWR VGND VPWR VGND sky130_fd_sc_hd__decap_3
XFILLER_44_253 VPWR VGND VPWR VGND sky130_fd_sc_hd__decap_3
XFILLER_44_242 VPWR VGND VPWR VGND sky130_fd_sc_hd__decap_3
XFILLER_16_80 VPWR VGND VPWR VGND sky130_fd_sc_hd__decap_3
XFILLER_44_286 VPWR VGND VPWR VGND sky130_fd_sc_hd__decap_3
XFILLER_12_150 VPWR VGND VPWR VGND sky130_fd_sc_hd__decap_3
XFILLER_8_121 VPWR VGND VPWR VGND sky130_fd_sc_hd__decap_3
XFILLER_8_165 VPWR VGND VPWR VGND sky130_fd_sc_hd__decap_3
XFILLER_4_360 VPWR VGND VPWR VGND sky130_fd_sc_hd__decap_3
XFILLER_4_393 VPWR VGND VPWR VGND sky130_fd_sc_hd__decap_3
XFILLER_35_231 VPWR VGND VPWR VGND sky130_fd_sc_hd__decap_3
XFILLER_35_220 VPWR VGND VPWR VGND sky130_fd_sc_hd__decap_3
XFILLER_35_264 VPWR VGND VPWR VGND sky130_fd_sc_hd__decap_3
XFILLER_50_212 VPWR VGND VPWR VGND sky130_fd_sc_hd__decap_3
XFILLER_50_245 VPWR VGND VPWR VGND sky130_fd_sc_hd__decap_3
XFILLER_50_256 VPWR VGND VPWR VGND sky130_fd_sc_hd__decap_3
XFILLER_10_109 VPWR VGND VPWR VGND sky130_fd_sc_hd__decap_3
XFILLER_50_289 VPWR VGND VPWR VGND sky130_fd_sc_hd__decap_3
XFILLER_12_38 VPWR VGND VPWR VGND sky130_fd_sc_hd__decap_3
XFILLER_58_312 VPWR VGND VPWR VGND sky130_fd_sc_hd__decap_3
XFILLER_58_301 VPWR VGND VPWR VGND sky130_fd_sc_hd__decap_3
XFILLER_58_345 VPWR VGND VPWR VGND sky130_fd_sc_hd__decap_3
XFILLER_58_389 VPWR VGND VPWR VGND sky130_fd_sc_hd__decap_3
XFILLER_37_46 VPWR VGND VPWR VGND sky130_fd_sc_hd__decap_3
XFILLER_26_253 VPWR VGND VPWR VGND sky130_fd_sc_hd__decap_3
XFILLER_26_242 VPWR VGND VPWR VGND sky130_fd_sc_hd__decap_3
XFILLER_26_286 VPWR VGND VPWR VGND sky130_fd_sc_hd__decap_3
XFILLER_53_12 VPWR VGND VPWR VGND sky130_fd_sc_hd__decap_3
XFILLER_53_78 VPWR VGND VPWR VGND sky130_fd_sc_hd__decap_3
XFILLER_41_234 VPWR VGND VPWR VGND sky130_fd_sc_hd__decap_3
X_271_ VGND VPWR VPWR VGND clknet_2_3__leaf_clk_regs cout_next _016_ net38 _271_/a_1462_47#
+ _271_/a_543_47# _271_/a_651_413# _271_/a_193_47# _271_/a_805_47# _271_/a_448_47#
+ _271_/a_639_47# _271_/a_1283_21# _271_/a_761_289# _271_/a_1108_47# _271_/a_1217_47#
+ _271_/a_1270_413# _271_/a_27_47# sky130_fd_sc_hd__dfrtp_1
XFILLER_41_267 VPWR VGND VPWR VGND sky130_fd_sc_hd__decap_3
XFILLER_5_113 VPWR VGND VPWR VGND sky130_fd_sc_hd__decap_3
XFILLER_5_146 VPWR VGND VPWR VGND sky130_fd_sc_hd__decap_3
XFILLER_1_352 VPWR VGND VPWR VGND sky130_fd_sc_hd__decap_3
XFILLER_49_323 VPWR VGND VPWR VGND sky130_fd_sc_hd__decap_3
XFILLER_1_385 VPWR VGND VPWR VGND sky130_fd_sc_hd__decap_3
XFILLER_64_326 VPWR VGND VPWR VGND sky130_fd_sc_hd__decap_3
XFILLER_49_367 VPWR VGND VPWR VGND sky130_fd_sc_hd__decap_3
XFILLER_64_337 VPWR VGND VPWR VGND sky130_fd_sc_hd__decap_3
XFILLER_27_90 VPWR VGND VPWR VGND sky130_fd_sc_hd__decap_3
XFILLER_32_212 VPWR VGND VPWR VGND sky130_fd_sc_hd__decap_3
XFILLER_32_245 VPWR VGND VPWR VGND sky130_fd_sc_hd__decap_3
XFILLER_32_256 VPWR VGND VPWR VGND sky130_fd_sc_hd__decap_3
XFILLER_32_289 VPWR VGND VPWR VGND sky130_fd_sc_hd__decap_3
XFILLER_4_50 VPWR VGND VPWR VGND sky130_fd_sc_hd__decap_3
XFILLER_4_94 VPWR VGND VPWR VGND sky130_fd_sc_hd__decap_3
XFILLER_55_337 VPWR VGND VPWR VGND sky130_fd_sc_hd__decap_3
XFILLER_55_326 VPWR VGND VPWR VGND sky130_fd_sc_hd__decap_3
XFILLER_63_370 VPWR VGND VPWR VGND sky130_fd_sc_hd__decap_3
XFILLER_23_234 VPWR VGND VPWR VGND sky130_fd_sc_hd__decap_3
XFILLER_23_267 VPWR VGND VPWR VGND sky130_fd_sc_hd__decap_3
XFILLER_2_127 VPWR VGND VPWR VGND sky130_fd_sc_hd__decap_3
XFILLER_48_12 VPWR VGND VPWR VGND sky130_fd_sc_hd__decap_3
XFILLER_58_131 VPWR VGND VPWR VGND sky130_fd_sc_hd__decap_3
XFILLER_58_153 VPWR VGND VPWR VGND sky130_fd_sc_hd__decap_3
XFILLER_46_315 VPWR VGND VPWR VGND sky130_fd_sc_hd__decap_3
XFILLER_46_304 VPWR VGND VPWR VGND sky130_fd_sc_hd__decap_3
XFILLER_58_197 VPWR VGND VPWR VGND sky130_fd_sc_hd__decap_3
XFILLER_58_186 VPWR VGND VPWR VGND sky130_fd_sc_hd__decap_3
XFILLER_64_11 VPWR VGND VPWR VGND sky130_fd_sc_hd__decap_3
XFILLER_46_348 VPWR VGND VPWR VGND sky130_fd_sc_hd__decap_3
XFILLER_64_44 VPWR VGND VPWR VGND sky130_fd_sc_hd__decap_3
XFILLER_61_329 VPWR VGND VPWR VGND sky130_fd_sc_hd__decap_3
XFILLER_64_88 VPWR VGND VPWR VGND sky130_fd_sc_hd__decap_3
XFILLER_64_66 VPWR VGND VPWR VGND sky130_fd_sc_hd__decap_3
XFILLER_54_392 VPWR VGND VPWR VGND sky130_fd_sc_hd__decap_3
X_254_ net56 _049_ VPWR VGND VPWR VGND sky130_fd_sc_hd__inv_2
Xfanout60 VPWR VGND net60 net61 VPWR VGND fanout60/a_27_47# sky130_fd_sc_hd__buf_4
XFILLER_13_81 VPWR VGND VPWR VGND sky130_fd_sc_hd__decap_3
X_185_ VPWR VGND VGND VPWR _097_ genblk1\[12\].fa_inst.b genblk1\[12\].fa_inst.a _185_/a_150_297#
+ _185_/a_68_297# sky130_fd_sc_hd__or2_1
XFILLER_50_9 VPWR VGND VPWR VGND sky130_fd_sc_hd__decap_3
XPHY_EDGE_ROW_19_1_Right_18 VPWR VGND VPWR VGND sky130_fd_sc_hd__decap_3
XPHY_EDGE_ROW_63_Left_169 VPWR VGND VPWR VGND sky130_fd_sc_hd__decap_3
XFILLER_29_6 VPWR VGND VPWR VGND sky130_fd_sc_hd__decap_3
XFILLER_49_131 VPWR VGND VPWR VGND sky130_fd_sc_hd__decap_3
XFILLER_49_164 VPWR VGND VPWR VGND sky130_fd_sc_hd__decap_3
XFILLER_49_175 VPWR VGND VPWR VGND sky130_fd_sc_hd__decap_3
XFILLER_64_134 VPWR VGND VPWR VGND sky130_fd_sc_hd__decap_3
XFILLER_37_326 VPWR VGND VPWR VGND sky130_fd_sc_hd__decap_3
XFILLER_37_337 VPWR VGND VPWR VGND sky130_fd_sc_hd__decap_3
XFILLER_64_156 VPWR VGND VPWR VGND sky130_fd_sc_hd__decap_3
XFILLER_64_178 VPWR VGND VPWR VGND sky130_fd_sc_hd__decap_3
XFILLER_52_318 VPWR VGND VPWR VGND sky130_fd_sc_hd__decap_3
XFILLER_45_370 VPWR VGND VPWR VGND sky130_fd_sc_hd__decap_3
XFILLER_60_351 VPWR VGND VPWR VGND sky130_fd_sc_hd__decap_3
XFILLER_60_395 VPWR VGND VPWR VGND sky130_fd_sc_hd__decap_3
XFILLER_18_15 VPWR VGND VPWR VGND sky130_fd_sc_hd__decap_3
XFILLER_28_304 VPWR VGND VPWR VGND sky130_fd_sc_hd__decap_3
XFILLER_28_315 VPWR VGND VPWR VGND sky130_fd_sc_hd__decap_3
XFILLER_28_348 VPWR VGND VPWR VGND sky130_fd_sc_hd__decap_3
XFILLER_55_134 VPWR VGND VPWR VGND sky130_fd_sc_hd__decap_3
XFILLER_43_329 VPWR VGND VPWR VGND sky130_fd_sc_hd__decap_3
XFILLER_55_178 VPWR VGND VPWR VGND sky130_fd_sc_hd__decap_3
XFILLER_51_340 VPWR VGND VPWR VGND sky130_fd_sc_hd__decap_3
XFILLER_36_392 VPWR VGND VPWR VGND sky130_fd_sc_hd__decap_3
XFILLER_51_373 VPWR VGND VPWR VGND sky130_fd_sc_hd__decap_3
XFILLER_34_47 VPWR VGND VPWR VGND sky130_fd_sc_hd__decap_3
Xclkload2 VGND VPWR clknet_2_3__leaf_clk_regs clkload2/X VPWR VGND clkload2/a_27_47#
+ sky130_fd_sc_hd__clkbuf_4
XFILLER_50_24 VPWR VGND VPWR VGND sky130_fd_sc_hd__decap_3
XFILLER_50_35 VPWR VGND VPWR VGND sky130_fd_sc_hd__decap_3
XFILLER_3_403 VPWR VGND VPWR VGND sky130_fd_sc_hd__decap_3
XFILLER_50_68 VPWR VGND VPWR VGND sky130_fd_sc_hd__decap_3
XFILLER_59_33 VPWR VGND VPWR VGND sky130_fd_sc_hd__decap_3
XFILLER_59_66 VPWR VGND VPWR VGND sky130_fd_sc_hd__decap_3
XFILLER_59_99 VPWR VGND VPWR VGND sky130_fd_sc_hd__decap_3
XFILLER_19_337 VPWR VGND VPWR VGND sky130_fd_sc_hd__decap_3
XFILLER_46_112 VPWR VGND VPWR VGND sky130_fd_sc_hd__decap_3
XFILLER_46_156 VPWR VGND VPWR VGND sky130_fd_sc_hd__decap_3
XFILLER_27_370 VPWR VGND VPWR VGND sky130_fd_sc_hd__decap_3
XFILLER_34_318 VPWR VGND VPWR VGND sky130_fd_sc_hd__decap_3
XFILLER_46_189 VPWR VGND VPWR VGND sky130_fd_sc_hd__decap_3
XFILLER_61_137 VPWR VGND VPWR VGND sky130_fd_sc_hd__decap_3
XFILLER_42_351 VPWR VGND VPWR VGND sky130_fd_sc_hd__decap_3
XFILLER_42_395 VPWR VGND VPWR VGND sky130_fd_sc_hd__decap_3
XFILLER_24_80 VPWR VGND VPWR VGND sky130_fd_sc_hd__decap_3
X_237_ net60 _032_ VPWR VGND VPWR VGND sky130_fd_sc_hd__inv_2
X_168_ VGND VPWR VGND VPWR _084_ _080_ _077_ _078_ _168_/a_215_297# _168_/a_27_413#
+ _168_/a_298_297# _168_/a_382_47# sky130_fd_sc_hd__a21bo_1
XFILLER_27_3 VPWR VGND VPWR VGND sky130_fd_sc_hd__decap_3
XFILLER_37_101 VPWR VGND VPWR VGND sky130_fd_sc_hd__decap_3
XFILLER_1_51 VPWR VGND VPWR VGND sky130_fd_sc_hd__decap_3
XFILLER_37_134 VPWR VGND VPWR VGND sky130_fd_sc_hd__decap_3
XFILLER_1_84 VPWR VGND VPWR VGND sky130_fd_sc_hd__decap_3
XFILLER_37_178 VPWR VGND VPWR VGND sky130_fd_sc_hd__decap_3
XFILLER_25_329 VPWR VGND VPWR VGND sky130_fd_sc_hd__decap_3
XFILLER_18_381 VPWR VGND VPWR VGND sky130_fd_sc_hd__decap_3
XFILLER_52_137 VPWR VGND VPWR VGND sky130_fd_sc_hd__decap_3
XFILLER_52_159 VPWR VGND VPWR VGND sky130_fd_sc_hd__decap_3
XFILLER_33_340 VPWR VGND VPWR VGND sky130_fd_sc_hd__decap_3
XFILLER_33_373 VPWR VGND VPWR VGND sky130_fd_sc_hd__decap_3
XFILLER_60_192 VPWR VGND VPWR VGND sky130_fd_sc_hd__decap_3
XFILLER_20_38 VPWR VGND VPWR VGND sky130_fd_sc_hd__decap_3
XFILLER_29_36 VPWR VGND VPWR VGND sky130_fd_sc_hd__decap_3
XFILLER_29_69 VPWR VGND VPWR VGND sky130_fd_sc_hd__decap_3
XFILLER_28_123 VPWR VGND VPWR VGND sky130_fd_sc_hd__decap_3
XFILLER_28_189 VPWR VGND VPWR VGND sky130_fd_sc_hd__decap_3
XFILLER_45_79 VPWR VGND VPWR VGND sky130_fd_sc_hd__decap_3
XFILLER_43_137 VPWR VGND VPWR VGND sky130_fd_sc_hd__decap_3
XFILLER_24_351 VPWR VGND VPWR VGND sky130_fd_sc_hd__decap_3
XFILLER_61_12 VPWR VGND VPWR VGND sky130_fd_sc_hd__decap_3
XFILLER_24_395 VPWR VGND VPWR VGND sky130_fd_sc_hd__decap_3
XFILLER_51_181 VPWR VGND VPWR VGND sky130_fd_sc_hd__decap_3
XFILLER_61_45 VPWR VGND VPWR VGND sky130_fd_sc_hd__decap_3
XFILLER_61_78 VPWR VGND VPWR VGND sky130_fd_sc_hd__decap_3
XFILLER_6_18 VPWR VGND VPWR VGND sky130_fd_sc_hd__decap_3
XFILLER_6_29 VPWR VGND VPWR VGND sky130_fd_sc_hd__decap_3
XFILLER_59_281 VPWR VGND VPWR VGND sky130_fd_sc_hd__decap_3
XFILLER_59_270 VPWR VGND VPWR VGND sky130_fd_sc_hd__decap_3
XFILLER_13_9 VPWR VGND VPWR VGND sky130_fd_sc_hd__decap_3
XPHY_EDGE_ROW_8_2_Right_94 VPWR VGND VPWR VGND sky130_fd_sc_hd__decap_3
XFILLER_19_134 VPWR VGND VPWR VGND sky130_fd_sc_hd__decap_3
XFILLER_34_115 VPWR VGND VPWR VGND sky130_fd_sc_hd__decap_3
XFILLER_15_340 VPWR VGND VPWR VGND sky130_fd_sc_hd__decap_3
XFILLER_34_159 VPWR VGND VPWR VGND sky130_fd_sc_hd__decap_3
XFILLER_15_373 VPWR VGND VPWR VGND sky130_fd_sc_hd__decap_3
XFILLER_35_90 VPWR VGND VPWR VGND sky130_fd_sc_hd__decap_3
XFILLER_30_321 VPWR VGND VPWR VGND sky130_fd_sc_hd__decap_3
XFILLER_30_354 VPWR VGND VPWR VGND sky130_fd_sc_hd__decap_3
XFILLER_42_192 VPWR VGND VPWR VGND sky130_fd_sc_hd__decap_3
XFILLER_30_365 VPWR VGND VPWR VGND sky130_fd_sc_hd__decap_3
XFILLER_30_398 VPWR VGND VPWR VGND sky130_fd_sc_hd__decap_3
XFILLER_25_137 VPWR VGND VPWR VGND sky130_fd_sc_hd__decap_3
XFILLER_15_49 VPWR VGND VPWR VGND sky130_fd_sc_hd__decap_3
XFILLER_33_181 VPWR VGND VPWR VGND sky130_fd_sc_hd__decap_3
XFILLER_21_321 VPWR VGND VPWR VGND sky130_fd_sc_hd__decap_3
XFILLER_40_118 VPWR VGND VPWR VGND sky130_fd_sc_hd__decap_3
XFILLER_21_343 VPWR VGND VPWR VGND sky130_fd_sc_hd__decap_3
XFILLER_31_15 VPWR VGND VPWR VGND sky130_fd_sc_hd__decap_3
XFILLER_21_365 VPWR VGND VPWR VGND sky130_fd_sc_hd__decap_3
Xoutput48 VPWR VGND s[3] net48 VPWR VGND output48/a_27_47# sky130_fd_sc_hd__buf_2
XFILLER_56_12 VPWR VGND VPWR VGND sky130_fd_sc_hd__decap_3
XFILLER_48_218 VPWR VGND VPWR VGND sky130_fd_sc_hd__decap_3
XFILLER_56_56 VPWR VGND VPWR VGND sky130_fd_sc_hd__decap_3
XFILLER_56_262 VPWR VGND VPWR VGND sky130_fd_sc_hd__decap_3
XFILLER_16_137 VPWR VGND VPWR VGND sky130_fd_sc_hd__decap_3
XFILLER_16_159 VPWR VGND VPWR VGND sky130_fd_sc_hd__decap_3
XFILLER_12_354 VPWR VGND VPWR VGND sky130_fd_sc_hd__decap_3
XFILLER_12_343 VPWR VGND VPWR VGND sky130_fd_sc_hd__decap_3
XFILLER_24_192 VPWR VGND VPWR VGND sky130_fd_sc_hd__decap_3
XFILLER_12_387 VPWR VGND VPWR VGND sky130_fd_sc_hd__decap_3
XFILLER_8_369 VPWR VGND VPWR VGND sky130_fd_sc_hd__decap_3
XFILLER_11_6 VPWR VGND VPWR VGND sky130_fd_sc_hd__decap_3
XFILLER_47_240 VPWR VGND VPWR VGND sky130_fd_sc_hd__decap_3
XFILLER_35_402 VPWR VGND VPWR VGND sky130_fd_sc_hd__decap_3
XFILLER_47_273 VPWR VGND VPWR VGND sky130_fd_sc_hd__decap_3
XFILLER_62_221 VPWR VGND VPWR VGND sky130_fd_sc_hd__decap_3
XFILLER_47_284 VPWR VGND VPWR VGND sky130_fd_sc_hd__decap_3
XFILLER_62_265 VPWR VGND VPWR VGND sky130_fd_sc_hd__decap_3
XFILLER_62_298 VPWR VGND VPWR VGND sky130_fd_sc_hd__decap_3
XFILLER_22_118 VPWR VGND VPWR VGND sky130_fd_sc_hd__decap_3
XFILLER_30_162 VPWR VGND VPWR VGND sky130_fd_sc_hd__decap_3
XFILLER_7_391 VPWR VGND VPWR VGND sky130_fd_sc_hd__decap_3
XFILLER_7_94 VPWR VGND VPWR VGND sky130_fd_sc_hd__decap_3
XFILLER_26_15 VPWR VGND VPWR VGND sky130_fd_sc_hd__decap_3
XFILLER_38_262 VPWR VGND VPWR VGND sky130_fd_sc_hd__decap_3
XFILLER_38_295 VPWR VGND VPWR VGND sky130_fd_sc_hd__decap_3
XFILLER_53_243 VPWR VGND VPWR VGND sky130_fd_sc_hd__decap_3
XPHY_EDGE_ROW_24_Right_45 VPWR VGND VPWR VGND sky130_fd_sc_hd__decap_3
XFILLER_53_276 VPWR VGND VPWR VGND sky130_fd_sc_hd__decap_3
XFILLER_53_287 VPWR VGND VPWR VGND sky130_fd_sc_hd__decap_3
XFILLER_21_162 VPWR VGND VPWR VGND sky130_fd_sc_hd__decap_3
XFILLER_42_47 VPWR VGND VPWR VGND sky130_fd_sc_hd__decap_3
XFILLER_21_184 VPWR VGND VPWR VGND sky130_fd_sc_hd__decap_3
XPHY_EDGE_ROW_33_Right_54 VPWR VGND VPWR VGND sky130_fd_sc_hd__decap_3
XFILLER_29_240 VPWR VGND VPWR VGND sky130_fd_sc_hd__decap_3
XFILLER_29_273 VPWR VGND VPWR VGND sky130_fd_sc_hd__decap_3
XPHY_EDGE_ROW_42_Right_63 VPWR VGND VPWR VGND sky130_fd_sc_hd__decap_3
XFILLER_29_284 VPWR VGND VPWR VGND sky130_fd_sc_hd__decap_3
XFILLER_44_221 VPWR VGND VPWR VGND sky130_fd_sc_hd__decap_3
XFILLER_44_265 VPWR VGND VPWR VGND sky130_fd_sc_hd__decap_3
XFILLER_44_298 VPWR VGND VPWR VGND sky130_fd_sc_hd__decap_3
XFILLER_12_162 VPWR VGND VPWR VGND sky130_fd_sc_hd__decap_3
XFILLER_8_144 VPWR VGND VPWR VGND sky130_fd_sc_hd__decap_3
XFILLER_8_133 VPWR VGND VPWR VGND sky130_fd_sc_hd__decap_3
XFILLER_8_177 VPWR VGND VPWR VGND sky130_fd_sc_hd__decap_3
XPHY_EDGE_ROW_51_Right_72 VPWR VGND VPWR VGND sky130_fd_sc_hd__decap_3
XFILLER_59_6 VPWR VGND VPWR VGND sky130_fd_sc_hd__decap_3
XFILLER_4_372 VPWR VGND VPWR VGND sky130_fd_sc_hd__decap_3
XPHY_EDGE_ROW_60_Right_81 VPWR VGND VPWR VGND sky130_fd_sc_hd__decap_3
XFILLER_35_243 VPWR VGND VPWR VGND sky130_fd_sc_hd__decap_3
XFILLER_35_276 VPWR VGND VPWR VGND sky130_fd_sc_hd__decap_3
XFILLER_35_287 VPWR VGND VPWR VGND sky130_fd_sc_hd__decap_3
XFILLER_50_224 VPWR VGND VPWR VGND sky130_fd_sc_hd__decap_3
XFILLER_50_268 VPWR VGND VPWR VGND sky130_fd_sc_hd__decap_3
XFILLER_58_324 VPWR VGND VPWR VGND sky130_fd_sc_hd__decap_3
XFILLER_58_357 VPWR VGND VPWR VGND sky130_fd_sc_hd__decap_3
XFILLER_58_368 VPWR VGND VPWR VGND sky130_fd_sc_hd__decap_3
XFILLER_26_221 VPWR VGND VPWR VGND sky130_fd_sc_hd__decap_3
XFILLER_26_265 VPWR VGND VPWR VGND sky130_fd_sc_hd__decap_3
XFILLER_26_298 VPWR VGND VPWR VGND sky130_fd_sc_hd__decap_3
XFILLER_41_202 VPWR VGND VPWR VGND sky130_fd_sc_hd__decap_3
XFILLER_53_57 VPWR VGND VPWR VGND sky130_fd_sc_hd__decap_3
XFILLER_53_46 VPWR VGND VPWR VGND sky130_fd_sc_hd__decap_3
XFILLER_41_246 VPWR VGND VPWR VGND sky130_fd_sc_hd__decap_3
X_270_ VGND VPWR VPWR VGND clknet_2_3__leaf_clk_regs genblk1\[15\].fa_inst.s _015_
+ net45 _270_/a_1462_47# _270_/a_543_47# _270_/a_651_413# _270_/a_193_47# _270_/a_805_47#
+ _270_/a_448_47# _270_/a_639_47# _270_/a_1283_21# _270_/a_761_289# _270_/a_1108_47#
+ _270_/a_1217_47# _270_/a_1270_413# _270_/a_27_47# sky130_fd_sc_hd__dfrtp_1
XFILLER_5_103 VPWR VGND VPWR VGND sky130_fd_sc_hd__decap_3
XFILLER_5_125 VPWR VGND VPWR VGND sky130_fd_sc_hd__decap_3
XFILLER_5_169 VPWR VGND VPWR VGND sky130_fd_sc_hd__decap_3
XFILLER_5_158 VPWR VGND VPWR VGND sky130_fd_sc_hd__decap_3
XFILLER_1_331 VPWR VGND VPWR VGND sky130_fd_sc_hd__decap_3
XFILLER_49_302 VPWR VGND VPWR VGND sky130_fd_sc_hd__decap_3
XFILLER_1_364 VPWR VGND VPWR VGND sky130_fd_sc_hd__decap_3
XFILLER_49_346 VPWR VGND VPWR VGND sky130_fd_sc_hd__decap_3
XFILLER_1_397 VPWR VGND VPWR VGND sky130_fd_sc_hd__decap_3
XFILLER_64_305 VPWR VGND VPWR VGND sky130_fd_sc_hd__decap_3
XFILLER_49_379 VPWR VGND VPWR VGND sky130_fd_sc_hd__decap_3
XFILLER_64_349 VPWR VGND VPWR VGND sky130_fd_sc_hd__decap_3
XFILLER_32_224 VPWR VGND VPWR VGND sky130_fd_sc_hd__decap_3
XFILLER_32_268 VPWR VGND VPWR VGND sky130_fd_sc_hd__decap_3
XFILLER_57_3 VPWR VGND VPWR VGND sky130_fd_sc_hd__decap_3
XFILLER_55_305 VPWR VGND VPWR VGND sky130_fd_sc_hd__decap_3
XFILLER_55_349 VPWR VGND VPWR VGND sky130_fd_sc_hd__decap_3
XFILLER_63_382 VPWR VGND VPWR VGND sky130_fd_sc_hd__decap_3
XFILLER_23_202 VPWR VGND VPWR VGND sky130_fd_sc_hd__decap_3
XFILLER_63_393 VPWR VGND VPWR VGND sky130_fd_sc_hd__decap_3
XFILLER_23_246 VPWR VGND VPWR VGND sky130_fd_sc_hd__decap_3
XFILLER_31_290 VPWR VGND VPWR VGND sky130_fd_sc_hd__decap_3
XFILLER_2_106 VPWR VGND VPWR VGND sky130_fd_sc_hd__decap_3
XFILLER_48_24 VPWR VGND VPWR VGND sky130_fd_sc_hd__decap_3
XFILLER_58_165 VPWR VGND VPWR VGND sky130_fd_sc_hd__decap_3
XFILLER_46_327 VPWR VGND VPWR VGND sky130_fd_sc_hd__decap_3
XFILLER_61_308 VPWR VGND VPWR VGND sky130_fd_sc_hd__decap_3
XFILLER_64_23 VPWR VGND VPWR VGND sky130_fd_sc_hd__decap_3
XFILLER_64_78 VPWR VGND VPWR VGND sky130_fd_sc_hd__decap_3
XFILLER_54_371 VPWR VGND VPWR VGND sky130_fd_sc_hd__decap_3
XFILLER_54_360 VPWR VGND VPWR VGND sky130_fd_sc_hd__decap_3
Xfanout61 VPWR VGND net61 net62 VPWR VGND fanout61/a_27_47# sky130_fd_sc_hd__buf_2
X_253_ net60 _048_ VPWR VGND VPWR VGND sky130_fd_sc_hd__inv_2
XFILLER_13_60 VPWR VGND VPWR VGND sky130_fd_sc_hd__decap_3
X_184_ VGND VPWR _096_ genblk1\[11\].fa_inst.s _095_ VPWR VGND _184_/a_129_47# _184_/a_47_47#
+ _184_/a_285_47# _184_/a_377_297# sky130_fd_sc_hd__xnor2_1
XFILLER_43_9 VPWR VGND VPWR VGND sky130_fd_sc_hd__decap_3
XFILLER_1_161 VPWR VGND VPWR VGND sky130_fd_sc_hd__decap_3
XFILLER_1_172 VPWR VGND VPWR VGND sky130_fd_sc_hd__decap_3
XFILLER_37_305 VPWR VGND VPWR VGND sky130_fd_sc_hd__decap_3
XFILLER_49_143 VPWR VGND VPWR VGND sky130_fd_sc_hd__decap_3
XFILLER_64_113 VPWR VGND VPWR VGND sky130_fd_sc_hd__decap_3
XFILLER_37_349 VPWR VGND VPWR VGND sky130_fd_sc_hd__decap_3
XFILLER_49_187 VPWR VGND VPWR VGND sky130_fd_sc_hd__decap_3
XFILLER_60_330 VPWR VGND VPWR VGND sky130_fd_sc_hd__decap_3
XFILLER_45_393 VPWR VGND VPWR VGND sky130_fd_sc_hd__decap_3
XFILLER_45_382 VPWR VGND VPWR VGND sky130_fd_sc_hd__decap_3
XFILLER_60_374 VPWR VGND VPWR VGND sky130_fd_sc_hd__decap_3
XFILLER_18_38 VPWR VGND VPWR VGND sky130_fd_sc_hd__decap_3
XFILLER_28_327 VPWR VGND VPWR VGND sky130_fd_sc_hd__decap_3
XFILLER_55_102 VPWR VGND VPWR VGND sky130_fd_sc_hd__decap_3
XFILLER_55_113 VPWR VGND VPWR VGND sky130_fd_sc_hd__decap_3
XFILLER_43_308 VPWR VGND VPWR VGND sky130_fd_sc_hd__decap_3
XFILLER_55_146 VPWR VGND VPWR VGND sky130_fd_sc_hd__decap_3
XFILLER_36_360 VPWR VGND VPWR VGND sky130_fd_sc_hd__decap_3
XFILLER_36_371 VPWR VGND VPWR VGND sky130_fd_sc_hd__decap_3
XFILLER_63_190 VPWR VGND VPWR VGND sky130_fd_sc_hd__decap_3
XFILLER_34_15 VPWR VGND VPWR VGND sky130_fd_sc_hd__decap_3
XFILLER_51_352 VPWR VGND VPWR VGND sky130_fd_sc_hd__decap_3
XFILLER_34_59 VPWR VGND VPWR VGND sky130_fd_sc_hd__decap_3
XFILLER_51_396 VPWR VGND VPWR VGND sky130_fd_sc_hd__decap_3
XFILLER_51_385 VPWR VGND VPWR VGND sky130_fd_sc_hd__decap_3
XPHY_EDGE_ROW_3_2_Left_24 VPWR VGND VPWR VGND sky130_fd_sc_hd__decap_3
XFILLER_50_47 VPWR VGND VPWR VGND sky130_fd_sc_hd__decap_3
XFILLER_59_12 VPWR VGND VPWR VGND sky130_fd_sc_hd__decap_3
XFILLER_59_45 VPWR VGND VPWR VGND sky130_fd_sc_hd__decap_3
XFILLER_59_78 VPWR VGND VPWR VGND sky130_fd_sc_hd__decap_3
XFILLER_46_124 VPWR VGND VPWR VGND sky130_fd_sc_hd__decap_3
XFILLER_19_349 VPWR VGND VPWR VGND sky130_fd_sc_hd__decap_3
XFILLER_61_116 VPWR VGND VPWR VGND sky130_fd_sc_hd__decap_3
XFILLER_61_105 VPWR VGND VPWR VGND sky130_fd_sc_hd__decap_3
XFILLER_46_168 VPWR VGND VPWR VGND sky130_fd_sc_hd__decap_3
XFILLER_61_149 VPWR VGND VPWR VGND sky130_fd_sc_hd__decap_3
XFILLER_42_330 VPWR VGND VPWR VGND sky130_fd_sc_hd__decap_3
XFILLER_27_382 VPWR VGND VPWR VGND sky130_fd_sc_hd__decap_3
XFILLER_27_393 VPWR VGND VPWR VGND sky130_fd_sc_hd__decap_3
XFILLER_42_374 VPWR VGND VPWR VGND sky130_fd_sc_hd__decap_3
X_236_ net60 _031_ VPWR VGND VPWR VGND sky130_fd_sc_hd__inv_2
X_167_ VPWR VGND VGND VPWR _081_ _083_ _082_ _167_/a_113_47# sky130_fd_sc_hd__nand2_1
XFILLER_41_6 VPWR VGND VPWR VGND sky130_fd_sc_hd__decap_3
XFILLER_1_30 VPWR VGND VPWR VGND sky130_fd_sc_hd__decap_3
XFILLER_37_113 VPWR VGND VPWR VGND sky130_fd_sc_hd__decap_3
XFILLER_1_63 VPWR VGND VPWR VGND sky130_fd_sc_hd__decap_3
XFILLER_37_146 VPWR VGND VPWR VGND sky130_fd_sc_hd__decap_3
XFILLER_1_96 VPWR VGND VPWR VGND sky130_fd_sc_hd__decap_3
XFILLER_18_360 VPWR VGND VPWR VGND sky130_fd_sc_hd__decap_3
XFILLER_25_308 VPWR VGND VPWR VGND sky130_fd_sc_hd__decap_3
XFILLER_18_393 VPWR VGND VPWR VGND sky130_fd_sc_hd__decap_3
XFILLER_45_190 VPWR VGND VPWR VGND sky130_fd_sc_hd__decap_3
XFILLER_33_352 VPWR VGND VPWR VGND sky130_fd_sc_hd__decap_3
XFILLER_60_171 VPWR VGND VPWR VGND sky130_fd_sc_hd__decap_3
XFILLER_33_385 VPWR VGND VPWR VGND sky130_fd_sc_hd__decap_3
XFILLER_33_396 VPWR VGND VPWR VGND sky130_fd_sc_hd__decap_3
XFILLER_28_135 VPWR VGND VPWR VGND sky130_fd_sc_hd__decap_3
XFILLER_28_168 VPWR VGND VPWR VGND sky130_fd_sc_hd__decap_3
XFILLER_45_47 VPWR VGND VPWR VGND sky130_fd_sc_hd__decap_3
XFILLER_43_116 VPWR VGND VPWR VGND sky130_fd_sc_hd__decap_3
XFILLER_24_330 VPWR VGND VPWR VGND sky130_fd_sc_hd__decap_3
XFILLER_43_149 VPWR VGND VPWR VGND sky130_fd_sc_hd__decap_3
XFILLER_61_24 VPWR VGND VPWR VGND sky130_fd_sc_hd__decap_3
XFILLER_24_374 VPWR VGND VPWR VGND sky130_fd_sc_hd__decap_3
XFILLER_61_57 VPWR VGND VPWR VGND sky130_fd_sc_hd__decap_3
XFILLER_51_193 VPWR VGND VPWR VGND sky130_fd_sc_hd__decap_3
XFILLER_10_94 VPWR VGND VPWR VGND sky130_fd_sc_hd__decap_3
XFILLER_19_113 VPWR VGND VPWR VGND sky130_fd_sc_hd__decap_3
XFILLER_59_293 VPWR VGND VPWR VGND sky130_fd_sc_hd__decap_3
XFILLER_19_81 VPWR VGND VPWR VGND sky130_fd_sc_hd__decap_3
XFILLER_19_146 VPWR VGND VPWR VGND sky130_fd_sc_hd__decap_3
XFILLER_34_127 VPWR VGND VPWR VGND sky130_fd_sc_hd__decap_3
XFILLER_15_352 VPWR VGND VPWR VGND sky130_fd_sc_hd__decap_3
XFILLER_27_190 VPWR VGND VPWR VGND sky130_fd_sc_hd__decap_3
XFILLER_15_385 VPWR VGND VPWR VGND sky130_fd_sc_hd__decap_3
XFILLER_42_171 VPWR VGND VPWR VGND sky130_fd_sc_hd__decap_3
XFILLER_30_333 VPWR VGND VPWR VGND sky130_fd_sc_hd__decap_3
XFILLER_30_377 VPWR VGND VPWR VGND sky130_fd_sc_hd__decap_3
X_219_ net61 _014_ VPWR VGND VPWR VGND sky130_fd_sc_hd__inv_2
XFILLER_57_208 VPWR VGND VPWR VGND sky130_fd_sc_hd__decap_3
XFILLER_25_116 VPWR VGND VPWR VGND sky130_fd_sc_hd__decap_3
XFILLER_25_149 VPWR VGND VPWR VGND sky130_fd_sc_hd__decap_3
XFILLER_33_193 VPWR VGND VPWR VGND sky130_fd_sc_hd__decap_3
XFILLER_21_333 VPWR VGND VPWR VGND sky130_fd_sc_hd__decap_3
XFILLER_21_355 VPWR VGND VPWR VGND sky130_fd_sc_hd__decap_3
XFILLER_21_377 VPWR VGND VPWR VGND sky130_fd_sc_hd__decap_3
XFILLER_31_38 VPWR VGND VPWR VGND sky130_fd_sc_hd__decap_3
XFILLER_21_399 VPWR VGND VPWR VGND sky130_fd_sc_hd__decap_3
Xoutput38 VPWR VGND cout net38 VPWR VGND output38/a_27_47# sky130_fd_sc_hd__buf_2
Xoutput49 VPWR VGND s[4] net49 VPWR VGND output49/a_27_47# sky130_fd_sc_hd__buf_2
XFILLER_56_35 VPWR VGND VPWR VGND sky130_fd_sc_hd__decap_3
XFILLER_56_230 VPWR VGND VPWR VGND sky130_fd_sc_hd__decap_3
XFILLER_56_68 VPWR VGND VPWR VGND sky130_fd_sc_hd__decap_3
XFILLER_56_274 VPWR VGND VPWR VGND sky130_fd_sc_hd__decap_3
XFILLER_16_116 VPWR VGND VPWR VGND sky130_fd_sc_hd__decap_3
XFILLER_24_171 VPWR VGND VPWR VGND sky130_fd_sc_hd__decap_3
XFILLER_31_108 VPWR VGND VPWR VGND sky130_fd_sc_hd__decap_3
XFILLER_31_119 VPWR VGND VPWR VGND sky130_fd_sc_hd__decap_3
XFILLER_12_366 VPWR VGND VPWR VGND sky130_fd_sc_hd__decap_3
XFILLER_8_337 VPWR VGND VPWR VGND sky130_fd_sc_hd__decap_3
XFILLER_12_399 VPWR VGND VPWR VGND sky130_fd_sc_hd__decap_3
XFILLER_21_71 VPWR VGND VPWR VGND sky130_fd_sc_hd__decap_3
XFILLER_39_208 VPWR VGND VPWR VGND sky130_fd_sc_hd__decap_3
XFILLER_47_252 VPWR VGND VPWR VGND sky130_fd_sc_hd__decap_3
XFILLER_62_233 VPWR VGND VPWR VGND sky130_fd_sc_hd__decap_3
XFILLER_62_200 VPWR VGND VPWR VGND sky130_fd_sc_hd__decap_3
XFILLER_47_296 VPWR VGND VPWR VGND sky130_fd_sc_hd__decap_3
XFILLER_62_277 VPWR VGND VPWR VGND sky130_fd_sc_hd__decap_3
XFILLER_30_130 VPWR VGND VPWR VGND sky130_fd_sc_hd__decap_3
Xclkbuf_0_clk VGND VPWR VGND VPWR clk clknet_0_clk clkbuf_0_clk/a_110_47# sky130_fd_sc_hd__clkbuf_16
XFILLER_30_141 VPWR VGND VPWR VGND sky130_fd_sc_hd__decap_3
XFILLER_30_174 VPWR VGND VPWR VGND sky130_fd_sc_hd__decap_3
XFILLER_7_370 VPWR VGND VPWR VGND sky130_fd_sc_hd__decap_3
XFILLER_38_230 VPWR VGND VPWR VGND sky130_fd_sc_hd__decap_3
XFILLER_26_38 VPWR VGND VPWR VGND sky130_fd_sc_hd__decap_3
XFILLER_38_274 VPWR VGND VPWR VGND sky130_fd_sc_hd__decap_3
XFILLER_53_211 VPWR VGND VPWR VGND sky130_fd_sc_hd__decap_3
XFILLER_53_255 VPWR VGND VPWR VGND sky130_fd_sc_hd__decap_3
XFILLER_53_299 VPWR VGND VPWR VGND sky130_fd_sc_hd__decap_3
XFILLER_13_119 VPWR VGND VPWR VGND sky130_fd_sc_hd__decap_3
XFILLER_42_15 VPWR VGND VPWR VGND sky130_fd_sc_hd__decap_3
XFILLER_21_141 VPWR VGND VPWR VGND sky130_fd_sc_hd__decap_3
XFILLER_42_59 VPWR VGND VPWR VGND sky130_fd_sc_hd__decap_3
XFILLER_29_252 VPWR VGND VPWR VGND sky130_fd_sc_hd__decap_3
XFILLER_29_296 VPWR VGND VPWR VGND sky130_fd_sc_hd__decap_3
XFILLER_44_200 VPWR VGND VPWR VGND sky130_fd_sc_hd__decap_3
XFILLER_44_233 VPWR VGND VPWR VGND sky130_fd_sc_hd__decap_3
XFILLER_16_71 VPWR VGND VPWR VGND sky130_fd_sc_hd__decap_3
XFILLER_44_277 VPWR VGND VPWR VGND sky130_fd_sc_hd__decap_3
XFILLER_12_141 VPWR VGND VPWR VGND sky130_fd_sc_hd__decap_3
XFILLER_12_130 VPWR VGND VPWR VGND sky130_fd_sc_hd__decap_3
XFILLER_12_174 VPWR VGND VPWR VGND sky130_fd_sc_hd__decap_3
XFILLER_8_156 VPWR VGND VPWR VGND sky130_fd_sc_hd__decap_3
XFILLER_32_81 VPWR VGND VPWR VGND sky130_fd_sc_hd__decap_3
XFILLER_4_340 VPWR VGND VPWR VGND sky130_fd_sc_hd__decap_3
XFILLER_4_384 VPWR VGND VPWR VGND sky130_fd_sc_hd__decap_3
XFILLER_35_211 VPWR VGND VPWR VGND sky130_fd_sc_hd__decap_3
XFILLER_35_255 VPWR VGND VPWR VGND sky130_fd_sc_hd__decap_3
XFILLER_50_203 VPWR VGND VPWR VGND sky130_fd_sc_hd__decap_3
XFILLER_35_299 VPWR VGND VPWR VGND sky130_fd_sc_hd__decap_3
XFILLER_50_236 VPWR VGND VPWR VGND sky130_fd_sc_hd__decap_3
XFILLER_12_29 VPWR VGND VPWR VGND sky130_fd_sc_hd__decap_3
XFILLER_58_336 VPWR VGND VPWR VGND sky130_fd_sc_hd__decap_3
XFILLER_37_37 VPWR VGND VPWR VGND sky130_fd_sc_hd__decap_3
XFILLER_26_200 VPWR VGND VPWR VGND sky130_fd_sc_hd__decap_3
XFILLER_26_233 VPWR VGND VPWR VGND sky130_fd_sc_hd__decap_3
XFILLER_26_277 VPWR VGND VPWR VGND sky130_fd_sc_hd__decap_3
XFILLER_41_214 VPWR VGND VPWR VGND sky130_fd_sc_hd__decap_3
XFILLER_53_69 VPWR VGND VPWR VGND sky130_fd_sc_hd__decap_3
XFILLER_41_225 VPWR VGND VPWR VGND sky130_fd_sc_hd__decap_3
XFILLER_41_258 VPWR VGND VPWR VGND sky130_fd_sc_hd__decap_3
XFILLER_5_137 VPWR VGND VPWR VGND sky130_fd_sc_hd__decap_3
XFILLER_1_343 VPWR VGND VPWR VGND sky130_fd_sc_hd__decap_3
XFILLER_49_314 VPWR VGND VPWR VGND sky130_fd_sc_hd__decap_3
XFILLER_1_376 VPWR VGND VPWR VGND sky130_fd_sc_hd__decap_3
XFILLER_64_317 VPWR VGND VPWR VGND sky130_fd_sc_hd__decap_3
XFILLER_49_358 VPWR VGND VPWR VGND sky130_fd_sc_hd__decap_3
XFILLER_27_81 VPWR VGND VPWR VGND sky130_fd_sc_hd__decap_3
XFILLER_32_203 VPWR VGND VPWR VGND sky130_fd_sc_hd__decap_3
XFILLER_32_236 VPWR VGND VPWR VGND sky130_fd_sc_hd__decap_3
XFILLER_40_280 VPWR VGND VPWR VGND sky130_fd_sc_hd__decap_3
XFILLER_4_41 VPWR VGND VPWR VGND sky130_fd_sc_hd__decap_3
XFILLER_4_74 VPWR VGND VPWR VGND sky130_fd_sc_hd__decap_3
XFILLER_4_85 VPWR VGND VPWR VGND sky130_fd_sc_hd__decap_3
XFILLER_55_317 VPWR VGND VPWR VGND sky130_fd_sc_hd__decap_3
XFILLER_48_380 VPWR VGND VPWR VGND sky130_fd_sc_hd__decap_3
XPHY_EDGE_ROW_13_2_Right_99 VPWR VGND VPWR VGND sky130_fd_sc_hd__decap_3
XFILLER_63_361 VPWR VGND VPWR VGND sky130_fd_sc_hd__decap_3
XFILLER_23_214 VPWR VGND VPWR VGND sky130_fd_sc_hd__decap_3
XFILLER_23_225 VPWR VGND VPWR VGND sky130_fd_sc_hd__decap_3
XFILLER_23_258 VPWR VGND VPWR VGND sky130_fd_sc_hd__decap_3
XFILLER_2_118 VPWR VGND VPWR VGND sky130_fd_sc_hd__decap_3
XFILLER_58_122 VPWR VGND VPWR VGND sky130_fd_sc_hd__decap_3
XFILLER_58_144 VPWR VGND VPWR VGND sky130_fd_sc_hd__decap_3
XFILLER_58_177 VPWR VGND VPWR VGND sky130_fd_sc_hd__decap_3
XFILLER_46_339 VPWR VGND VPWR VGND sky130_fd_sc_hd__decap_3
XFILLER_64_35 VPWR VGND VPWR VGND sky130_fd_sc_hd__decap_3
XFILLER_64_57 VPWR VGND VPWR VGND sky130_fd_sc_hd__decap_3
XFILLER_54_383 VPWR VGND VPWR VGND sky130_fd_sc_hd__decap_3
Xfanout62 net62 net37 VPWR VGND VGND VPWR fanout62/a_110_47# sky130_fd_sc_hd__clkbuf_8
X_252_ net60 _047_ VPWR VGND VPWR VGND sky130_fd_sc_hd__inv_2
XFILLER_6_402 VPWR VGND VPWR VGND sky130_fd_sc_hd__decap_3
XFILLER_22_280 VPWR VGND VPWR VGND sky130_fd_sc_hd__decap_3
X_183_ VGND VPWR VGND VPWR _096_ _092_ _089_ _090_ _183_/a_215_297# _183_/a_27_413#
+ _183_/a_298_297# _183_/a_382_47# sky130_fd_sc_hd__a21bo_1
XFILLER_13_72 VPWR VGND VPWR VGND sky130_fd_sc_hd__decap_3
XFILLER_1_140 VPWR VGND VPWR VGND sky130_fd_sc_hd__decap_3
XFILLER_36_9 VPWR VGND VPWR VGND sky130_fd_sc_hd__decap_3
XFILLER_49_100 VPWR VGND VPWR VGND sky130_fd_sc_hd__decap_3
XFILLER_49_122 VPWR VGND VPWR VGND sky130_fd_sc_hd__decap_3
XFILLER_49_155 VPWR VGND VPWR VGND sky130_fd_sc_hd__decap_3
XFILLER_64_125 VPWR VGND VPWR VGND sky130_fd_sc_hd__decap_3
XFILLER_64_103 VPWR VGND VPWR VGND sky130_fd_sc_hd__decap_3
XFILLER_37_317 VPWR VGND VPWR VGND sky130_fd_sc_hd__decap_3
XFILLER_49_199 VPWR VGND VPWR VGND sky130_fd_sc_hd__decap_3
XFILLER_64_147 VPWR VGND VPWR VGND sky130_fd_sc_hd__decap_3
XFILLER_38_91 VPWR VGND VPWR VGND sky130_fd_sc_hd__decap_3
XFILLER_64_169 VPWR VGND VPWR VGND sky130_fd_sc_hd__decap_3
XFILLER_52_309 VPWR VGND VPWR VGND sky130_fd_sc_hd__decap_3
XFILLER_45_361 VPWR VGND VPWR VGND sky130_fd_sc_hd__decap_3
XFILLER_60_342 VPWR VGND VPWR VGND sky130_fd_sc_hd__decap_3
XFILLER_60_386 VPWR VGND VPWR VGND sky130_fd_sc_hd__decap_3
XFILLER_28_339 VPWR VGND VPWR VGND sky130_fd_sc_hd__decap_3
XFILLER_55_125 VPWR VGND VPWR VGND sky130_fd_sc_hd__decap_3
XFILLER_55_158 VPWR VGND VPWR VGND sky130_fd_sc_hd__decap_3
XFILLER_55_169 VPWR VGND VPWR VGND sky130_fd_sc_hd__decap_3
XFILLER_51_320 VPWR VGND VPWR VGND sky130_fd_sc_hd__decap_3
XFILLER_36_383 VPWR VGND VPWR VGND sky130_fd_sc_hd__decap_3
XFILLER_51_364 VPWR VGND VPWR VGND sky130_fd_sc_hd__decap_3
XFILLER_34_38 VPWR VGND VPWR VGND sky130_fd_sc_hd__decap_3
XFILLER_50_15 VPWR VGND VPWR VGND sky130_fd_sc_hd__decap_3
XPHY_EDGE_ROW_18_2_Left_39 VPWR VGND VPWR VGND sky130_fd_sc_hd__decap_3
XFILLER_50_59 VPWR VGND VPWR VGND sky130_fd_sc_hd__decap_3
XFILLER_59_24 VPWR VGND VPWR VGND sky130_fd_sc_hd__decap_3
XFILLER_1_6 VPWR VGND VPWR VGND sky130_fd_sc_hd__decap_3
XFILLER_59_57 VPWR VGND VPWR VGND sky130_fd_sc_hd__decap_3
XFILLER_19_328 VPWR VGND VPWR VGND sky130_fd_sc_hd__decap_3
XFILLER_46_103 VPWR VGND VPWR VGND sky130_fd_sc_hd__decap_3
XFILLER_46_136 VPWR VGND VPWR VGND sky130_fd_sc_hd__decap_3
XFILLER_46_147 VPWR VGND VPWR VGND sky130_fd_sc_hd__decap_3
XFILLER_27_361 VPWR VGND VPWR VGND sky130_fd_sc_hd__decap_3
XFILLER_34_309 VPWR VGND VPWR VGND sky130_fd_sc_hd__decap_3
XFILLER_61_128 VPWR VGND VPWR VGND sky130_fd_sc_hd__decap_3
XFILLER_54_180 VPWR VGND VPWR VGND sky130_fd_sc_hd__decap_3
XFILLER_42_342 VPWR VGND VPWR VGND sky130_fd_sc_hd__decap_3
XFILLER_42_386 VPWR VGND VPWR VGND sky130_fd_sc_hd__decap_3
X_304_ VGND VPWR VPWR VGND clknet_2_0__leaf_clk_regs net33 _049_ cin_q _304_/a_1462_47#
+ _304_/a_543_47# _304_/a_651_413# _304_/a_193_47# _304_/a_805_47# _304_/a_448_47#
+ _304_/a_639_47# _304_/a_1283_21# _304_/a_761_289# _304_/a_1108_47# _304_/a_1217_47#
+ _304_/a_1270_413# _304_/a_27_47# sky130_fd_sc_hd__dfrtp_1
XFILLER_24_71 VPWR VGND VPWR VGND sky130_fd_sc_hd__decap_3
X_235_ net60 _030_ VPWR VGND VPWR VGND sky130_fd_sc_hd__inv_2
X_166_ VPWR VGND VGND VPWR genblk1\[8\].fa_inst.b _082_ genblk1\[8\].fa_inst.a _166_/a_113_47#
+ sky130_fd_sc_hd__nand2_1
XFILLER_34_6 VPWR VGND VPWR VGND sky130_fd_sc_hd__decap_3
XFILLER_1_42 VPWR VGND VPWR VGND sky130_fd_sc_hd__decap_3
XFILLER_37_125 VPWR VGND VPWR VGND sky130_fd_sc_hd__decap_3
XFILLER_1_75 VPWR VGND VPWR VGND sky130_fd_sc_hd__decap_3
XFILLER_37_158 VPWR VGND VPWR VGND sky130_fd_sc_hd__decap_3
XFILLER_37_169 VPWR VGND VPWR VGND sky130_fd_sc_hd__decap_3
XFILLER_18_372 VPWR VGND VPWR VGND sky130_fd_sc_hd__decap_3
XFILLER_33_320 VPWR VGND VPWR VGND sky130_fd_sc_hd__decap_3
XFILLER_52_128 VPWR VGND VPWR VGND sky130_fd_sc_hd__decap_3
XFILLER_33_364 VPWR VGND VPWR VGND sky130_fd_sc_hd__decap_3
XFILLER_60_183 VPWR VGND VPWR VGND sky130_fd_sc_hd__decap_3
XFILLER_60_150 VPWR VGND VPWR VGND sky130_fd_sc_hd__decap_3
XFILLER_20_18 VPWR VGND VPWR VGND sky130_fd_sc_hd__decap_3
XFILLER_56_401 VPWR VGND VPWR VGND sky130_fd_sc_hd__decap_3
XFILLER_28_114 VPWR VGND VPWR VGND sky130_fd_sc_hd__decap_3
XFILLER_45_15 VPWR VGND VPWR VGND sky130_fd_sc_hd__decap_3
XPHY_EDGE_ROW_18_1_Right_17 VPWR VGND VPWR VGND sky130_fd_sc_hd__decap_3
XFILLER_36_180 VPWR VGND VPWR VGND sky130_fd_sc_hd__decap_3
XFILLER_43_128 VPWR VGND VPWR VGND sky130_fd_sc_hd__decap_3
XFILLER_24_342 VPWR VGND VPWR VGND sky130_fd_sc_hd__decap_3
XFILLER_24_386 VPWR VGND VPWR VGND sky130_fd_sc_hd__decap_3
XFILLER_51_172 VPWR VGND VPWR VGND sky130_fd_sc_hd__decap_3
XFILLER_51_161 VPWR VGND VPWR VGND sky130_fd_sc_hd__decap_3
XFILLER_61_36 VPWR VGND VPWR VGND sky130_fd_sc_hd__decap_3
XFILLER_61_69 VPWR VGND VPWR VGND sky130_fd_sc_hd__decap_3
Xclkbuf_regs_0_clk VGND VPWR VGND VPWR clk clk_regs clkbuf_regs_0_clk/a_110_47# sky130_fd_sc_hd__clkbuf_16
XFILLER_59_261 VPWR VGND VPWR VGND sky130_fd_sc_hd__decap_3
XFILLER_19_60 VPWR VGND VPWR VGND sky130_fd_sc_hd__decap_3
XFILLER_19_125 VPWR VGND VPWR VGND sky130_fd_sc_hd__decap_3
XFILLER_62_404 VPWR VGND VPWR VGND sky130_fd_sc_hd__decap_3
XFILLER_19_158 VPWR VGND VPWR VGND sky130_fd_sc_hd__decap_3
XFILLER_19_169 VPWR VGND VPWR VGND sky130_fd_sc_hd__decap_3
XFILLER_34_106 VPWR VGND VPWR VGND sky130_fd_sc_hd__decap_3
XFILLER_15_331 VPWR VGND VPWR VGND sky130_fd_sc_hd__decap_3
XFILLER_15_364 VPWR VGND VPWR VGND sky130_fd_sc_hd__decap_3
XFILLER_35_81 VPWR VGND VPWR VGND sky130_fd_sc_hd__decap_3
XFILLER_30_301 VPWR VGND VPWR VGND sky130_fd_sc_hd__decap_3
XFILLER_30_312 VPWR VGND VPWR VGND sky130_fd_sc_hd__decap_3
XFILLER_42_150 VPWR VGND VPWR VGND sky130_fd_sc_hd__decap_3
XFILLER_15_397 VPWR VGND VPWR VGND sky130_fd_sc_hd__decap_3
XFILLER_30_345 VPWR VGND VPWR VGND sky130_fd_sc_hd__decap_3
XFILLER_42_183 VPWR VGND VPWR VGND sky130_fd_sc_hd__decap_3
XFILLER_30_389 VPWR VGND VPWR VGND sky130_fd_sc_hd__decap_3
XFILLER_51_80 VPWR VGND VPWR VGND sky130_fd_sc_hd__decap_3
X_218_ net60 _013_ VPWR VGND VPWR VGND sky130_fd_sc_hd__inv_2
X_149_ VGND VPWR _068_ genblk1\[4\].fa_inst.s _067_ VPWR VGND _149_/a_129_47# _149_/a_47_47#
+ _149_/a_285_47# _149_/a_377_297# sky130_fd_sc_hd__xnor2_1
XFILLER_38_401 VPWR VGND VPWR VGND sky130_fd_sc_hd__decap_3
XFILLER_25_106 VPWR VGND VPWR VGND sky130_fd_sc_hd__decap_3
XFILLER_25_128 VPWR VGND VPWR VGND sky130_fd_sc_hd__decap_3
XFILLER_33_172 VPWR VGND VPWR VGND sky130_fd_sc_hd__decap_3
XFILLER_33_161 VPWR VGND VPWR VGND sky130_fd_sc_hd__decap_3
XFILLER_21_312 VPWR VGND VPWR VGND sky130_fd_sc_hd__decap_3
XFILLER_21_389 VPWR VGND VPWR VGND sky130_fd_sc_hd__decap_3
Xoutput39 VPWR VGND s[0] net39 VPWR VGND output39/a_27_47# sky130_fd_sc_hd__buf_2
XPHY_EDGE_ROW_9_1_Left_115 VPWR VGND VPWR VGND sky130_fd_sc_hd__decap_3
XFILLER_48_209 VPWR VGND VPWR VGND sky130_fd_sc_hd__decap_3
XFILLER_56_47 VPWR VGND VPWR VGND sky130_fd_sc_hd__decap_3
XFILLER_44_404 VPWR VGND VPWR VGND sky130_fd_sc_hd__decap_3
XFILLER_56_242 VPWR VGND VPWR VGND sky130_fd_sc_hd__decap_3
XFILLER_56_253 VPWR VGND VPWR VGND sky130_fd_sc_hd__decap_3
XFILLER_56_286 VPWR VGND VPWR VGND sky130_fd_sc_hd__decap_3
XFILLER_16_128 VPWR VGND VPWR VGND sky130_fd_sc_hd__decap_3
XFILLER_24_150 VPWR VGND VPWR VGND sky130_fd_sc_hd__decap_3
XFILLER_12_334 VPWR VGND VPWR VGND sky130_fd_sc_hd__decap_3
XFILLER_24_183 VPWR VGND VPWR VGND sky130_fd_sc_hd__decap_3
XFILLER_12_378 VPWR VGND VPWR VGND sky130_fd_sc_hd__decap_3
XFILLER_8_349 VPWR VGND VPWR VGND sky130_fd_sc_hd__decap_3
XFILLER_47_231 VPWR VGND VPWR VGND sky130_fd_sc_hd__decap_3
XFILLER_47_220 VPWR VGND VPWR VGND sky130_fd_sc_hd__decap_3
XFILLER_47_264 VPWR VGND VPWR VGND sky130_fd_sc_hd__decap_3
XFILLER_62_212 VPWR VGND VPWR VGND sky130_fd_sc_hd__decap_3
XFILLER_62_256 VPWR VGND VPWR VGND sky130_fd_sc_hd__decap_3
XFILLER_62_245 VPWR VGND VPWR VGND sky130_fd_sc_hd__decap_3
XFILLER_46_80 VPWR VGND VPWR VGND sky130_fd_sc_hd__decap_3
XFILLER_46_91 VPWR VGND VPWR VGND sky130_fd_sc_hd__decap_3
XFILLER_62_289 VPWR VGND VPWR VGND sky130_fd_sc_hd__decap_3
XFILLER_15_161 VPWR VGND VPWR VGND sky130_fd_sc_hd__decap_3
XFILLER_22_109 VPWR VGND VPWR VGND sky130_fd_sc_hd__decap_3
XFILLER_15_172 VPWR VGND VPWR VGND sky130_fd_sc_hd__decap_3
XFILLER_30_153 VPWR VGND VPWR VGND sky130_fd_sc_hd__decap_3
XFILLER_7_30 VPWR VGND VPWR VGND sky130_fd_sc_hd__decap_3
XFILLER_30_186 VPWR VGND VPWR VGND sky130_fd_sc_hd__decap_3
XFILLER_30_197 VPWR VGND VPWR VGND sky130_fd_sc_hd__decap_3
XFILLER_7_382 VPWR VGND VPWR VGND sky130_fd_sc_hd__decap_3
XFILLER_7_85 VPWR VGND VPWR VGND sky130_fd_sc_hd__decap_3
XFILLER_26_404 VPWR VGND VPWR VGND sky130_fd_sc_hd__decap_3
XFILLER_38_253 VPWR VGND VPWR VGND sky130_fd_sc_hd__decap_3
XFILLER_38_242 VPWR VGND VPWR VGND sky130_fd_sc_hd__decap_3
XFILLER_38_286 VPWR VGND VPWR VGND sky130_fd_sc_hd__decap_3
XFILLER_53_234 VPWR VGND VPWR VGND sky130_fd_sc_hd__decap_3
XFILLER_53_267 VPWR VGND VPWR VGND sky130_fd_sc_hd__decap_3
XFILLER_21_131 VPWR VGND VPWR VGND sky130_fd_sc_hd__decap_3
XFILLER_21_153 VPWR VGND VPWR VGND sky130_fd_sc_hd__decap_3
XFILLER_42_38 VPWR VGND VPWR VGND sky130_fd_sc_hd__decap_3
XFILLER_21_175 VPWR VGND VPWR VGND sky130_fd_sc_hd__decap_3
XFILLER_21_197 VPWR VGND VPWR VGND sky130_fd_sc_hd__decap_3
XPHY_EDGE_ROW_7_2_Right_93 VPWR VGND VPWR VGND sky130_fd_sc_hd__decap_3
XFILLER_29_220 VPWR VGND VPWR VGND sky130_fd_sc_hd__decap_3
XFILLER_29_231 VPWR VGND VPWR VGND sky130_fd_sc_hd__decap_3
XFILLER_29_264 VPWR VGND VPWR VGND sky130_fd_sc_hd__decap_3
XFILLER_44_212 VPWR VGND VPWR VGND sky130_fd_sc_hd__decap_3
XFILLER_44_256 VPWR VGND VPWR VGND sky130_fd_sc_hd__decap_3
XFILLER_44_245 VPWR VGND VPWR VGND sky130_fd_sc_hd__decap_3
XFILLER_16_50 VPWR VGND VPWR VGND sky130_fd_sc_hd__decap_3
XFILLER_44_289 VPWR VGND VPWR VGND sky130_fd_sc_hd__decap_3
XFILLER_12_153 VPWR VGND VPWR VGND sky130_fd_sc_hd__decap_3
XFILLER_8_124 VPWR VGND VPWR VGND sky130_fd_sc_hd__decap_3
XFILLER_8_168 VPWR VGND VPWR VGND sky130_fd_sc_hd__decap_3
XFILLER_4_363 VPWR VGND VPWR VGND sky130_fd_sc_hd__decap_3
XFILLER_4_396 VPWR VGND VPWR VGND sky130_fd_sc_hd__decap_3
XFILLER_35_234 VPWR VGND VPWR VGND sky130_fd_sc_hd__decap_3
XFILLER_35_267 VPWR VGND VPWR VGND sky130_fd_sc_hd__decap_3
XFILLER_50_215 VPWR VGND VPWR VGND sky130_fd_sc_hd__decap_3
XFILLER_50_248 VPWR VGND VPWR VGND sky130_fd_sc_hd__decap_3
XFILLER_50_259 VPWR VGND VPWR VGND sky130_fd_sc_hd__decap_3
XFILLER_58_315 VPWR VGND VPWR VGND sky130_fd_sc_hd__decap_3
XFILLER_58_304 VPWR VGND VPWR VGND sky130_fd_sc_hd__decap_3
XFILLER_58_348 VPWR VGND VPWR VGND sky130_fd_sc_hd__decap_3
XFILLER_26_212 VPWR VGND VPWR VGND sky130_fd_sc_hd__decap_3
XFILLER_26_245 VPWR VGND VPWR VGND sky130_fd_sc_hd__decap_3
XFILLER_26_256 VPWR VGND VPWR VGND sky130_fd_sc_hd__decap_3
XFILLER_26_289 VPWR VGND VPWR VGND sky130_fd_sc_hd__decap_3
XFILLER_53_37 VPWR VGND VPWR VGND sky130_fd_sc_hd__decap_3
XFILLER_41_237 VPWR VGND VPWR VGND sky130_fd_sc_hd__decap_3
XFILLER_5_116 VPWR VGND VPWR VGND sky130_fd_sc_hd__decap_3
XFILLER_5_149 VPWR VGND VPWR VGND sky130_fd_sc_hd__decap_3
XFILLER_1_355 VPWR VGND VPWR VGND sky130_fd_sc_hd__decap_3
XFILLER_49_337 VPWR VGND VPWR VGND sky130_fd_sc_hd__decap_3
XFILLER_49_326 VPWR VGND VPWR VGND sky130_fd_sc_hd__decap_3
XFILLER_1_388 VPWR VGND VPWR VGND sky130_fd_sc_hd__decap_3
XFILLER_64_329 VPWR VGND VPWR VGND sky130_fd_sc_hd__decap_3
XFILLER_57_370 VPWR VGND VPWR VGND sky130_fd_sc_hd__decap_3
XFILLER_27_60 VPWR VGND VPWR VGND sky130_fd_sc_hd__decap_3
XFILLER_27_93 VPWR VGND VPWR VGND sky130_fd_sc_hd__decap_3
XFILLER_32_215 VPWR VGND VPWR VGND sky130_fd_sc_hd__decap_3
XFILLER_32_248 VPWR VGND VPWR VGND sky130_fd_sc_hd__decap_3
XFILLER_9_400 VPWR VGND VPWR VGND sky130_fd_sc_hd__decap_3
XFILLER_32_259 VPWR VGND VPWR VGND sky130_fd_sc_hd__decap_3
XFILLER_43_81 VPWR VGND VPWR VGND sky130_fd_sc_hd__decap_3
XFILLER_40_292 VPWR VGND VPWR VGND sky130_fd_sc_hd__decap_3
XFILLER_4_171 VPWR VGND VPWR VGND sky130_fd_sc_hd__decap_3
XFILLER_4_53 VPWR VGND VPWR VGND sky130_fd_sc_hd__decap_3
XFILLER_55_329 VPWR VGND VPWR VGND sky130_fd_sc_hd__decap_3
XFILLER_63_340 VPWR VGND VPWR VGND sky130_fd_sc_hd__decap_3
XFILLER_48_392 VPWR VGND VPWR VGND sky130_fd_sc_hd__decap_3
XFILLER_63_373 VPWR VGND VPWR VGND sky130_fd_sc_hd__decap_3
XFILLER_23_237 VPWR VGND VPWR VGND sky130_fd_sc_hd__decap_3
XFILLER_31_270 VPWR VGND VPWR VGND sky130_fd_sc_hd__decap_3
XFILLER_31_281 VPWR VGND VPWR VGND sky130_fd_sc_hd__decap_3
XFILLER_48_15 VPWR VGND VPWR VGND sky130_fd_sc_hd__decap_3
XFILLER_58_156 VPWR VGND VPWR VGND sky130_fd_sc_hd__decap_3
XFILLER_58_134 VPWR VGND VPWR VGND sky130_fd_sc_hd__decap_3
XFILLER_58_189 VPWR VGND VPWR VGND sky130_fd_sc_hd__decap_3
XFILLER_46_318 VPWR VGND VPWR VGND sky130_fd_sc_hd__decap_3
XFILLER_39_370 VPWR VGND VPWR VGND sky130_fd_sc_hd__decap_3
XPHY_EDGE_ROW_6_1_Right_5 VPWR VGND VPWR VGND sky130_fd_sc_hd__decap_3
XFILLER_64_14 VPWR VGND VPWR VGND sky130_fd_sc_hd__decap_3
XFILLER_64_69 VPWR VGND VPWR VGND sky130_fd_sc_hd__decap_3
XFILLER_64_47 VPWR VGND VPWR VGND sky130_fd_sc_hd__decap_3
XFILLER_54_351 VPWR VGND VPWR VGND sky130_fd_sc_hd__decap_3
XFILLER_54_395 VPWR VGND VPWR VGND sky130_fd_sc_hd__decap_3
X_251_ net60 _046_ VPWR VGND VPWR VGND sky130_fd_sc_hd__inv_2
XFILLER_13_40 VPWR VGND VPWR VGND sky130_fd_sc_hd__decap_3
XFILLER_22_292 VPWR VGND VPWR VGND sky130_fd_sc_hd__decap_3
X_182_ VPWR VGND VGND VPWR _093_ _095_ _094_ _182_/a_113_47# sky130_fd_sc_hd__nand2_1
XFILLER_13_84 VPWR VGND VPWR VGND sky130_fd_sc_hd__decap_3
XPHY_EDGE_ROW_23_Left_129 VPWR VGND VPWR VGND sky130_fd_sc_hd__decap_3
XFILLER_1_152 VPWR VGND VPWR VGND sky130_fd_sc_hd__decap_3
XPHY_EDGE_ROW_39_Right_60 VPWR VGND VPWR VGND sky130_fd_sc_hd__decap_3
XFILLER_29_9 VPWR VGND VPWR VGND sky130_fd_sc_hd__decap_3
XFILLER_49_134 VPWR VGND VPWR VGND sky130_fd_sc_hd__decap_3
XFILLER_37_329 VPWR VGND VPWR VGND sky130_fd_sc_hd__decap_3
XFILLER_49_178 VPWR VGND VPWR VGND sky130_fd_sc_hd__decap_3
XFILLER_64_159 VPWR VGND VPWR VGND sky130_fd_sc_hd__decap_3
XFILLER_64_137 VPWR VGND VPWR VGND sky130_fd_sc_hd__decap_3
XPHY_EDGE_ROW_32_Left_138 VPWR VGND VPWR VGND sky130_fd_sc_hd__decap_3
XFILLER_45_340 VPWR VGND VPWR VGND sky130_fd_sc_hd__decap_3
XFILLER_60_321 VPWR VGND VPWR VGND sky130_fd_sc_hd__decap_3
XFILLER_45_373 VPWR VGND VPWR VGND sky130_fd_sc_hd__decap_3
XFILLER_60_365 VPWR VGND VPWR VGND sky130_fd_sc_hd__decap_3
XFILLER_60_354 VPWR VGND VPWR VGND sky130_fd_sc_hd__decap_3
XFILLER_54_80 VPWR VGND VPWR VGND sky130_fd_sc_hd__decap_3
XFILLER_54_91 VPWR VGND VPWR VGND sky130_fd_sc_hd__decap_3
XFILLER_60_398 VPWR VGND VPWR VGND sky130_fd_sc_hd__decap_3
XPHY_EDGE_ROW_41_Left_147 VPWR VGND VPWR VGND sky130_fd_sc_hd__decap_3
XFILLER_18_18 VPWR VGND VPWR VGND sky130_fd_sc_hd__decap_3
XFILLER_28_318 VPWR VGND VPWR VGND sky130_fd_sc_hd__decap_3
XPHY_EDGE_ROW_50_Left_156 VPWR VGND VPWR VGND sky130_fd_sc_hd__decap_3
XFILLER_55_137 VPWR VGND VPWR VGND sky130_fd_sc_hd__decap_3
XFILLER_36_351 VPWR VGND VPWR VGND sky130_fd_sc_hd__decap_3
XFILLER_63_181 VPWR VGND VPWR VGND sky130_fd_sc_hd__decap_3
XFILLER_36_395 VPWR VGND VPWR VGND sky130_fd_sc_hd__decap_3
XFILLER_51_343 VPWR VGND VPWR VGND sky130_fd_sc_hd__decap_3
XFILLER_51_332 VPWR VGND VPWR VGND sky130_fd_sc_hd__decap_3
XFILLER_51_376 VPWR VGND VPWR VGND sky130_fd_sc_hd__decap_3
XFILLER_50_38 VPWR VGND VPWR VGND sky130_fd_sc_hd__decap_3
XFILLER_59_36 VPWR VGND VPWR VGND sky130_fd_sc_hd__decap_3
XFILLER_59_69 VPWR VGND VPWR VGND sky130_fd_sc_hd__decap_3
XFILLER_46_115 VPWR VGND VPWR VGND sky130_fd_sc_hd__decap_3
XFILLER_27_340 VPWR VGND VPWR VGND sky130_fd_sc_hd__decap_3
XFILLER_46_159 VPWR VGND VPWR VGND sky130_fd_sc_hd__decap_3
XFILLER_42_321 VPWR VGND VPWR VGND sky130_fd_sc_hd__decap_3
XFILLER_27_373 VPWR VGND VPWR VGND sky130_fd_sc_hd__decap_3
XFILLER_42_354 VPWR VGND VPWR VGND sky130_fd_sc_hd__decap_3
XFILLER_54_192 VPWR VGND VPWR VGND sky130_fd_sc_hd__decap_3
X_303_ VGND VPWR VPWR VGND clknet_2_3__leaf_clk_regs net23 _048_ genblk1\[15\].fa_inst.b
+ _303_/a_1462_47# _303_/a_543_47# _303_/a_651_413# _303_/a_193_47# _303_/a_805_47#
+ _303_/a_448_47# _303_/a_639_47# _303_/a_1283_21# _303_/a_761_289# _303_/a_1108_47#
+ _303_/a_1217_47# _303_/a_1270_413# _303_/a_27_47# sky130_fd_sc_hd__dfrtp_1
XFILLER_42_398 VPWR VGND VPWR VGND sky130_fd_sc_hd__decap_3
XFILLER_42_365 VPWR VGND VPWR VGND sky130_fd_sc_hd__decap_3
XFILLER_24_50 VPWR VGND VPWR VGND sky130_fd_sc_hd__decap_3
X_234_ net59 _029_ VPWR VGND VPWR VGND sky130_fd_sc_hd__inv_2
X_165_ VPWR VGND VGND VPWR _081_ genblk1\[8\].fa_inst.b genblk1\[8\].fa_inst.a _165_/a_150_297#
+ _165_/a_68_297# sky130_fd_sc_hd__or2_1
XFILLER_27_6 VPWR VGND VPWR VGND sky130_fd_sc_hd__decap_3
XFILLER_49_91 VPWR VGND VPWR VGND sky130_fd_sc_hd__decap_3
XFILLER_1_21 VPWR VGND VPWR VGND sky130_fd_sc_hd__decap_3
XFILLER_37_104 VPWR VGND VPWR VGND sky130_fd_sc_hd__decap_3
XFILLER_37_137 VPWR VGND VPWR VGND sky130_fd_sc_hd__decap_3
XFILLER_1_87 VPWR VGND VPWR VGND sky130_fd_sc_hd__decap_3
XFILLER_18_340 VPWR VGND VPWR VGND sky130_fd_sc_hd__decap_3
XFILLER_18_384 VPWR VGND VPWR VGND sky130_fd_sc_hd__decap_3
XFILLER_45_181 VPWR VGND VPWR VGND sky130_fd_sc_hd__decap_3
XFILLER_33_332 VPWR VGND VPWR VGND sky130_fd_sc_hd__decap_3
XFILLER_33_343 VPWR VGND VPWR VGND sky130_fd_sc_hd__decap_3
XFILLER_60_162 VPWR VGND VPWR VGND sky130_fd_sc_hd__decap_3
XFILLER_33_376 VPWR VGND VPWR VGND sky130_fd_sc_hd__decap_3
XFILLER_29_39 VPWR VGND VPWR VGND sky130_fd_sc_hd__decap_3
XFILLER_28_126 VPWR VGND VPWR VGND sky130_fd_sc_hd__decap_3
XFILLER_36_192 VPWR VGND VPWR VGND sky130_fd_sc_hd__decap_3
XFILLER_24_321 VPWR VGND VPWR VGND sky130_fd_sc_hd__decap_3
XFILLER_24_354 VPWR VGND VPWR VGND sky130_fd_sc_hd__decap_3
XFILLER_61_15 VPWR VGND VPWR VGND sky130_fd_sc_hd__decap_3
XFILLER_24_365 VPWR VGND VPWR VGND sky130_fd_sc_hd__decap_3
XFILLER_51_140 VPWR VGND VPWR VGND sky130_fd_sc_hd__decap_3
XFILLER_61_48 VPWR VGND VPWR VGND sky130_fd_sc_hd__decap_3
XFILLER_24_398 VPWR VGND VPWR VGND sky130_fd_sc_hd__decap_3
XFILLER_51_184 VPWR VGND VPWR VGND sky130_fd_sc_hd__decap_3
XFILLER_10_41 VPWR VGND VPWR VGND sky130_fd_sc_hd__decap_3
XFILLER_10_74 VPWR VGND VPWR VGND sky130_fd_sc_hd__decap_3
XFILLER_10_85 VPWR VGND VPWR VGND sky130_fd_sc_hd__decap_3
XFILLER_59_240 VPWR VGND VPWR VGND sky130_fd_sc_hd__decap_3
XFILLER_59_273 VPWR VGND VPWR VGND sky130_fd_sc_hd__decap_3
XFILLER_47_402 VPWR VGND VPWR VGND sky130_fd_sc_hd__decap_3
XFILLER_59_284 VPWR VGND VPWR VGND sky130_fd_sc_hd__decap_3
XFILLER_19_72 VPWR VGND VPWR VGND sky130_fd_sc_hd__decap_3
XFILLER_19_137 VPWR VGND VPWR VGND sky130_fd_sc_hd__decap_3
XFILLER_34_118 VPWR VGND VPWR VGND sky130_fd_sc_hd__decap_3
XFILLER_15_343 VPWR VGND VPWR VGND sky130_fd_sc_hd__decap_3
XFILLER_35_60 VPWR VGND VPWR VGND sky130_fd_sc_hd__decap_3
XFILLER_27_181 VPWR VGND VPWR VGND sky130_fd_sc_hd__decap_3
XFILLER_15_376 VPWR VGND VPWR VGND sky130_fd_sc_hd__decap_3
XFILLER_35_93 VPWR VGND VPWR VGND sky130_fd_sc_hd__decap_3
XFILLER_42_162 VPWR VGND VPWR VGND sky130_fd_sc_hd__decap_3
XFILLER_30_324 VPWR VGND VPWR VGND sky130_fd_sc_hd__decap_3
XFILLER_30_357 VPWR VGND VPWR VGND sky130_fd_sc_hd__decap_3
XFILLER_30_368 VPWR VGND VPWR VGND sky130_fd_sc_hd__decap_3
X_217_ net60 _012_ VPWR VGND VPWR VGND sky130_fd_sc_hd__inv_2
X_148_ VGND VPWR VGND VPWR _068_ _064_ _061_ _062_ _148_/a_215_297# _148_/a_27_413#
+ _148_/a_298_297# _148_/a_382_47# sky130_fd_sc_hd__a21bo_1
XFILLER_51_92 VPWR VGND VPWR VGND sky130_fd_sc_hd__decap_3
XFILLER_25_3 VPWR VGND VPWR VGND sky130_fd_sc_hd__decap_3
XFILLER_33_140 VPWR VGND VPWR VGND sky130_fd_sc_hd__decap_3
XFILLER_21_302 VPWR VGND VPWR VGND sky130_fd_sc_hd__decap_3
XFILLER_33_184 VPWR VGND VPWR VGND sky130_fd_sc_hd__decap_3
XFILLER_21_324 VPWR VGND VPWR VGND sky130_fd_sc_hd__decap_3
XFILLER_21_346 VPWR VGND VPWR VGND sky130_fd_sc_hd__decap_3
XFILLER_21_368 VPWR VGND VPWR VGND sky130_fd_sc_hd__decap_3
XFILLER_56_15 VPWR VGND VPWR VGND sky130_fd_sc_hd__decap_3
XFILLER_56_221 VPWR VGND VPWR VGND sky130_fd_sc_hd__decap_3
XFILLER_56_59 VPWR VGND VPWR VGND sky130_fd_sc_hd__decap_3
XFILLER_56_265 VPWR VGND VPWR VGND sky130_fd_sc_hd__decap_3
XFILLER_56_298 VPWR VGND VPWR VGND sky130_fd_sc_hd__decap_3
XFILLER_24_162 VPWR VGND VPWR VGND sky130_fd_sc_hd__decap_3
XFILLER_12_357 VPWR VGND VPWR VGND sky130_fd_sc_hd__decap_3
XFILLER_12_346 VPWR VGND VPWR VGND sky130_fd_sc_hd__decap_3
XFILLER_8_328 VPWR VGND VPWR VGND sky130_fd_sc_hd__decap_3
XFILLER_20_390 VPWR VGND VPWR VGND sky130_fd_sc_hd__decap_3
XFILLER_11_9 VPWR VGND VPWR VGND sky130_fd_sc_hd__decap_3
XFILLER_47_243 VPWR VGND VPWR VGND sky130_fd_sc_hd__decap_3
XFILLER_62_224 VPWR VGND VPWR VGND sky130_fd_sc_hd__decap_3
XFILLER_47_276 VPWR VGND VPWR VGND sky130_fd_sc_hd__decap_3
XFILLER_47_287 VPWR VGND VPWR VGND sky130_fd_sc_hd__decap_3
XFILLER_62_268 VPWR VGND VPWR VGND sky130_fd_sc_hd__decap_3
XFILLER_15_140 VPWR VGND VPWR VGND sky130_fd_sc_hd__decap_3
XFILLER_30_121 VPWR VGND VPWR VGND sky130_fd_sc_hd__decap_3
XFILLER_62_91 VPWR VGND VPWR VGND sky130_fd_sc_hd__decap_3
XFILLER_62_80 VPWR VGND VPWR VGND sky130_fd_sc_hd__decap_3
XFILLER_30_165 VPWR VGND VPWR VGND sky130_fd_sc_hd__decap_3
XFILLER_7_42 VPWR VGND VPWR VGND sky130_fd_sc_hd__decap_3
XFILLER_7_361 VPWR VGND VPWR VGND sky130_fd_sc_hd__decap_3
XFILLER_7_97 VPWR VGND VPWR VGND sky130_fd_sc_hd__decap_3
XFILLER_7_394 VPWR VGND VPWR VGND sky130_fd_sc_hd__decap_3
XFILLER_38_221 VPWR VGND VPWR VGND sky130_fd_sc_hd__decap_3
XFILLER_38_298 VPWR VGND VPWR VGND sky130_fd_sc_hd__decap_3
XFILLER_26_18 VPWR VGND VPWR VGND sky130_fd_sc_hd__decap_3
XFILLER_38_265 VPWR VGND VPWR VGND sky130_fd_sc_hd__decap_3
XFILLER_53_202 VPWR VGND VPWR VGND sky130_fd_sc_hd__decap_3
XFILLER_53_246 VPWR VGND VPWR VGND sky130_fd_sc_hd__decap_3
XFILLER_61_290 VPWR VGND VPWR VGND sky130_fd_sc_hd__decap_3
XFILLER_21_165 VPWR VGND VPWR VGND sky130_fd_sc_hd__decap_3
XFILLER_21_187 VPWR VGND VPWR VGND sky130_fd_sc_hd__decap_3
XFILLER_29_243 VPWR VGND VPWR VGND sky130_fd_sc_hd__decap_3
XFILLER_29_276 VPWR VGND VPWR VGND sky130_fd_sc_hd__decap_3
XFILLER_29_287 VPWR VGND VPWR VGND sky130_fd_sc_hd__decap_3
XFILLER_44_224 VPWR VGND VPWR VGND sky130_fd_sc_hd__decap_3
XFILLER_16_62 VPWR VGND VPWR VGND sky130_fd_sc_hd__decap_3
XFILLER_44_268 VPWR VGND VPWR VGND sky130_fd_sc_hd__decap_3
XFILLER_12_121 VPWR VGND VPWR VGND sky130_fd_sc_hd__decap_3
XFILLER_12_165 VPWR VGND VPWR VGND sky130_fd_sc_hd__decap_3
XFILLER_8_136 VPWR VGND VPWR VGND sky130_fd_sc_hd__decap_3
XFILLER_8_147 VPWR VGND VPWR VGND sky130_fd_sc_hd__decap_3
XFILLER_32_50 VPWR VGND VPWR VGND sky130_fd_sc_hd__decap_3
XFILLER_59_9 VPWR VGND VPWR VGND sky130_fd_sc_hd__decap_3
XFILLER_4_331 VPWR VGND VPWR VGND sky130_fd_sc_hd__decap_3
XFILLER_4_375 VPWR VGND VPWR VGND sky130_fd_sc_hd__decap_3
XFILLER_35_202 VPWR VGND VPWR VGND sky130_fd_sc_hd__decap_3
XFILLER_35_246 VPWR VGND VPWR VGND sky130_fd_sc_hd__decap_3
XFILLER_50_227 VPWR VGND VPWR VGND sky130_fd_sc_hd__decap_3
XFILLER_43_290 VPWR VGND VPWR VGND sky130_fd_sc_hd__decap_3
XFILLER_58_327 VPWR VGND VPWR VGND sky130_fd_sc_hd__decap_3
XFILLER_26_224 VPWR VGND VPWR VGND sky130_fd_sc_hd__decap_3
XFILLER_26_268 VPWR VGND VPWR VGND sky130_fd_sc_hd__decap_3
XFILLER_41_205 VPWR VGND VPWR VGND sky130_fd_sc_hd__decap_3
XFILLER_53_49 VPWR VGND VPWR VGND sky130_fd_sc_hd__decap_3
XFILLER_41_249 VPWR VGND VPWR VGND sky130_fd_sc_hd__decap_3
XFILLER_5_128 VPWR VGND VPWR VGND sky130_fd_sc_hd__decap_3
XFILLER_5_106 VPWR VGND VPWR VGND sky130_fd_sc_hd__decap_3
XFILLER_1_334 VPWR VGND VPWR VGND sky130_fd_sc_hd__decap_3
XFILLER_49_305 VPWR VGND VPWR VGND sky130_fd_sc_hd__decap_3
XFILLER_1_367 VPWR VGND VPWR VGND sky130_fd_sc_hd__decap_3
XFILLER_49_349 VPWR VGND VPWR VGND sky130_fd_sc_hd__decap_3
XFILLER_57_393 VPWR VGND VPWR VGND sky130_fd_sc_hd__decap_3
XFILLER_57_382 VPWR VGND VPWR VGND sky130_fd_sc_hd__decap_3
XFILLER_27_72 VPWR VGND VPWR VGND sky130_fd_sc_hd__decap_3
XFILLER_27_50 VPWR VGND VPWR VGND sky130_fd_sc_hd__decap_3
XFILLER_32_227 VPWR VGND VPWR VGND sky130_fd_sc_hd__decap_3
XFILLER_25_290 VPWR VGND VPWR VGND sky130_fd_sc_hd__decap_3
XFILLER_43_60 VPWR VGND VPWR VGND sky130_fd_sc_hd__decap_3
XFILLER_40_271 VPWR VGND VPWR VGND sky130_fd_sc_hd__decap_3
XFILLER_4_150 VPWR VGND VPWR VGND sky130_fd_sc_hd__decap_3
XFILLER_57_6 VPWR VGND VPWR VGND sky130_fd_sc_hd__decap_3
XFILLER_4_32 VPWR VGND VPWR VGND sky130_fd_sc_hd__decap_3
XFILLER_4_65 VPWR VGND VPWR VGND sky130_fd_sc_hd__decap_3
XFILLER_55_308 VPWR VGND VPWR VGND sky130_fd_sc_hd__decap_3
XFILLER_48_371 VPWR VGND VPWR VGND sky130_fd_sc_hd__decap_3
XFILLER_48_360 VPWR VGND VPWR VGND sky130_fd_sc_hd__decap_3
XFILLER_63_352 VPWR VGND VPWR VGND sky130_fd_sc_hd__decap_3
XFILLER_23_205 VPWR VGND VPWR VGND sky130_fd_sc_hd__decap_3
XFILLER_63_396 VPWR VGND VPWR VGND sky130_fd_sc_hd__decap_3
XFILLER_63_385 VPWR VGND VPWR VGND sky130_fd_sc_hd__decap_3
XFILLER_23_249 VPWR VGND VPWR VGND sky130_fd_sc_hd__decap_3
XFILLER_31_293 VPWR VGND VPWR VGND sky130_fd_sc_hd__decap_3
XFILLER_2_109 VPWR VGND VPWR VGND sky130_fd_sc_hd__decap_3
XFILLER_48_49 VPWR VGND VPWR VGND sky130_fd_sc_hd__decap_3
XFILLER_58_168 VPWR VGND VPWR VGND sky130_fd_sc_hd__decap_3
XFILLER_39_393 VPWR VGND VPWR VGND sky130_fd_sc_hd__decap_3
XFILLER_54_330 VPWR VGND VPWR VGND sky130_fd_sc_hd__decap_3
XFILLER_39_382 VPWR VGND VPWR VGND sky130_fd_sc_hd__decap_3
XFILLER_54_374 VPWR VGND VPWR VGND sky130_fd_sc_hd__decap_3
X_250_ net60 _045_ VPWR VGND VPWR VGND sky130_fd_sc_hd__inv_2
XFILLER_22_271 VPWR VGND VPWR VGND sky130_fd_sc_hd__decap_3
X_181_ VPWR VGND VGND VPWR genblk1\[11\].fa_inst.b _094_ genblk1\[11\].fa_inst.a _181_/a_113_47#
+ sky130_fd_sc_hd__nand2_1
XFILLER_13_52 VPWR VGND VPWR VGND sky130_fd_sc_hd__decap_3
XFILLER_1_131 VPWR VGND VPWR VGND sky130_fd_sc_hd__decap_3
XFILLER_1_175 VPWR VGND VPWR VGND sky130_fd_sc_hd__decap_3
XFILLER_1_164 VPWR VGND VPWR VGND sky130_fd_sc_hd__decap_3
XFILLER_49_113 VPWR VGND VPWR VGND sky130_fd_sc_hd__decap_3
XFILLER_49_146 VPWR VGND VPWR VGND sky130_fd_sc_hd__decap_3
XFILLER_64_116 VPWR VGND VPWR VGND sky130_fd_sc_hd__decap_3
XFILLER_37_308 VPWR VGND VPWR VGND sky130_fd_sc_hd__decap_3
XFILLER_45_352 VPWR VGND VPWR VGND sky130_fd_sc_hd__decap_3
XFILLER_57_190 VPWR VGND VPWR VGND sky130_fd_sc_hd__decap_3
XFILLER_45_396 VPWR VGND VPWR VGND sky130_fd_sc_hd__decap_3
XFILLER_45_385 VPWR VGND VPWR VGND sky130_fd_sc_hd__decap_3
XFILLER_60_333 VPWR VGND VPWR VGND sky130_fd_sc_hd__decap_3
XFILLER_60_377 VPWR VGND VPWR VGND sky130_fd_sc_hd__decap_3
XFILLER_55_3 VPWR VGND VPWR VGND sky130_fd_sc_hd__decap_3
XFILLER_55_105 VPWR VGND VPWR VGND sky130_fd_sc_hd__decap_3
XFILLER_55_116 VPWR VGND VPWR VGND sky130_fd_sc_hd__decap_3
XFILLER_55_149 VPWR VGND VPWR VGND sky130_fd_sc_hd__decap_3
XFILLER_36_330 VPWR VGND VPWR VGND sky130_fd_sc_hd__decap_3
XFILLER_51_311 VPWR VGND VPWR VGND sky130_fd_sc_hd__decap_3
XFILLER_34_18 VPWR VGND VPWR VGND sky130_fd_sc_hd__decap_3
XFILLER_36_374 VPWR VGND VPWR VGND sky130_fd_sc_hd__decap_3
XFILLER_63_193 VPWR VGND VPWR VGND sky130_fd_sc_hd__decap_3
XFILLER_51_355 VPWR VGND VPWR VGND sky130_fd_sc_hd__decap_3
XFILLER_51_388 VPWR VGND VPWR VGND sky130_fd_sc_hd__decap_3
XFILLER_51_399 VPWR VGND VPWR VGND sky130_fd_sc_hd__decap_3
XFILLER_59_15 VPWR VGND VPWR VGND sky130_fd_sc_hd__decap_3
XFILLER_59_48 VPWR VGND VPWR VGND sky130_fd_sc_hd__decap_3
XFILLER_46_127 VPWR VGND VPWR VGND sky130_fd_sc_hd__decap_3
XFILLER_61_108 VPWR VGND VPWR VGND sky130_fd_sc_hd__decap_3
XFILLER_27_352 VPWR VGND VPWR VGND sky130_fd_sc_hd__decap_3
XFILLER_39_190 VPWR VGND VPWR VGND sky130_fd_sc_hd__decap_3
XFILLER_61_119 VPWR VGND VPWR VGND sky130_fd_sc_hd__decap_3
XFILLER_27_385 VPWR VGND VPWR VGND sky130_fd_sc_hd__decap_3
XFILLER_27_396 VPWR VGND VPWR VGND sky130_fd_sc_hd__decap_3
XFILLER_54_171 VPWR VGND VPWR VGND sky130_fd_sc_hd__decap_3
XFILLER_42_333 VPWR VGND VPWR VGND sky130_fd_sc_hd__decap_3
XFILLER_42_377 VPWR VGND VPWR VGND sky130_fd_sc_hd__decap_3
X_302_ VGND VPWR VPWR VGND clknet_2_2__leaf_clk_regs net22 _047_ genblk1\[14\].fa_inst.b
+ _302_/a_1462_47# _302_/a_543_47# _302_/a_651_413# _302_/a_193_47# _302_/a_805_47#
+ _302_/a_448_47# _302_/a_639_47# _302_/a_1283_21# _302_/a_761_289# _302_/a_1108_47#
+ _302_/a_1217_47# _302_/a_1270_413# _302_/a_27_47# sky130_fd_sc_hd__dfrtp_1
XFILLER_24_62 VPWR VGND VPWR VGND sky130_fd_sc_hd__decap_3
X_233_ net59 _028_ VPWR VGND VPWR VGND sky130_fd_sc_hd__inv_2
X_164_ VGND VPWR _080_ genblk1\[7\].fa_inst.s _079_ VPWR VGND _164_/a_129_47# _164_/a_47_47#
+ _164_/a_285_47# _164_/a_377_297# sky130_fd_sc_hd__xnor2_1
XPHY_EDGE_ROW_12_2_Right_98 VPWR VGND VPWR VGND sky130_fd_sc_hd__decap_3
XFILLER_40_50 VPWR VGND VPWR VGND sky130_fd_sc_hd__decap_3
XFILLER_41_9 VPWR VGND VPWR VGND sky130_fd_sc_hd__decap_3
XFILLER_1_33 VPWR VGND VPWR VGND sky130_fd_sc_hd__decap_3
XFILLER_37_116 VPWR VGND VPWR VGND sky130_fd_sc_hd__decap_3
XFILLER_1_99 VPWR VGND VPWR VGND sky130_fd_sc_hd__decap_3
XFILLER_1_66 VPWR VGND VPWR VGND sky130_fd_sc_hd__decap_3
XFILLER_37_149 VPWR VGND VPWR VGND sky130_fd_sc_hd__decap_3
XFILLER_18_363 VPWR VGND VPWR VGND sky130_fd_sc_hd__decap_3
XFILLER_33_311 VPWR VGND VPWR VGND sky130_fd_sc_hd__decap_3
XFILLER_60_130 VPWR VGND VPWR VGND sky130_fd_sc_hd__decap_3
XFILLER_33_355 VPWR VGND VPWR VGND sky130_fd_sc_hd__decap_3
XFILLER_18_396 VPWR VGND VPWR VGND sky130_fd_sc_hd__decap_3
XFILLER_45_193 VPWR VGND VPWR VGND sky130_fd_sc_hd__decap_3
XFILLER_60_174 VPWR VGND VPWR VGND sky130_fd_sc_hd__decap_3
XFILLER_60_141 VPWR VGND VPWR VGND sky130_fd_sc_hd__decap_3
XFILLER_33_388 VPWR VGND VPWR VGND sky130_fd_sc_hd__decap_3
XFILLER_33_399 VPWR VGND VPWR VGND sky130_fd_sc_hd__decap_3
XPHY_EDGE_ROW_58_Right_79 VPWR VGND VPWR VGND sky130_fd_sc_hd__decap_3
XFILLER_36_171 VPWR VGND VPWR VGND sky130_fd_sc_hd__decap_3
XFILLER_43_119 VPWR VGND VPWR VGND sky130_fd_sc_hd__decap_3
XFILLER_24_333 VPWR VGND VPWR VGND sky130_fd_sc_hd__decap_3
XFILLER_24_377 VPWR VGND VPWR VGND sky130_fd_sc_hd__decap_3
XFILLER_51_152 VPWR VGND VPWR VGND sky130_fd_sc_hd__decap_3
XFILLER_61_27 VPWR VGND VPWR VGND sky130_fd_sc_hd__decap_3
XPHY_EDGE_ROW_0_1_Right_20 VPWR VGND VPWR VGND sky130_fd_sc_hd__decap_3
XFILLER_51_196 VPWR VGND VPWR VGND sky130_fd_sc_hd__decap_3
XFILLER_10_53 VPWR VGND VPWR VGND sky130_fd_sc_hd__decap_3
XFILLER_10_64 VPWR VGND VPWR VGND sky130_fd_sc_hd__decap_3
XFILLER_10_97 VPWR VGND VPWR VGND sky130_fd_sc_hd__decap_3
XFILLER_59_252 VPWR VGND VPWR VGND sky130_fd_sc_hd__decap_3
XFILLER_19_40 VPWR VGND VPWR VGND sky130_fd_sc_hd__decap_3
XFILLER_59_296 VPWR VGND VPWR VGND sky130_fd_sc_hd__decap_3
XFILLER_19_116 VPWR VGND VPWR VGND sky130_fd_sc_hd__decap_3
XFILLER_19_84 VPWR VGND VPWR VGND sky130_fd_sc_hd__decap_3
XFILLER_19_149 VPWR VGND VPWR VGND sky130_fd_sc_hd__decap_3
XFILLER_35_50 VPWR VGND VPWR VGND sky130_fd_sc_hd__decap_3
XFILLER_27_193 VPWR VGND VPWR VGND sky130_fd_sc_hd__decap_3
XFILLER_15_355 VPWR VGND VPWR VGND sky130_fd_sc_hd__decap_3
XFILLER_35_72 VPWR VGND VPWR VGND sky130_fd_sc_hd__decap_3
XFILLER_42_141 VPWR VGND VPWR VGND sky130_fd_sc_hd__decap_3
XFILLER_15_388 VPWR VGND VPWR VGND sky130_fd_sc_hd__decap_3
XFILLER_30_336 VPWR VGND VPWR VGND sky130_fd_sc_hd__decap_3
XFILLER_42_174 VPWR VGND VPWR VGND sky130_fd_sc_hd__decap_3
XFILLER_51_60 VPWR VGND VPWR VGND sky130_fd_sc_hd__decap_3
X_216_ net61 _011_ VPWR VGND VPWR VGND sky130_fd_sc_hd__inv_2
X_147_ VPWR VGND VGND VPWR _065_ _067_ _066_ _147_/a_113_47# sky130_fd_sc_hd__nand2_1
XFILLER_25_119 VPWR VGND VPWR VGND sky130_fd_sc_hd__decap_3
XFILLER_18_171 VPWR VGND VPWR VGND sky130_fd_sc_hd__decap_3
XFILLER_33_152 VPWR VGND VPWR VGND sky130_fd_sc_hd__decap_3
XFILLER_33_196 VPWR VGND VPWR VGND sky130_fd_sc_hd__decap_3
XFILLER_21_358 VPWR VGND VPWR VGND sky130_fd_sc_hd__decap_3
XFILLER_56_38 VPWR VGND VPWR VGND sky130_fd_sc_hd__decap_3
XFILLER_56_200 VPWR VGND VPWR VGND sky130_fd_sc_hd__decap_3
XFILLER_56_233 VPWR VGND VPWR VGND sky130_fd_sc_hd__decap_3
XFILLER_16_119 VPWR VGND VPWR VGND sky130_fd_sc_hd__decap_3
XFILLER_56_277 VPWR VGND VPWR VGND sky130_fd_sc_hd__decap_3
XFILLER_24_141 VPWR VGND VPWR VGND sky130_fd_sc_hd__decap_3
XFILLER_24_174 VPWR VGND VPWR VGND sky130_fd_sc_hd__decap_3
XFILLER_12_369 VPWR VGND VPWR VGND sky130_fd_sc_hd__decap_3
XFILLER_21_41 VPWR VGND VPWR VGND sky130_fd_sc_hd__decap_3
XFILLER_21_74 VPWR VGND VPWR VGND sky130_fd_sc_hd__decap_3
XFILLER_21_85 VPWR VGND VPWR VGND sky130_fd_sc_hd__decap_3
XFILLER_47_211 VPWR VGND VPWR VGND sky130_fd_sc_hd__decap_3
XFILLER_47_255 VPWR VGND VPWR VGND sky130_fd_sc_hd__decap_3
XFILLER_62_203 VPWR VGND VPWR VGND sky130_fd_sc_hd__decap_3
XFILLER_62_236 VPWR VGND VPWR VGND sky130_fd_sc_hd__decap_3
XFILLER_47_299 VPWR VGND VPWR VGND sky130_fd_sc_hd__decap_3
XFILLER_46_71 VPWR VGND VPWR VGND sky130_fd_sc_hd__decap_3
XFILLER_15_152 VPWR VGND VPWR VGND sky130_fd_sc_hd__decap_3
XFILLER_30_100 VPWR VGND VPWR VGND sky130_fd_sc_hd__decap_3
XFILLER_30_133 VPWR VGND VPWR VGND sky130_fd_sc_hd__decap_3
XFILLER_30_144 VPWR VGND VPWR VGND sky130_fd_sc_hd__decap_3
XFILLER_7_21 VPWR VGND VPWR VGND sky130_fd_sc_hd__decap_3
XFILLER_30_177 VPWR VGND VPWR VGND sky130_fd_sc_hd__decap_3
XFILLER_11_391 VPWR VGND VPWR VGND sky130_fd_sc_hd__decap_3
XFILLER_7_340 VPWR VGND VPWR VGND sky130_fd_sc_hd__decap_3
XFILLER_7_373 VPWR VGND VPWR VGND sky130_fd_sc_hd__decap_3
XPHY_EDGE_ROW_17_1_Right_16 VPWR VGND VPWR VGND sky130_fd_sc_hd__decap_3
XFILLER_38_200 VPWR VGND VPWR VGND sky130_fd_sc_hd__decap_3
XFILLER_38_233 VPWR VGND VPWR VGND sky130_fd_sc_hd__decap_3
XFILLER_38_277 VPWR VGND VPWR VGND sky130_fd_sc_hd__decap_3
XFILLER_53_214 VPWR VGND VPWR VGND sky130_fd_sc_hd__decap_3
XFILLER_53_225 VPWR VGND VPWR VGND sky130_fd_sc_hd__decap_3
XFILLER_53_258 VPWR VGND VPWR VGND sky130_fd_sc_hd__decap_3
XFILLER_21_122 VPWR VGND VPWR VGND sky130_fd_sc_hd__decap_3
XFILLER_21_144 VPWR VGND VPWR VGND sky130_fd_sc_hd__decap_3
XFILLER_42_18 VPWR VGND VPWR VGND sky130_fd_sc_hd__decap_3
XFILLER_42_29 VPWR VGND VPWR VGND sky130_fd_sc_hd__decap_3
XFILLER_29_211 VPWR VGND VPWR VGND sky130_fd_sc_hd__decap_3
XFILLER_29_255 VPWR VGND VPWR VGND sky130_fd_sc_hd__decap_3
XFILLER_44_203 VPWR VGND VPWR VGND sky130_fd_sc_hd__decap_3
XFILLER_29_299 VPWR VGND VPWR VGND sky130_fd_sc_hd__decap_3
XFILLER_44_236 VPWR VGND VPWR VGND sky130_fd_sc_hd__decap_3
XFILLER_16_41 VPWR VGND VPWR VGND sky130_fd_sc_hd__decap_3
XFILLER_12_100 VPWR VGND VPWR VGND sky130_fd_sc_hd__decap_3
XFILLER_16_85 VPWR VGND VPWR VGND sky130_fd_sc_hd__decap_3
XFILLER_16_74 VPWR VGND VPWR VGND sky130_fd_sc_hd__decap_3
XFILLER_52_280 VPWR VGND VPWR VGND sky130_fd_sc_hd__decap_3
XFILLER_12_144 VPWR VGND VPWR VGND sky130_fd_sc_hd__decap_3
XFILLER_12_133 VPWR VGND VPWR VGND sky130_fd_sc_hd__decap_3
XFILLER_12_177 VPWR VGND VPWR VGND sky130_fd_sc_hd__decap_3
XFILLER_8_159 VPWR VGND VPWR VGND sky130_fd_sc_hd__decap_3
XFILLER_32_62 VPWR VGND VPWR VGND sky130_fd_sc_hd__decap_3
XFILLER_4_343 VPWR VGND VPWR VGND sky130_fd_sc_hd__decap_3
XFILLER_4_354 VPWR VGND VPWR VGND sky130_fd_sc_hd__decap_3
XFILLER_4_387 VPWR VGND VPWR VGND sky130_fd_sc_hd__decap_3
XFILLER_57_92 VPWR VGND VPWR VGND sky130_fd_sc_hd__decap_3
XFILLER_35_214 VPWR VGND VPWR VGND sky130_fd_sc_hd__decap_3
XFILLER_35_225 VPWR VGND VPWR VGND sky130_fd_sc_hd__decap_3
XFILLER_35_258 VPWR VGND VPWR VGND sky130_fd_sc_hd__decap_3
XFILLER_50_206 VPWR VGND VPWR VGND sky130_fd_sc_hd__decap_3
XPHY_EDGE_ROW_8_1_Left_114 VPWR VGND VPWR VGND sky130_fd_sc_hd__decap_3
XFILLER_50_239 VPWR VGND VPWR VGND sky130_fd_sc_hd__decap_3
XPHY_EDGE_ROW_14_2_Right_100 VPWR VGND VPWR VGND sky130_fd_sc_hd__decap_3
XFILLER_58_339 VPWR VGND VPWR VGND sky130_fd_sc_hd__decap_3
XFILLER_26_203 VPWR VGND VPWR VGND sky130_fd_sc_hd__decap_3
XFILLER_26_236 VPWR VGND VPWR VGND sky130_fd_sc_hd__decap_3
XFILLER_41_228 VPWR VGND VPWR VGND sky130_fd_sc_hd__decap_3
XFILLER_41_217 VPWR VGND VPWR VGND sky130_fd_sc_hd__decap_3
XFILLER_34_280 VPWR VGND VPWR VGND sky130_fd_sc_hd__decap_3
XFILLER_1_346 VPWR VGND VPWR VGND sky130_fd_sc_hd__decap_3
XFILLER_49_317 VPWR VGND VPWR VGND sky130_fd_sc_hd__decap_3
XFILLER_64_309 VPWR VGND VPWR VGND sky130_fd_sc_hd__decap_3
XFILLER_57_361 VPWR VGND VPWR VGND sky130_fd_sc_hd__decap_3
XFILLER_27_84 VPWR VGND VPWR VGND sky130_fd_sc_hd__decap_3
XFILLER_32_206 VPWR VGND VPWR VGND sky130_fd_sc_hd__decap_3
XFILLER_32_239 VPWR VGND VPWR VGND sky130_fd_sc_hd__decap_3
XFILLER_43_72 VPWR VGND VPWR VGND sky130_fd_sc_hd__decap_3
XFILLER_40_283 VPWR VGND VPWR VGND sky130_fd_sc_hd__decap_3
XPHY_EDGE_ROW_13_2_Left_34 VPWR VGND VPWR VGND sky130_fd_sc_hd__decap_3
XFILLER_4_162 VPWR VGND VPWR VGND sky130_fd_sc_hd__decap_3
XFILLER_4_44 VPWR VGND VPWR VGND sky130_fd_sc_hd__decap_3
XFILLER_4_77 VPWR VGND VPWR VGND sky130_fd_sc_hd__decap_3
XFILLER_4_88 VPWR VGND VPWR VGND sky130_fd_sc_hd__decap_3
XPHY_EDGE_ROW_6_2_Right_92 VPWR VGND VPWR VGND sky130_fd_sc_hd__decap_3
XFILLER_63_320 VPWR VGND VPWR VGND sky130_fd_sc_hd__decap_3
XFILLER_48_383 VPWR VGND VPWR VGND sky130_fd_sc_hd__decap_3
XFILLER_63_364 VPWR VGND VPWR VGND sky130_fd_sc_hd__decap_3
XFILLER_23_228 VPWR VGND VPWR VGND sky130_fd_sc_hd__decap_3
XFILLER_23_217 VPWR VGND VPWR VGND sky130_fd_sc_hd__decap_3
XFILLER_31_261 VPWR VGND VPWR VGND sky130_fd_sc_hd__decap_3
XPHY_EDGE_ROW_15_2_Right_101 VPWR VGND VPWR VGND sky130_fd_sc_hd__decap_3
XFILLER_58_147 VPWR VGND VPWR VGND sky130_fd_sc_hd__decap_3
XFILLER_58_125 VPWR VGND VPWR VGND sky130_fd_sc_hd__decap_3
XFILLER_46_309 VPWR VGND VPWR VGND sky130_fd_sc_hd__decap_3
XFILLER_39_361 VPWR VGND VPWR VGND sky130_fd_sc_hd__decap_3
XFILLER_64_38 VPWR VGND VPWR VGND sky130_fd_sc_hd__decap_3
XFILLER_54_342 VPWR VGND VPWR VGND sky130_fd_sc_hd__decap_3
XFILLER_54_386 VPWR VGND VPWR VGND sky130_fd_sc_hd__decap_3
XFILLER_22_283 VPWR VGND VPWR VGND sky130_fd_sc_hd__decap_3
X_180_ VPWR VGND VGND VPWR _093_ genblk1\[11\].fa_inst.b genblk1\[11\].fa_inst.a _180_/a_150_297#
+ _180_/a_68_297# sky130_fd_sc_hd__or2_1
XFILLER_13_75 VPWR VGND VPWR VGND sky130_fd_sc_hd__decap_3
XFILLER_1_143 VPWR VGND VPWR VGND sky130_fd_sc_hd__decap_3
XFILLER_49_103 VPWR VGND VPWR VGND sky130_fd_sc_hd__decap_3
XFILLER_49_125 VPWR VGND VPWR VGND sky130_fd_sc_hd__decap_3
XFILLER_64_106 VPWR VGND VPWR VGND sky130_fd_sc_hd__decap_3
XFILLER_38_50 VPWR VGND VPWR VGND sky130_fd_sc_hd__decap_3
XFILLER_49_158 VPWR VGND VPWR VGND sky130_fd_sc_hd__decap_3
XFILLER_49_169 VPWR VGND VPWR VGND sky130_fd_sc_hd__decap_3
XFILLER_64_128 VPWR VGND VPWR VGND sky130_fd_sc_hd__decap_3
XFILLER_45_320 VPWR VGND VPWR VGND sky130_fd_sc_hd__decap_3
XFILLER_38_94 VPWR VGND VPWR VGND sky130_fd_sc_hd__decap_3
XFILLER_60_312 VPWR VGND VPWR VGND sky130_fd_sc_hd__decap_3
XFILLER_60_301 VPWR VGND VPWR VGND sky130_fd_sc_hd__decap_3
XFILLER_45_364 VPWR VGND VPWR VGND sky130_fd_sc_hd__decap_3
XFILLER_60_345 VPWR VGND VPWR VGND sky130_fd_sc_hd__decap_3
XFILLER_54_71 VPWR VGND VPWR VGND sky130_fd_sc_hd__decap_3
XFILLER_60_389 VPWR VGND VPWR VGND sky130_fd_sc_hd__decap_3
XFILLER_28_309 VPWR VGND VPWR VGND sky130_fd_sc_hd__decap_3
XFILLER_48_180 VPWR VGND VPWR VGND sky130_fd_sc_hd__decap_3
XFILLER_55_128 VPWR VGND VPWR VGND sky130_fd_sc_hd__decap_3
XFILLER_36_342 VPWR VGND VPWR VGND sky130_fd_sc_hd__decap_3
XFILLER_63_161 VPWR VGND VPWR VGND sky130_fd_sc_hd__decap_3
XFILLER_63_172 VPWR VGND VPWR VGND sky130_fd_sc_hd__decap_3
XFILLER_36_386 VPWR VGND VPWR VGND sky130_fd_sc_hd__decap_3
XFILLER_51_323 VPWR VGND VPWR VGND sky130_fd_sc_hd__decap_3
XFILLER_51_367 VPWR VGND VPWR VGND sky130_fd_sc_hd__decap_3
XFILLER_50_18 VPWR VGND VPWR VGND sky130_fd_sc_hd__decap_3
XFILLER_50_29 VPWR VGND VPWR VGND sky130_fd_sc_hd__decap_3
XFILLER_59_27 VPWR VGND VPWR VGND sky130_fd_sc_hd__decap_3
XPHY_EDGE_ROW_16_2_Right_102 VPWR VGND VPWR VGND sky130_fd_sc_hd__decap_3
XFILLER_1_9 VPWR VGND VPWR VGND sky130_fd_sc_hd__decap_3
XFILLER_46_106 VPWR VGND VPWR VGND sky130_fd_sc_hd__decap_3
XFILLER_27_320 VPWR VGND VPWR VGND sky130_fd_sc_hd__decap_3
XFILLER_42_312 VPWR VGND VPWR VGND sky130_fd_sc_hd__decap_3
XFILLER_42_301 VPWR VGND VPWR VGND sky130_fd_sc_hd__decap_3
XFILLER_27_364 VPWR VGND VPWR VGND sky130_fd_sc_hd__decap_3
XFILLER_54_150 VPWR VGND VPWR VGND sky130_fd_sc_hd__decap_3
XFILLER_42_345 VPWR VGND VPWR VGND sky130_fd_sc_hd__decap_3
XFILLER_54_183 VPWR VGND VPWR VGND sky130_fd_sc_hd__decap_3
XFILLER_42_389 VPWR VGND VPWR VGND sky130_fd_sc_hd__decap_3
XFILLER_24_41 VPWR VGND VPWR VGND sky130_fd_sc_hd__decap_3
X_301_ VGND VPWR VPWR VGND clknet_2_3__leaf_clk_regs net21 _046_ genblk1\[13\].fa_inst.b
+ _301_/a_1462_47# _301_/a_543_47# _301_/a_651_413# _301_/a_193_47# _301_/a_805_47#
+ _301_/a_448_47# _301_/a_639_47# _301_/a_1283_21# _301_/a_761_289# _301_/a_1108_47#
+ _301_/a_1217_47# _301_/a_1270_413# _301_/a_27_47# sky130_fd_sc_hd__dfrtp_1
XFILLER_24_74 VPWR VGND VPWR VGND sky130_fd_sc_hd__decap_3
XFILLER_24_85 VPWR VGND VPWR VGND sky130_fd_sc_hd__decap_3
X_232_ net59 _027_ VPWR VGND VPWR VGND sky130_fd_sc_hd__inv_2
X_163_ VGND VPWR VGND VPWR _080_ _076_ _073_ _074_ _163_/a_215_297# _163_/a_27_413#
+ _163_/a_298_297# _163_/a_382_47# sky130_fd_sc_hd__a21bo_1
XFILLER_40_62 VPWR VGND VPWR VGND sky130_fd_sc_hd__decap_3
XFILLER_34_9 VPWR VGND VPWR VGND sky130_fd_sc_hd__decap_3
XFILLER_49_60 VPWR VGND VPWR VGND sky130_fd_sc_hd__decap_3
XFILLER_49_82 VPWR VGND VPWR VGND sky130_fd_sc_hd__decap_3
XFILLER_1_12 VPWR VGND VPWR VGND sky130_fd_sc_hd__decap_3
XFILLER_1_45 VPWR VGND VPWR VGND sky130_fd_sc_hd__decap_3
XFILLER_37_128 VPWR VGND VPWR VGND sky130_fd_sc_hd__decap_3
XFILLER_1_78 VPWR VGND VPWR VGND sky130_fd_sc_hd__decap_3
XFILLER_18_331 VPWR VGND VPWR VGND sky130_fd_sc_hd__decap_3
XFILLER_18_375 VPWR VGND VPWR VGND sky130_fd_sc_hd__decap_3
XFILLER_45_172 VPWR VGND VPWR VGND sky130_fd_sc_hd__decap_3
XFILLER_45_161 VPWR VGND VPWR VGND sky130_fd_sc_hd__decap_3
XFILLER_33_323 VPWR VGND VPWR VGND sky130_fd_sc_hd__decap_3
XFILLER_60_153 VPWR VGND VPWR VGND sky130_fd_sc_hd__decap_3
XFILLER_33_367 VPWR VGND VPWR VGND sky130_fd_sc_hd__decap_3
XFILLER_60_197 VPWR VGND VPWR VGND sky130_fd_sc_hd__decap_3
XFILLER_60_186 VPWR VGND VPWR VGND sky130_fd_sc_hd__decap_3
XFILLER_56_404 VPWR VGND VPWR VGND sky130_fd_sc_hd__decap_3
XFILLER_28_117 VPWR VGND VPWR VGND sky130_fd_sc_hd__decap_3
XFILLER_36_150 VPWR VGND VPWR VGND sky130_fd_sc_hd__decap_3
XFILLER_24_301 VPWR VGND VPWR VGND sky130_fd_sc_hd__decap_3
XFILLER_36_183 VPWR VGND VPWR VGND sky130_fd_sc_hd__decap_3
XFILLER_24_312 VPWR VGND VPWR VGND sky130_fd_sc_hd__decap_3
XFILLER_24_345 VPWR VGND VPWR VGND sky130_fd_sc_hd__decap_3
XFILLER_51_131 VPWR VGND VPWR VGND sky130_fd_sc_hd__decap_3
XFILLER_51_164 VPWR VGND VPWR VGND sky130_fd_sc_hd__decap_3
XFILLER_61_39 VPWR VGND VPWR VGND sky130_fd_sc_hd__decap_3
XFILLER_24_389 VPWR VGND VPWR VGND sky130_fd_sc_hd__decap_3
XFILLER_51_175 VPWR VGND VPWR VGND sky130_fd_sc_hd__decap_3
XFILLER_10_21 VPWR VGND VPWR VGND sky130_fd_sc_hd__decap_3
XFILLER_10_32 VPWR VGND VPWR VGND sky130_fd_sc_hd__decap_3
XFILLER_59_231 VPWR VGND VPWR VGND sky130_fd_sc_hd__decap_3
XFILLER_59_220 VPWR VGND VPWR VGND sky130_fd_sc_hd__decap_3
XPHY_EDGE_ROW_17_2_Right_103 VPWR VGND VPWR VGND sky130_fd_sc_hd__decap_3
XFILLER_59_264 VPWR VGND VPWR VGND sky130_fd_sc_hd__decap_3
XFILLER_19_52 VPWR VGND VPWR VGND sky130_fd_sc_hd__decap_3
XFILLER_19_63 VPWR VGND VPWR VGND sky130_fd_sc_hd__decap_3
XFILLER_19_128 VPWR VGND VPWR VGND sky130_fd_sc_hd__decap_3
XFILLER_27_161 VPWR VGND VPWR VGND sky130_fd_sc_hd__decap_3
XFILLER_34_109 VPWR VGND VPWR VGND sky130_fd_sc_hd__decap_3
XFILLER_15_334 VPWR VGND VPWR VGND sky130_fd_sc_hd__decap_3
XFILLER_27_172 VPWR VGND VPWR VGND sky130_fd_sc_hd__decap_3
XFILLER_42_120 VPWR VGND VPWR VGND sky130_fd_sc_hd__decap_3
XFILLER_15_367 VPWR VGND VPWR VGND sky130_fd_sc_hd__decap_3
XFILLER_35_84 VPWR VGND VPWR VGND sky130_fd_sc_hd__decap_3
XFILLER_30_304 VPWR VGND VPWR VGND sky130_fd_sc_hd__decap_3
XFILLER_42_153 VPWR VGND VPWR VGND sky130_fd_sc_hd__decap_3
XFILLER_30_315 VPWR VGND VPWR VGND sky130_fd_sc_hd__decap_3
XFILLER_42_186 VPWR VGND VPWR VGND sky130_fd_sc_hd__decap_3
XFILLER_42_197 VPWR VGND VPWR VGND sky130_fd_sc_hd__decap_3
XFILLER_30_348 VPWR VGND VPWR VGND sky130_fd_sc_hd__decap_3
X_215_ net61 _010_ VPWR VGND VPWR VGND sky130_fd_sc_hd__inv_2
X_146_ VPWR VGND VGND VPWR genblk1\[4\].fa_inst.b _066_ genblk1\[4\].fa_inst.a _146_/a_113_47#
+ sky130_fd_sc_hd__nand2_1
XFILLER_51_83 VPWR VGND VPWR VGND sky130_fd_sc_hd__decap_3
XPHY_EDGE_ROW_29_Left_135 VPWR VGND VPWR VGND sky130_fd_sc_hd__decap_3
XFILLER_32_6 VPWR VGND VPWR VGND sky130_fd_sc_hd__decap_3
XFILLER_38_404 VPWR VGND VPWR VGND sky130_fd_sc_hd__decap_3
XFILLER_18_150 VPWR VGND VPWR VGND sky130_fd_sc_hd__decap_3
XFILLER_25_109 VPWR VGND VPWR VGND sky130_fd_sc_hd__decap_3
XFILLER_33_131 VPWR VGND VPWR VGND sky130_fd_sc_hd__decap_3
XPHY_EDGE_ROW_38_Left_144 VPWR VGND VPWR VGND sky130_fd_sc_hd__decap_3
XFILLER_33_175 VPWR VGND VPWR VGND sky130_fd_sc_hd__decap_3
XFILLER_33_164 VPWR VGND VPWR VGND sky130_fd_sc_hd__decap_3
XFILLER_21_315 VPWR VGND VPWR VGND sky130_fd_sc_hd__decap_3
XFILLER_21_337 VPWR VGND VPWR VGND sky130_fd_sc_hd__decap_3
XPHY_EDGE_ROW_47_Left_153 VPWR VGND VPWR VGND sky130_fd_sc_hd__decap_3
XFILLER_56_212 VPWR VGND VPWR VGND sky130_fd_sc_hd__decap_3
XFILLER_56_245 VPWR VGND VPWR VGND sky130_fd_sc_hd__decap_3
XFILLER_56_256 VPWR VGND VPWR VGND sky130_fd_sc_hd__decap_3
XFILLER_56_289 VPWR VGND VPWR VGND sky130_fd_sc_hd__decap_3
XFILLER_24_120 VPWR VGND VPWR VGND sky130_fd_sc_hd__decap_3
XPHY_EDGE_ROW_56_Left_162 VPWR VGND VPWR VGND sky130_fd_sc_hd__decap_3
XFILLER_24_153 VPWR VGND VPWR VGND sky130_fd_sc_hd__decap_3
XFILLER_24_186 VPWR VGND VPWR VGND sky130_fd_sc_hd__decap_3
XFILLER_12_337 VPWR VGND VPWR VGND sky130_fd_sc_hd__decap_3
XFILLER_24_197 VPWR VGND VPWR VGND sky130_fd_sc_hd__decap_3
XFILLER_20_381 VPWR VGND VPWR VGND sky130_fd_sc_hd__decap_3
XPHY_EDGE_ROW_18_2_Right_104 VPWR VGND VPWR VGND sky130_fd_sc_hd__decap_3
XFILLER_47_234 VPWR VGND VPWR VGND sky130_fd_sc_hd__decap_3
XFILLER_62_215 VPWR VGND VPWR VGND sky130_fd_sc_hd__decap_3
XFILLER_46_50 VPWR VGND VPWR VGND sky130_fd_sc_hd__decap_3
XFILLER_47_267 VPWR VGND VPWR VGND sky130_fd_sc_hd__decap_3
XFILLER_62_248 VPWR VGND VPWR VGND sky130_fd_sc_hd__decap_3
XFILLER_46_94 VPWR VGND VPWR VGND sky130_fd_sc_hd__decap_3
XFILLER_62_259 VPWR VGND VPWR VGND sky130_fd_sc_hd__decap_3
XFILLER_15_131 VPWR VGND VPWR VGND sky130_fd_sc_hd__decap_3
XFILLER_15_164 VPWR VGND VPWR VGND sky130_fd_sc_hd__decap_3
XFILLER_15_175 VPWR VGND VPWR VGND sky130_fd_sc_hd__decap_3
XFILLER_30_112 VPWR VGND VPWR VGND sky130_fd_sc_hd__decap_3
XFILLER_62_71 VPWR VGND VPWR VGND sky130_fd_sc_hd__decap_3
XFILLER_30_156 VPWR VGND VPWR VGND sky130_fd_sc_hd__decap_3
XFILLER_11_370 VPWR VGND VPWR VGND sky130_fd_sc_hd__decap_3
XFILLER_7_33 VPWR VGND VPWR VGND sky130_fd_sc_hd__decap_3
XFILLER_30_189 VPWR VGND VPWR VGND sky130_fd_sc_hd__decap_3
XFILLER_7_352 VPWR VGND VPWR VGND sky130_fd_sc_hd__decap_3
XFILLER_7_88 VPWR VGND VPWR VGND sky130_fd_sc_hd__decap_3
XFILLER_7_385 VPWR VGND VPWR VGND sky130_fd_sc_hd__decap_3
X_129_ VGND VPWR _052_ genblk1\[0\].fa_inst.s net75 VPWR VGND _129_/a_129_47# _129_/a_47_47#
+ _129_/a_285_47# _129_/a_377_297# sky130_fd_sc_hd__xnor2_1
XFILLER_38_212 VPWR VGND VPWR VGND sky130_fd_sc_hd__decap_3
XFILLER_38_245 VPWR VGND VPWR VGND sky130_fd_sc_hd__decap_3
XFILLER_38_256 VPWR VGND VPWR VGND sky130_fd_sc_hd__decap_3
XFILLER_38_289 VPWR VGND VPWR VGND sky130_fd_sc_hd__decap_3
XFILLER_53_237 VPWR VGND VPWR VGND sky130_fd_sc_hd__decap_3
XFILLER_61_270 VPWR VGND VPWR VGND sky130_fd_sc_hd__decap_3
XFILLER_61_281 VPWR VGND VPWR VGND sky130_fd_sc_hd__decap_3
XFILLER_21_134 VPWR VGND VPWR VGND sky130_fd_sc_hd__decap_3
XFILLER_21_156 VPWR VGND VPWR VGND sky130_fd_sc_hd__decap_3
XFILLER_21_178 VPWR VGND VPWR VGND sky130_fd_sc_hd__decap_3
XFILLER_29_234 VPWR VGND VPWR VGND sky130_fd_sc_hd__decap_3
XFILLER_29_267 VPWR VGND VPWR VGND sky130_fd_sc_hd__decap_3
XFILLER_44_215 VPWR VGND VPWR VGND sky130_fd_sc_hd__decap_3
XFILLER_16_53 VPWR VGND VPWR VGND sky130_fd_sc_hd__decap_3
XFILLER_44_248 VPWR VGND VPWR VGND sky130_fd_sc_hd__decap_3
XFILLER_44_259 VPWR VGND VPWR VGND sky130_fd_sc_hd__decap_3
XFILLER_52_292 VPWR VGND VPWR VGND sky130_fd_sc_hd__decap_3
XFILLER_12_112 VPWR VGND VPWR VGND sky130_fd_sc_hd__decap_3
XFILLER_12_156 VPWR VGND VPWR VGND sky130_fd_sc_hd__decap_3
XFILLER_8_127 VPWR VGND VPWR VGND sky130_fd_sc_hd__decap_3
XFILLER_32_41 VPWR VGND VPWR VGND sky130_fd_sc_hd__decap_3
XFILLER_32_85 VPWR VGND VPWR VGND sky130_fd_sc_hd__decap_3
XFILLER_4_366 VPWR VGND VPWR VGND sky130_fd_sc_hd__decap_3
XFILLER_4_399 VPWR VGND VPWR VGND sky130_fd_sc_hd__decap_3
XPHY_EDGE_ROW_19_2_Right_105 VPWR VGND VPWR VGND sky130_fd_sc_hd__decap_3
XFILLER_57_60 VPWR VGND VPWR VGND sky130_fd_sc_hd__decap_3
XPHY_EDGE_ROW_1_1_Right_0 VPWR VGND VPWR VGND sky130_fd_sc_hd__decap_3
XFILLER_35_237 VPWR VGND VPWR VGND sky130_fd_sc_hd__decap_3
XFILLER_43_270 VPWR VGND VPWR VGND sky130_fd_sc_hd__decap_3
XFILLER_50_218 VPWR VGND VPWR VGND sky130_fd_sc_hd__decap_3
XFILLER_43_281 VPWR VGND VPWR VGND sky130_fd_sc_hd__decap_3
XFILLER_58_318 VPWR VGND VPWR VGND sky130_fd_sc_hd__decap_3
XFILLER_26_215 VPWR VGND VPWR VGND sky130_fd_sc_hd__decap_3
XFILLER_26_248 VPWR VGND VPWR VGND sky130_fd_sc_hd__decap_3
XFILLER_26_259 VPWR VGND VPWR VGND sky130_fd_sc_hd__decap_3
XFILLER_34_292 VPWR VGND VPWR VGND sky130_fd_sc_hd__decap_3
XFILLER_5_119 VPWR VGND VPWR VGND sky130_fd_sc_hd__decap_3
XFILLER_1_358 VPWR VGND VPWR VGND sky130_fd_sc_hd__decap_3
XFILLER_49_329 VPWR VGND VPWR VGND sky130_fd_sc_hd__decap_3
XFILLER_57_340 VPWR VGND VPWR VGND sky130_fd_sc_hd__decap_3
XFILLER_57_373 VPWR VGND VPWR VGND sky130_fd_sc_hd__decap_3
XFILLER_27_41 VPWR VGND VPWR VGND sky130_fd_sc_hd__decap_3
XFILLER_27_63 VPWR VGND VPWR VGND sky130_fd_sc_hd__decap_3
XFILLER_27_96 VPWR VGND VPWR VGND sky130_fd_sc_hd__decap_3
XFILLER_32_218 VPWR VGND VPWR VGND sky130_fd_sc_hd__decap_3
XFILLER_25_270 VPWR VGND VPWR VGND sky130_fd_sc_hd__decap_3
XFILLER_25_281 VPWR VGND VPWR VGND sky130_fd_sc_hd__decap_3
XFILLER_43_51 VPWR VGND VPWR VGND sky130_fd_sc_hd__decap_3
XFILLER_40_262 VPWR VGND VPWR VGND sky130_fd_sc_hd__decap_3
XFILLER_40_295 VPWR VGND VPWR VGND sky130_fd_sc_hd__decap_3
XFILLER_43_84 VPWR VGND VPWR VGND sky130_fd_sc_hd__decap_3
XFILLER_4_141 VPWR VGND VPWR VGND sky130_fd_sc_hd__decap_3
XFILLER_4_130 VPWR VGND VPWR VGND sky130_fd_sc_hd__decap_3
XFILLER_4_174 VPWR VGND VPWR VGND sky130_fd_sc_hd__decap_3
XFILLER_4_56 VPWR VGND VPWR VGND sky130_fd_sc_hd__decap_3
XFILLER_0_391 VPWR VGND VPWR VGND sky130_fd_sc_hd__decap_3
XFILLER_48_351 VPWR VGND VPWR VGND sky130_fd_sc_hd__decap_3
XFILLER_48_395 VPWR VGND VPWR VGND sky130_fd_sc_hd__decap_3
XFILLER_63_343 VPWR VGND VPWR VGND sky130_fd_sc_hd__decap_3
XFILLER_63_332 VPWR VGND VPWR VGND sky130_fd_sc_hd__decap_3
XFILLER_63_376 VPWR VGND VPWR VGND sky130_fd_sc_hd__decap_3
XFILLER_31_240 VPWR VGND VPWR VGND sky130_fd_sc_hd__decap_3
XFILLER_31_273 VPWR VGND VPWR VGND sky130_fd_sc_hd__decap_3
XFILLER_31_284 VPWR VGND VPWR VGND sky130_fd_sc_hd__decap_3
XFILLER_48_18 VPWR VGND VPWR VGND sky130_fd_sc_hd__decap_3
XFILLER_58_137 VPWR VGND VPWR VGND sky130_fd_sc_hd__decap_3
XFILLER_58_159 VPWR VGND VPWR VGND sky130_fd_sc_hd__decap_3
XFILLER_39_340 VPWR VGND VPWR VGND sky130_fd_sc_hd__decap_3
XFILLER_64_17 VPWR VGND VPWR VGND sky130_fd_sc_hd__decap_3
XFILLER_54_321 VPWR VGND VPWR VGND sky130_fd_sc_hd__decap_3
XFILLER_39_373 VPWR VGND VPWR VGND sky130_fd_sc_hd__decap_3
XFILLER_54_354 VPWR VGND VPWR VGND sky130_fd_sc_hd__decap_3
XFILLER_54_365 VPWR VGND VPWR VGND sky130_fd_sc_hd__decap_3
XFILLER_54_398 VPWR VGND VPWR VGND sky130_fd_sc_hd__decap_3
XFILLER_10_402 VPWR VGND VPWR VGND sky130_fd_sc_hd__decap_3
XFILLER_22_262 VPWR VGND VPWR VGND sky130_fd_sc_hd__decap_3
XFILLER_22_295 VPWR VGND VPWR VGND sky130_fd_sc_hd__decap_3
XFILLER_13_43 VPWR VGND VPWR VGND sky130_fd_sc_hd__decap_3
XFILLER_13_87 VPWR VGND VPWR VGND sky130_fd_sc_hd__decap_3
XFILLER_1_122 VPWR VGND VPWR VGND sky130_fd_sc_hd__decap_3
XFILLER_1_155 VPWR VGND VPWR VGND sky130_fd_sc_hd__decap_3
XFILLER_49_137 VPWR VGND VPWR VGND sky130_fd_sc_hd__decap_3
XFILLER_38_62 VPWR VGND VPWR VGND sky130_fd_sc_hd__decap_3
XFILLER_45_343 VPWR VGND VPWR VGND sky130_fd_sc_hd__decap_3
XFILLER_45_332 VPWR VGND VPWR VGND sky130_fd_sc_hd__decap_3
XFILLER_57_181 VPWR VGND VPWR VGND sky130_fd_sc_hd__decap_3
XFILLER_45_376 VPWR VGND VPWR VGND sky130_fd_sc_hd__decap_3
XFILLER_54_50 VPWR VGND VPWR VGND sky130_fd_sc_hd__decap_3
XFILLER_60_324 VPWR VGND VPWR VGND sky130_fd_sc_hd__decap_3
XFILLER_60_368 VPWR VGND VPWR VGND sky130_fd_sc_hd__decap_3
XFILLER_60_357 VPWR VGND VPWR VGND sky130_fd_sc_hd__decap_3
XFILLER_54_94 VPWR VGND VPWR VGND sky130_fd_sc_hd__decap_3
XFILLER_62_6 VPWR VGND VPWR VGND sky130_fd_sc_hd__decap_3
XFILLER_36_321 VPWR VGND VPWR VGND sky130_fd_sc_hd__decap_3
XFILLER_36_354 VPWR VGND VPWR VGND sky130_fd_sc_hd__decap_3
XFILLER_48_192 VPWR VGND VPWR VGND sky130_fd_sc_hd__decap_3
XFILLER_63_140 VPWR VGND VPWR VGND sky130_fd_sc_hd__decap_3
XFILLER_51_302 VPWR VGND VPWR VGND sky130_fd_sc_hd__decap_3
XFILLER_36_365 VPWR VGND VPWR VGND sky130_fd_sc_hd__decap_3
XFILLER_63_184 VPWR VGND VPWR VGND sky130_fd_sc_hd__decap_3
XFILLER_51_346 VPWR VGND VPWR VGND sky130_fd_sc_hd__decap_3
XFILLER_36_398 VPWR VGND VPWR VGND sky130_fd_sc_hd__decap_3
XFILLER_51_379 VPWR VGND VPWR VGND sky130_fd_sc_hd__decap_3
XPHY_EDGE_ROW_7_2_Left_28 VPWR VGND VPWR VGND sky130_fd_sc_hd__decap_3
XFILLER_59_39 VPWR VGND VPWR VGND sky130_fd_sc_hd__decap_3
XFILLER_59_402 VPWR VGND VPWR VGND sky130_fd_sc_hd__decap_3
XFILLER_46_118 VPWR VGND VPWR VGND sky130_fd_sc_hd__decap_3
XFILLER_27_332 VPWR VGND VPWR VGND sky130_fd_sc_hd__decap_3
XFILLER_27_343 VPWR VGND VPWR VGND sky130_fd_sc_hd__decap_3
XFILLER_39_181 VPWR VGND VPWR VGND sky130_fd_sc_hd__decap_3
XFILLER_27_376 VPWR VGND VPWR VGND sky130_fd_sc_hd__decap_3
XFILLER_54_162 VPWR VGND VPWR VGND sky130_fd_sc_hd__decap_3
XFILLER_42_324 VPWR VGND VPWR VGND sky130_fd_sc_hd__decap_3
X_300_ VGND VPWR VPWR VGND clknet_2_2__leaf_clk_regs net20 _045_ genblk1\[12\].fa_inst.b
+ _300_/a_1462_47# _300_/a_543_47# _300_/a_651_413# _300_/a_193_47# _300_/a_805_47#
+ _300_/a_448_47# _300_/a_639_47# _300_/a_1283_21# _300_/a_761_289# _300_/a_1108_47#
+ _300_/a_1217_47# _300_/a_1270_413# _300_/a_27_47# sky130_fd_sc_hd__dfrtp_1
XFILLER_42_368 VPWR VGND VPWR VGND sky130_fd_sc_hd__decap_3
XFILLER_42_357 VPWR VGND VPWR VGND sky130_fd_sc_hd__decap_3
XFILLER_24_53 VPWR VGND VPWR VGND sky130_fd_sc_hd__decap_3
X_231_ net59 _026_ VPWR VGND VPWR VGND sky130_fd_sc_hd__inv_2
X_162_ VPWR VGND VGND VPWR _077_ _079_ _078_ _162_/a_113_47# sky130_fd_sc_hd__nand2_1
XFILLER_40_41 VPWR VGND VPWR VGND sky130_fd_sc_hd__decap_3
XFILLER_40_85 VPWR VGND VPWR VGND sky130_fd_sc_hd__decap_3
XFILLER_49_50 VPWR VGND VPWR VGND sky130_fd_sc_hd__decap_3
XFILLER_27_9 VPWR VGND VPWR VGND sky130_fd_sc_hd__decap_3
XFILLER_49_94 VPWR VGND VPWR VGND sky130_fd_sc_hd__decap_3
XFILLER_1_24 VPWR VGND VPWR VGND sky130_fd_sc_hd__decap_3
XFILLER_37_107 VPWR VGND VPWR VGND sky130_fd_sc_hd__decap_3
XFILLER_1_57 VPWR VGND VPWR VGND sky130_fd_sc_hd__decap_3
XFILLER_18_343 VPWR VGND VPWR VGND sky130_fd_sc_hd__decap_3
XFILLER_18_354 VPWR VGND VPWR VGND sky130_fd_sc_hd__decap_3
XFILLER_33_302 VPWR VGND VPWR VGND sky130_fd_sc_hd__decap_3
XFILLER_45_140 VPWR VGND VPWR VGND sky130_fd_sc_hd__decap_3
XFILLER_60_121 VPWR VGND VPWR VGND sky130_fd_sc_hd__decap_3
XFILLER_18_387 VPWR VGND VPWR VGND sky130_fd_sc_hd__decap_3
XFILLER_33_346 VPWR VGND VPWR VGND sky130_fd_sc_hd__decap_3
XFILLER_45_184 VPWR VGND VPWR VGND sky130_fd_sc_hd__decap_3
XFILLER_60_165 VPWR VGND VPWR VGND sky130_fd_sc_hd__decap_3
XFILLER_33_379 VPWR VGND VPWR VGND sky130_fd_sc_hd__decap_3
Xinput1 VGND VPWR net1 a[0] VPWR VGND input1/a_75_212# sky130_fd_sc_hd__clkbuf_1
XFILLER_28_129 VPWR VGND VPWR VGND sky130_fd_sc_hd__decap_3
XFILLER_36_162 VPWR VGND VPWR VGND sky130_fd_sc_hd__decap_3
XFILLER_24_324 VPWR VGND VPWR VGND sky130_fd_sc_hd__decap_3
XFILLER_24_357 VPWR VGND VPWR VGND sky130_fd_sc_hd__decap_3
XFILLER_24_368 VPWR VGND VPWR VGND sky130_fd_sc_hd__decap_3
XFILLER_51_143 VPWR VGND VPWR VGND sky130_fd_sc_hd__decap_3
XFILLER_61_18 VPWR VGND VPWR VGND sky130_fd_sc_hd__decap_3
XFILLER_51_187 VPWR VGND VPWR VGND sky130_fd_sc_hd__decap_3
XPHY_EDGE_ROW_13_1_Left_119 VPWR VGND VPWR VGND sky130_fd_sc_hd__decap_3
XFILLER_10_77 VPWR VGND VPWR VGND sky130_fd_sc_hd__decap_3
XFILLER_10_88 VPWR VGND VPWR VGND sky130_fd_sc_hd__decap_3
XFILLER_59_243 VPWR VGND VPWR VGND sky130_fd_sc_hd__decap_3
XFILLER_59_287 VPWR VGND VPWR VGND sky130_fd_sc_hd__decap_3
XFILLER_59_276 VPWR VGND VPWR VGND sky130_fd_sc_hd__decap_3
XFILLER_19_75 VPWR VGND VPWR VGND sky130_fd_sc_hd__decap_3
XFILLER_27_140 VPWR VGND VPWR VGND sky130_fd_sc_hd__decap_3
XFILLER_35_41 VPWR VGND VPWR VGND sky130_fd_sc_hd__decap_3
XFILLER_27_184 VPWR VGND VPWR VGND sky130_fd_sc_hd__decap_3
XFILLER_15_346 VPWR VGND VPWR VGND sky130_fd_sc_hd__decap_3
XFILLER_35_63 VPWR VGND VPWR VGND sky130_fd_sc_hd__decap_3
XFILLER_42_132 VPWR VGND VPWR VGND sky130_fd_sc_hd__decap_3
XFILLER_35_96 VPWR VGND VPWR VGND sky130_fd_sc_hd__decap_3
XFILLER_30_327 VPWR VGND VPWR VGND sky130_fd_sc_hd__decap_3
XFILLER_42_165 VPWR VGND VPWR VGND sky130_fd_sc_hd__decap_3
X_214_ net59 _009_ VPWR VGND VPWR VGND sky130_fd_sc_hd__inv_2
X_145_ VPWR VGND VGND VPWR _065_ genblk1\[4\].fa_inst.b genblk1\[4\].fa_inst.a _145_/a_150_297#
+ _145_/a_68_297# sky130_fd_sc_hd__or2_1
XFILLER_51_95 VPWR VGND VPWR VGND sky130_fd_sc_hd__decap_3
XFILLER_25_6 VPWR VGND VPWR VGND sky130_fd_sc_hd__decap_3
XFILLER_18_162 VPWR VGND VPWR VGND sky130_fd_sc_hd__decap_3
XFILLER_33_143 VPWR VGND VPWR VGND sky130_fd_sc_hd__decap_3
XFILLER_33_187 VPWR VGND VPWR VGND sky130_fd_sc_hd__decap_3
XFILLER_21_305 VPWR VGND VPWR VGND sky130_fd_sc_hd__decap_3
XFILLER_21_327 VPWR VGND VPWR VGND sky130_fd_sc_hd__decap_3
XFILLER_14_390 VPWR VGND VPWR VGND sky130_fd_sc_hd__decap_3
XFILLER_21_349 VPWR VGND VPWR VGND sky130_fd_sc_hd__decap_3
XFILLER_56_18 VPWR VGND VPWR VGND sky130_fd_sc_hd__decap_3
XFILLER_56_29 VPWR VGND VPWR VGND sky130_fd_sc_hd__decap_3
XFILLER_56_224 VPWR VGND VPWR VGND sky130_fd_sc_hd__decap_3
XPHY_EDGE_ROW_11_2_Right_97 VPWR VGND VPWR VGND sky130_fd_sc_hd__decap_3
XFILLER_56_268 VPWR VGND VPWR VGND sky130_fd_sc_hd__decap_3
XFILLER_64_290 VPWR VGND VPWR VGND sky130_fd_sc_hd__decap_3
XFILLER_24_132 VPWR VGND VPWR VGND sky130_fd_sc_hd__decap_3
XFILLER_24_165 VPWR VGND VPWR VGND sky130_fd_sc_hd__decap_3
XFILLER_12_349 VPWR VGND VPWR VGND sky130_fd_sc_hd__decap_3
XFILLER_20_360 VPWR VGND VPWR VGND sky130_fd_sc_hd__decap_3
XFILLER_21_21 VPWR VGND VPWR VGND sky130_fd_sc_hd__decap_3
XFILLER_20_393 VPWR VGND VPWR VGND sky130_fd_sc_hd__decap_3
XFILLER_21_32 VPWR VGND VPWR VGND sky130_fd_sc_hd__decap_3
XFILLER_21_65 VPWR VGND VPWR VGND sky130_fd_sc_hd__decap_3
XFILLER_47_202 VPWR VGND VPWR VGND sky130_fd_sc_hd__decap_3
XFILLER_47_246 VPWR VGND VPWR VGND sky130_fd_sc_hd__decap_3
XFILLER_62_227 VPWR VGND VPWR VGND sky130_fd_sc_hd__decap_3
XFILLER_46_62 VPWR VGND VPWR VGND sky130_fd_sc_hd__decap_3
XFILLER_55_290 VPWR VGND VPWR VGND sky130_fd_sc_hd__decap_3
XFILLER_15_143 VPWR VGND VPWR VGND sky130_fd_sc_hd__decap_3
XFILLER_62_50 VPWR VGND VPWR VGND sky130_fd_sc_hd__decap_3
XFILLER_30_124 VPWR VGND VPWR VGND sky130_fd_sc_hd__decap_3
XFILLER_62_94 VPWR VGND VPWR VGND sky130_fd_sc_hd__decap_3
XFILLER_7_12 VPWR VGND VPWR VGND sky130_fd_sc_hd__decap_3
XFILLER_30_168 VPWR VGND VPWR VGND sky130_fd_sc_hd__decap_3
XFILLER_11_382 VPWR VGND VPWR VGND sky130_fd_sc_hd__decap_3
XFILLER_7_331 VPWR VGND VPWR VGND sky130_fd_sc_hd__decap_3
XFILLER_7_364 VPWR VGND VPWR VGND sky130_fd_sc_hd__decap_3
X_128_ VPWR VGND VGND VPWR _050_ _052_ _051_ _128_/a_113_47# sky130_fd_sc_hd__nand2_1
XFILLER_7_397 VPWR VGND VPWR VGND sky130_fd_sc_hd__decap_3
XFILLER_23_3 VPWR VGND VPWR VGND sky130_fd_sc_hd__decap_3
XFILLER_38_224 VPWR VGND VPWR VGND sky130_fd_sc_hd__decap_3
XFILLER_38_268 VPWR VGND VPWR VGND sky130_fd_sc_hd__decap_3
XFILLER_53_205 VPWR VGND VPWR VGND sky130_fd_sc_hd__decap_3
XFILLER_53_249 VPWR VGND VPWR VGND sky130_fd_sc_hd__decap_3
XFILLER_61_293 VPWR VGND VPWR VGND sky130_fd_sc_hd__decap_3
XFILLER_21_113 VPWR VGND VPWR VGND sky130_fd_sc_hd__decap_3
XFILLER_29_202 VPWR VGND VPWR VGND sky130_fd_sc_hd__decap_3
XFILLER_29_246 VPWR VGND VPWR VGND sky130_fd_sc_hd__decap_3
XFILLER_44_227 VPWR VGND VPWR VGND sky130_fd_sc_hd__decap_3
XFILLER_16_21 VPWR VGND VPWR VGND sky130_fd_sc_hd__decap_3
XFILLER_37_290 VPWR VGND VPWR VGND sky130_fd_sc_hd__decap_3
XFILLER_16_65 VPWR VGND VPWR VGND sky130_fd_sc_hd__decap_3
XFILLER_52_271 VPWR VGND VPWR VGND sky130_fd_sc_hd__decap_3
XFILLER_12_124 VPWR VGND VPWR VGND sky130_fd_sc_hd__decap_3
XFILLER_12_168 VPWR VGND VPWR VGND sky130_fd_sc_hd__decap_3
XFILLER_32_53 VPWR VGND VPWR VGND sky130_fd_sc_hd__decap_3
XFILLER_32_75 VPWR VGND VPWR VGND sky130_fd_sc_hd__decap_3
XFILLER_4_334 VPWR VGND VPWR VGND sky130_fd_sc_hd__decap_3
XFILLER_4_378 VPWR VGND VPWR VGND sky130_fd_sc_hd__decap_3
XFILLER_35_205 VPWR VGND VPWR VGND sky130_fd_sc_hd__decap_3
XFILLER_35_249 VPWR VGND VPWR VGND sky130_fd_sc_hd__decap_3
XFILLER_43_293 VPWR VGND VPWR VGND sky130_fd_sc_hd__decap_3
XFILLER_7_172 VPWR VGND VPWR VGND sky130_fd_sc_hd__decap_3
XFILLER_7_161 VPWR VGND VPWR VGND sky130_fd_sc_hd__decap_3
XFILLER_26_227 VPWR VGND VPWR VGND sky130_fd_sc_hd__decap_3
XFILLER_41_208 VPWR VGND VPWR VGND sky130_fd_sc_hd__decap_3
XFILLER_34_271 VPWR VGND VPWR VGND sky130_fd_sc_hd__decap_3
XFILLER_1_337 VPWR VGND VPWR VGND sky130_fd_sc_hd__decap_3
XFILLER_49_308 VPWR VGND VPWR VGND sky130_fd_sc_hd__decap_3
XFILLER_57_352 VPWR VGND VPWR VGND sky130_fd_sc_hd__decap_3
XFILLER_57_396 VPWR VGND VPWR VGND sky130_fd_sc_hd__decap_3
XFILLER_57_385 VPWR VGND VPWR VGND sky130_fd_sc_hd__decap_3
XFILLER_27_53 VPWR VGND VPWR VGND sky130_fd_sc_hd__decap_3
XPHY_EDGE_ROW_16_1_Right_15 VPWR VGND VPWR VGND sky130_fd_sc_hd__decap_3
XFILLER_27_75 VPWR VGND VPWR VGND sky130_fd_sc_hd__decap_3
XFILLER_13_400 VPWR VGND VPWR VGND sky130_fd_sc_hd__decap_3
XFILLER_25_293 VPWR VGND VPWR VGND sky130_fd_sc_hd__decap_3
XFILLER_43_63 VPWR VGND VPWR VGND sky130_fd_sc_hd__decap_3
XFILLER_40_230 VPWR VGND VPWR VGND sky130_fd_sc_hd__decap_3
XFILLER_40_274 VPWR VGND VPWR VGND sky130_fd_sc_hd__decap_3
XFILLER_57_9 VPWR VGND VPWR VGND sky130_fd_sc_hd__decap_3
XFILLER_4_153 VPWR VGND VPWR VGND sky130_fd_sc_hd__decap_3
XFILLER_4_35 VPWR VGND VPWR VGND sky130_fd_sc_hd__decap_3
XFILLER_4_68 VPWR VGND VPWR VGND sky130_fd_sc_hd__decap_3
XFILLER_48_330 VPWR VGND VPWR VGND sky130_fd_sc_hd__decap_3
XFILLER_63_311 VPWR VGND VPWR VGND sky130_fd_sc_hd__decap_3
XFILLER_48_374 VPWR VGND VPWR VGND sky130_fd_sc_hd__decap_3
XFILLER_63_355 VPWR VGND VPWR VGND sky130_fd_sc_hd__decap_3
XFILLER_63_388 VPWR VGND VPWR VGND sky130_fd_sc_hd__decap_3
XFILLER_23_208 VPWR VGND VPWR VGND sky130_fd_sc_hd__decap_3
XFILLER_63_399 VPWR VGND VPWR VGND sky130_fd_sc_hd__decap_3
XFILLER_31_252 VPWR VGND VPWR VGND sky130_fd_sc_hd__decap_3
XFILLER_31_296 VPWR VGND VPWR VGND sky130_fd_sc_hd__decap_3
XFILLER_39_352 VPWR VGND VPWR VGND sky130_fd_sc_hd__decap_3
XFILLER_39_385 VPWR VGND VPWR VGND sky130_fd_sc_hd__decap_3
XFILLER_64_29 VPWR VGND VPWR VGND sky130_fd_sc_hd__decap_3
XFILLER_39_396 VPWR VGND VPWR VGND sky130_fd_sc_hd__decap_3
XFILLER_54_333 VPWR VGND VPWR VGND sky130_fd_sc_hd__decap_3
XFILLER_54_377 VPWR VGND VPWR VGND sky130_fd_sc_hd__decap_3
Xfanout56 VPWR VGND net56 net58 VPWR VGND fanout56/a_27_47# sky130_fd_sc_hd__buf_4
XFILLER_22_241 VPWR VGND VPWR VGND sky130_fd_sc_hd__decap_3
XFILLER_22_274 VPWR VGND VPWR VGND sky130_fd_sc_hd__decap_3
XFILLER_1_134 VPWR VGND VPWR VGND sky130_fd_sc_hd__decap_3
XPHY_EDGE_ROW_7_1_Left_113 VPWR VGND VPWR VGND sky130_fd_sc_hd__decap_3
XFILLER_49_116 VPWR VGND VPWR VGND sky130_fd_sc_hd__decap_3
XFILLER_38_41 VPWR VGND VPWR VGND sky130_fd_sc_hd__decap_3
XFILLER_49_149 VPWR VGND VPWR VGND sky130_fd_sc_hd__decap_3
XFILLER_64_119 VPWR VGND VPWR VGND sky130_fd_sc_hd__decap_3
XFILLER_45_311 VPWR VGND VPWR VGND sky130_fd_sc_hd__decap_3
XFILLER_38_85 VPWR VGND VPWR VGND sky130_fd_sc_hd__decap_3
XFILLER_57_193 VPWR VGND VPWR VGND sky130_fd_sc_hd__decap_3
XFILLER_45_388 VPWR VGND VPWR VGND sky130_fd_sc_hd__decap_3
XFILLER_45_355 VPWR VGND VPWR VGND sky130_fd_sc_hd__decap_3
XFILLER_60_336 VPWR VGND VPWR VGND sky130_fd_sc_hd__decap_3
XFILLER_45_399 VPWR VGND VPWR VGND sky130_fd_sc_hd__decap_3
XFILLER_54_62 VPWR VGND VPWR VGND sky130_fd_sc_hd__decap_3
XFILLER_55_6 VPWR VGND VPWR VGND sky130_fd_sc_hd__decap_3
XFILLER_48_171 VPWR VGND VPWR VGND sky130_fd_sc_hd__decap_3
XFILLER_55_119 VPWR VGND VPWR VGND sky130_fd_sc_hd__decap_3
XFILLER_36_333 VPWR VGND VPWR VGND sky130_fd_sc_hd__decap_3
XFILLER_63_152 VPWR VGND VPWR VGND sky130_fd_sc_hd__decap_3
XFILLER_36_377 VPWR VGND VPWR VGND sky130_fd_sc_hd__decap_3
XFILLER_63_196 VPWR VGND VPWR VGND sky130_fd_sc_hd__decap_3
XFILLER_51_314 VPWR VGND VPWR VGND sky130_fd_sc_hd__decap_3
XFILLER_51_358 VPWR VGND VPWR VGND sky130_fd_sc_hd__decap_3
XFILLER_59_18 VPWR VGND VPWR VGND sky130_fd_sc_hd__decap_3
XFILLER_27_311 VPWR VGND VPWR VGND sky130_fd_sc_hd__decap_3
XFILLER_39_193 VPWR VGND VPWR VGND sky130_fd_sc_hd__decap_3
XFILLER_54_130 VPWR VGND VPWR VGND sky130_fd_sc_hd__decap_3
XFILLER_27_355 VPWR VGND VPWR VGND sky130_fd_sc_hd__decap_3
XFILLER_54_141 VPWR VGND VPWR VGND sky130_fd_sc_hd__decap_3
XFILLER_42_336 VPWR VGND VPWR VGND sky130_fd_sc_hd__decap_3
XFILLER_27_388 VPWR VGND VPWR VGND sky130_fd_sc_hd__decap_3
XFILLER_27_399 VPWR VGND VPWR VGND sky130_fd_sc_hd__decap_3
XFILLER_54_174 VPWR VGND VPWR VGND sky130_fd_sc_hd__decap_3
XFILLER_24_21 VPWR VGND VPWR VGND sky130_fd_sc_hd__decap_3
XFILLER_24_32 VPWR VGND VPWR VGND sky130_fd_sc_hd__decap_3
XFILLER_24_65 VPWR VGND VPWR VGND sky130_fd_sc_hd__decap_3
X_230_ net58 _025_ VPWR VGND VPWR VGND sky130_fd_sc_hd__inv_2
XFILLER_50_380 VPWR VGND VPWR VGND sky130_fd_sc_hd__decap_3
X_161_ VPWR VGND VGND VPWR genblk1\[7\].fa_inst.b _078_ genblk1\[7\].fa_inst.a _161_/a_113_47#
+ sky130_fd_sc_hd__nand2_1
XPHY_EDGE_ROW_5_2_Right_91 VPWR VGND VPWR VGND sky130_fd_sc_hd__decap_3
XFILLER_40_53 VPWR VGND VPWR VGND sky130_fd_sc_hd__decap_3
XFILLER_49_73 VPWR VGND VPWR VGND sky130_fd_sc_hd__decap_3
XFILLER_1_36 VPWR VGND VPWR VGND sky130_fd_sc_hd__decap_3
XFILLER_37_119 VPWR VGND VPWR VGND sky130_fd_sc_hd__decap_3
XFILLER_1_69 VPWR VGND VPWR VGND sky130_fd_sc_hd__decap_3
XFILLER_18_366 VPWR VGND VPWR VGND sky130_fd_sc_hd__decap_3
XFILLER_45_152 VPWR VGND VPWR VGND sky130_fd_sc_hd__decap_3
XFILLER_60_100 VPWR VGND VPWR VGND sky130_fd_sc_hd__decap_3
XFILLER_33_314 VPWR VGND VPWR VGND sky130_fd_sc_hd__decap_3
XFILLER_18_399 VPWR VGND VPWR VGND sky130_fd_sc_hd__decap_3
XFILLER_45_196 VPWR VGND VPWR VGND sky130_fd_sc_hd__decap_3
XFILLER_60_144 VPWR VGND VPWR VGND sky130_fd_sc_hd__decap_3
XFILLER_60_133 VPWR VGND VPWR VGND sky130_fd_sc_hd__decap_3
XFILLER_33_358 VPWR VGND VPWR VGND sky130_fd_sc_hd__decap_3
XFILLER_60_177 VPWR VGND VPWR VGND sky130_fd_sc_hd__decap_3
XFILLER_53_3 VPWR VGND VPWR VGND sky130_fd_sc_hd__decap_3
Xinput2 VGND VPWR net2 a[10] VPWR VGND input2/a_27_47# sky130_fd_sc_hd__buf_1
XFILLER_36_130 VPWR VGND VPWR VGND sky130_fd_sc_hd__decap_3
XFILLER_36_141 VPWR VGND VPWR VGND sky130_fd_sc_hd__decap_3
XFILLER_36_174 VPWR VGND VPWR VGND sky130_fd_sc_hd__decap_3
XFILLER_24_336 VPWR VGND VPWR VGND sky130_fd_sc_hd__decap_3
XFILLER_51_122 VPWR VGND VPWR VGND sky130_fd_sc_hd__decap_3
XFILLER_51_155 VPWR VGND VPWR VGND sky130_fd_sc_hd__decap_3
XPHY_EDGE_ROW_27_Right_48 VPWR VGND VPWR VGND sky130_fd_sc_hd__decap_3
XFILLER_32_380 VPWR VGND VPWR VGND sky130_fd_sc_hd__decap_3
XFILLER_51_199 VPWR VGND VPWR VGND sky130_fd_sc_hd__decap_3
XFILLER_10_12 VPWR VGND VPWR VGND sky130_fd_sc_hd__decap_3
XFILLER_10_56 VPWR VGND VPWR VGND sky130_fd_sc_hd__decap_3
XPHY_EDGE_ROW_36_Right_57 VPWR VGND VPWR VGND sky130_fd_sc_hd__decap_3
XFILLER_59_211 VPWR VGND VPWR VGND sky130_fd_sc_hd__decap_3
XFILLER_59_255 VPWR VGND VPWR VGND sky130_fd_sc_hd__decap_3
XFILLER_19_43 VPWR VGND VPWR VGND sky130_fd_sc_hd__decap_3
XFILLER_19_119 VPWR VGND VPWR VGND sky130_fd_sc_hd__decap_3
XFILLER_59_299 VPWR VGND VPWR VGND sky130_fd_sc_hd__decap_3
XFILLER_19_87 VPWR VGND VPWR VGND sky130_fd_sc_hd__decap_3
XFILLER_27_152 VPWR VGND VPWR VGND sky130_fd_sc_hd__decap_3
XFILLER_42_111 VPWR VGND VPWR VGND sky130_fd_sc_hd__decap_3
XPHY_EDGE_ROW_45_Right_66 VPWR VGND VPWR VGND sky130_fd_sc_hd__decap_3
XFILLER_15_358 VPWR VGND VPWR VGND sky130_fd_sc_hd__decap_3
XFILLER_35_53 VPWR VGND VPWR VGND sky130_fd_sc_hd__decap_3
XFILLER_35_75 VPWR VGND VPWR VGND sky130_fd_sc_hd__decap_3
XFILLER_27_196 VPWR VGND VPWR VGND sky130_fd_sc_hd__decap_3
XFILLER_42_144 VPWR VGND VPWR VGND sky130_fd_sc_hd__decap_3
XFILLER_42_177 VPWR VGND VPWR VGND sky130_fd_sc_hd__decap_3
X_213_ net59 _008_ VPWR VGND VPWR VGND sky130_fd_sc_hd__inv_2
XFILLER_30_339 VPWR VGND VPWR VGND sky130_fd_sc_hd__decap_3
XFILLER_51_52 VPWR VGND VPWR VGND sky130_fd_sc_hd__decap_3
XFILLER_51_63 VPWR VGND VPWR VGND sky130_fd_sc_hd__decap_3
X_144_ VGND VPWR _064_ genblk1\[3\].fa_inst.s _063_ VPWR VGND _144_/a_129_47# _144_/a_47_47#
+ _144_/a_285_47# _144_/a_377_297# sky130_fd_sc_hd__xnor2_1
XPHY_EDGE_ROW_54_Right_75 VPWR VGND VPWR VGND sky130_fd_sc_hd__decap_3
XFILLER_18_6 VPWR VGND VPWR VGND sky130_fd_sc_hd__decap_3
XFILLER_18_130 VPWR VGND VPWR VGND sky130_fd_sc_hd__decap_3
XFILLER_18_141 VPWR VGND VPWR VGND sky130_fd_sc_hd__decap_3
XPHY_EDGE_ROW_63_Right_84 VPWR VGND VPWR VGND sky130_fd_sc_hd__decap_3
XFILLER_18_174 VPWR VGND VPWR VGND sky130_fd_sc_hd__decap_3
XFILLER_33_122 VPWR VGND VPWR VGND sky130_fd_sc_hd__decap_3
XFILLER_33_155 VPWR VGND VPWR VGND sky130_fd_sc_hd__decap_3
XFILLER_33_199 VPWR VGND VPWR VGND sky130_fd_sc_hd__decap_3
XFILLER_56_203 VPWR VGND VPWR VGND sky130_fd_sc_hd__decap_3
XFILLER_56_236 VPWR VGND VPWR VGND sky130_fd_sc_hd__decap_3
XFILLER_24_111 VPWR VGND VPWR VGND sky130_fd_sc_hd__decap_3
XFILLER_24_144 VPWR VGND VPWR VGND sky130_fd_sc_hd__decap_3
XFILLER_24_177 VPWR VGND VPWR VGND sky130_fd_sc_hd__decap_3
XFILLER_20_372 VPWR VGND VPWR VGND sky130_fd_sc_hd__decap_3
XFILLER_21_44 VPWR VGND VPWR VGND sky130_fd_sc_hd__decap_3
XFILLER_21_88 VPWR VGND VPWR VGND sky130_fd_sc_hd__decap_3
XFILLER_21_77 VPWR VGND VPWR VGND sky130_fd_sc_hd__decap_3
XFILLER_47_214 VPWR VGND VPWR VGND sky130_fd_sc_hd__decap_3
XFILLER_47_225 VPWR VGND VPWR VGND sky130_fd_sc_hd__decap_3
XFILLER_62_206 VPWR VGND VPWR VGND sky130_fd_sc_hd__decap_3
XFILLER_46_41 VPWR VGND VPWR VGND sky130_fd_sc_hd__decap_3
XFILLER_47_258 VPWR VGND VPWR VGND sky130_fd_sc_hd__decap_3
XFILLER_62_239 VPWR VGND VPWR VGND sky130_fd_sc_hd__decap_3
XFILLER_46_74 VPWR VGND VPWR VGND sky130_fd_sc_hd__decap_3
XFILLER_46_85 VPWR VGND VPWR VGND sky130_fd_sc_hd__decap_3
XFILLER_15_122 VPWR VGND VPWR VGND sky130_fd_sc_hd__decap_3
XFILLER_15_155 VPWR VGND VPWR VGND sky130_fd_sc_hd__decap_3
XFILLER_30_103 VPWR VGND VPWR VGND sky130_fd_sc_hd__decap_3
XFILLER_62_62 VPWR VGND VPWR VGND sky130_fd_sc_hd__decap_3
XFILLER_30_136 VPWR VGND VPWR VGND sky130_fd_sc_hd__decap_3
XFILLER_30_147 VPWR VGND VPWR VGND sky130_fd_sc_hd__decap_3
XFILLER_11_361 VPWR VGND VPWR VGND sky130_fd_sc_hd__decap_3
XFILLER_7_24 VPWR VGND VPWR VGND sky130_fd_sc_hd__decap_3
XFILLER_11_394 VPWR VGND VPWR VGND sky130_fd_sc_hd__decap_3
XFILLER_7_343 VPWR VGND VPWR VGND sky130_fd_sc_hd__decap_3
X_127_ VPWR VGND VGND VPWR genblk1\[0\].fa_inst.b _051_ genblk1\[0\].fa_inst.a _127_/a_113_47#
+ sky130_fd_sc_hd__nand2_1
XFILLER_7_57 VPWR VGND VPWR VGND sky130_fd_sc_hd__decap_3
XFILLER_7_376 VPWR VGND VPWR VGND sky130_fd_sc_hd__decap_3
XFILLER_38_203 VPWR VGND VPWR VGND sky130_fd_sc_hd__decap_3
XFILLER_38_236 VPWR VGND VPWR VGND sky130_fd_sc_hd__decap_3
XFILLER_53_228 VPWR VGND VPWR VGND sky130_fd_sc_hd__decap_3
XFILLER_53_217 VPWR VGND VPWR VGND sky130_fd_sc_hd__decap_3
XFILLER_46_280 VPWR VGND VPWR VGND sky130_fd_sc_hd__decap_3
XFILLER_61_261 VPWR VGND VPWR VGND sky130_fd_sc_hd__decap_3
XFILLER_21_125 VPWR VGND VPWR VGND sky130_fd_sc_hd__decap_3
XFILLER_21_147 VPWR VGND VPWR VGND sky130_fd_sc_hd__decap_3
XFILLER_21_169 VPWR VGND VPWR VGND sky130_fd_sc_hd__decap_3
XFILLER_29_214 VPWR VGND VPWR VGND sky130_fd_sc_hd__decap_3
XFILLER_29_225 VPWR VGND VPWR VGND sky130_fd_sc_hd__decap_3
XFILLER_29_258 VPWR VGND VPWR VGND sky130_fd_sc_hd__decap_3
XFILLER_44_206 VPWR VGND VPWR VGND sky130_fd_sc_hd__decap_3
XFILLER_16_44 VPWR VGND VPWR VGND sky130_fd_sc_hd__decap_3
XFILLER_44_239 VPWR VGND VPWR VGND sky130_fd_sc_hd__decap_3
XFILLER_40_401 VPWR VGND VPWR VGND sky130_fd_sc_hd__decap_3
XFILLER_16_77 VPWR VGND VPWR VGND sky130_fd_sc_hd__decap_3
XFILLER_12_136 VPWR VGND VPWR VGND sky130_fd_sc_hd__decap_3
XFILLER_52_283 VPWR VGND VPWR VGND sky130_fd_sc_hd__decap_3
XFILLER_12_147 VPWR VGND VPWR VGND sky130_fd_sc_hd__decap_3
XFILLER_32_21 VPWR VGND VPWR VGND sky130_fd_sc_hd__decap_3
XFILLER_32_32 VPWR VGND VPWR VGND sky130_fd_sc_hd__decap_3
XFILLER_32_65 VPWR VGND VPWR VGND sky130_fd_sc_hd__decap_3
XFILLER_4_357 VPWR VGND VPWR VGND sky130_fd_sc_hd__decap_3
XFILLER_4_346 VPWR VGND VPWR VGND sky130_fd_sc_hd__decap_3
XFILLER_57_40 VPWR VGND VPWR VGND sky130_fd_sc_hd__decap_3
XFILLER_57_95 VPWR VGND VPWR VGND sky130_fd_sc_hd__decap_3
XFILLER_35_228 VPWR VGND VPWR VGND sky130_fd_sc_hd__decap_3
XFILLER_35_217 VPWR VGND VPWR VGND sky130_fd_sc_hd__decap_3
XFILLER_28_280 VPWR VGND VPWR VGND sky130_fd_sc_hd__decap_3
XFILLER_43_261 VPWR VGND VPWR VGND sky130_fd_sc_hd__decap_3
XFILLER_50_209 VPWR VGND VPWR VGND sky130_fd_sc_hd__decap_3
XFILLER_7_140 VPWR VGND VPWR VGND sky130_fd_sc_hd__decap_3
XFILLER_58_309 VPWR VGND VPWR VGND sky130_fd_sc_hd__decap_3
XFILLER_26_206 VPWR VGND VPWR VGND sky130_fd_sc_hd__decap_3
XFILLER_26_239 VPWR VGND VPWR VGND sky130_fd_sc_hd__decap_3
XFILLER_22_401 VPWR VGND VPWR VGND sky130_fd_sc_hd__decap_3
XFILLER_34_283 VPWR VGND VPWR VGND sky130_fd_sc_hd__decap_3
XFILLER_1_349 VPWR VGND VPWR VGND sky130_fd_sc_hd__decap_3
XFILLER_57_320 VPWR VGND VPWR VGND sky130_fd_sc_hd__decap_3
XFILLER_57_364 VPWR VGND VPWR VGND sky130_fd_sc_hd__decap_3
XFILLER_27_87 VPWR VGND VPWR VGND sky130_fd_sc_hd__decap_3
XFILLER_32_209 VPWR VGND VPWR VGND sky130_fd_sc_hd__decap_3
XFILLER_25_261 VPWR VGND VPWR VGND sky130_fd_sc_hd__decap_3
XFILLER_43_42 VPWR VGND VPWR VGND sky130_fd_sc_hd__decap_3
XFILLER_40_253 VPWR VGND VPWR VGND sky130_fd_sc_hd__decap_3
XFILLER_40_242 VPWR VGND VPWR VGND sky130_fd_sc_hd__decap_3
XFILLER_43_75 VPWR VGND VPWR VGND sky130_fd_sc_hd__decap_3
XFILLER_40_286 VPWR VGND VPWR VGND sky130_fd_sc_hd__decap_3
XFILLER_4_121 VPWR VGND VPWR VGND sky130_fd_sc_hd__decap_3
XFILLER_4_165 VPWR VGND VPWR VGND sky130_fd_sc_hd__decap_3
XFILLER_4_47 VPWR VGND VPWR VGND sky130_fd_sc_hd__decap_3
XFILLER_0_382 VPWR VGND VPWR VGND sky130_fd_sc_hd__decap_3
XFILLER_0_360 VPWR VGND VPWR VGND sky130_fd_sc_hd__decap_3
XFILLER_48_342 VPWR VGND VPWR VGND sky130_fd_sc_hd__decap_3
XFILLER_48_386 VPWR VGND VPWR VGND sky130_fd_sc_hd__decap_3
XFILLER_63_323 VPWR VGND VPWR VGND sky130_fd_sc_hd__decap_3
XFILLER_63_367 VPWR VGND VPWR VGND sky130_fd_sc_hd__decap_3
XFILLER_31_220 VPWR VGND VPWR VGND sky130_fd_sc_hd__decap_3
XFILLER_31_231 VPWR VGND VPWR VGND sky130_fd_sc_hd__decap_3
XFILLER_31_264 VPWR VGND VPWR VGND sky130_fd_sc_hd__decap_3
XFILLER_58_128 VPWR VGND VPWR VGND sky130_fd_sc_hd__decap_3
XFILLER_39_320 VPWR VGND VPWR VGND sky130_fd_sc_hd__decap_3
XFILLER_54_312 VPWR VGND VPWR VGND sky130_fd_sc_hd__decap_3
XFILLER_54_301 VPWR VGND VPWR VGND sky130_fd_sc_hd__decap_3
XFILLER_39_364 VPWR VGND VPWR VGND sky130_fd_sc_hd__decap_3
XFILLER_54_345 VPWR VGND VPWR VGND sky130_fd_sc_hd__decap_3
XFILLER_54_389 VPWR VGND VPWR VGND sky130_fd_sc_hd__decap_3
Xfanout57 VPWR VGND net57 net58 VPWR VGND fanout57/a_27_47# sky130_fd_sc_hd__buf_2
XFILLER_22_253 VPWR VGND VPWR VGND sky130_fd_sc_hd__decap_3
XFILLER_22_286 VPWR VGND VPWR VGND sky130_fd_sc_hd__decap_3
XFILLER_13_34 VPWR VGND VPWR VGND sky130_fd_sc_hd__decap_3
XFILLER_13_78 VPWR VGND VPWR VGND sky130_fd_sc_hd__decap_3
XFILLER_1_113 VPWR VGND VPWR VGND sky130_fd_sc_hd__decap_3
XFILLER_1_102 VPWR VGND VPWR VGND sky130_fd_sc_hd__decap_3
XFILLER_1_146 VPWR VGND VPWR VGND sky130_fd_sc_hd__decap_3
XFILLER_49_106 VPWR VGND VPWR VGND sky130_fd_sc_hd__decap_3
XFILLER_49_128 VPWR VGND VPWR VGND sky130_fd_sc_hd__decap_3
XFILLER_38_53 VPWR VGND VPWR VGND sky130_fd_sc_hd__decap_3
XFILLER_64_109 VPWR VGND VPWR VGND sky130_fd_sc_hd__decap_3
XFILLER_38_97 VPWR VGND VPWR VGND sky130_fd_sc_hd__decap_3
XFILLER_57_161 VPWR VGND VPWR VGND sky130_fd_sc_hd__decap_3
XFILLER_45_323 VPWR VGND VPWR VGND sky130_fd_sc_hd__decap_3
XFILLER_57_172 VPWR VGND VPWR VGND sky130_fd_sc_hd__decap_3
XFILLER_60_304 VPWR VGND VPWR VGND sky130_fd_sc_hd__decap_3
XFILLER_45_367 VPWR VGND VPWR VGND sky130_fd_sc_hd__decap_3
XFILLER_54_41 VPWR VGND VPWR VGND sky130_fd_sc_hd__decap_3
XFILLER_60_315 VPWR VGND VPWR VGND sky130_fd_sc_hd__decap_3
XFILLER_54_74 VPWR VGND VPWR VGND sky130_fd_sc_hd__decap_3
XFILLER_60_348 VPWR VGND VPWR VGND sky130_fd_sc_hd__decap_3
XFILLER_54_85 VPWR VGND VPWR VGND sky130_fd_sc_hd__decap_3
XFILLER_48_6 VPWR VGND VPWR VGND sky130_fd_sc_hd__decap_3
XFILLER_36_301 VPWR VGND VPWR VGND sky130_fd_sc_hd__decap_3
XFILLER_48_150 VPWR VGND VPWR VGND sky130_fd_sc_hd__decap_3
XFILLER_36_312 VPWR VGND VPWR VGND sky130_fd_sc_hd__decap_3
XFILLER_36_345 VPWR VGND VPWR VGND sky130_fd_sc_hd__decap_3
XFILLER_48_183 VPWR VGND VPWR VGND sky130_fd_sc_hd__decap_3
XFILLER_63_164 VPWR VGND VPWR VGND sky130_fd_sc_hd__decap_3
XFILLER_63_131 VPWR VGND VPWR VGND sky130_fd_sc_hd__decap_3
XFILLER_63_175 VPWR VGND VPWR VGND sky130_fd_sc_hd__decap_3
XFILLER_51_337 VPWR VGND VPWR VGND sky130_fd_sc_hd__decap_3
XFILLER_51_326 VPWR VGND VPWR VGND sky130_fd_sc_hd__decap_3
XFILLER_36_389 VPWR VGND VPWR VGND sky130_fd_sc_hd__decap_3
XFILLER_39_161 VPWR VGND VPWR VGND sky130_fd_sc_hd__decap_3
XFILLER_46_109 VPWR VGND VPWR VGND sky130_fd_sc_hd__decap_3
XFILLER_27_323 VPWR VGND VPWR VGND sky130_fd_sc_hd__decap_3
XFILLER_39_172 VPWR VGND VPWR VGND sky130_fd_sc_hd__decap_3
XFILLER_27_367 VPWR VGND VPWR VGND sky130_fd_sc_hd__decap_3
XFILLER_54_153 VPWR VGND VPWR VGND sky130_fd_sc_hd__decap_3
XFILLER_42_315 VPWR VGND VPWR VGND sky130_fd_sc_hd__decap_3
XFILLER_42_304 VPWR VGND VPWR VGND sky130_fd_sc_hd__decap_3
XFILLER_54_186 VPWR VGND VPWR VGND sky130_fd_sc_hd__decap_3
XFILLER_54_197 VPWR VGND VPWR VGND sky130_fd_sc_hd__decap_3
XFILLER_42_348 VPWR VGND VPWR VGND sky130_fd_sc_hd__decap_3
XFILLER_24_44 VPWR VGND VPWR VGND sky130_fd_sc_hd__decap_3
XFILLER_50_392 VPWR VGND VPWR VGND sky130_fd_sc_hd__decap_3
XFILLER_24_77 VPWR VGND VPWR VGND sky130_fd_sc_hd__decap_3
X_160_ VPWR VGND VGND VPWR _077_ genblk1\[7\].fa_inst.b genblk1\[7\].fa_inst.a _160_/a_150_297#
+ _160_/a_68_297# sky130_fd_sc_hd__or2_1
XFILLER_40_32 VPWR VGND VPWR VGND sky130_fd_sc_hd__decap_3
XFILLER_40_21 VPWR VGND VPWR VGND sky130_fd_sc_hd__decap_3
XFILLER_40_76 VPWR VGND VPWR VGND sky130_fd_sc_hd__decap_3
XFILLER_40_65 VPWR VGND VPWR VGND sky130_fd_sc_hd__decap_3
XFILLER_49_41 VPWR VGND VPWR VGND sky130_fd_sc_hd__decap_3
XFILLER_49_85 VPWR VGND VPWR VGND sky130_fd_sc_hd__decap_3
XFILLER_1_15 VPWR VGND VPWR VGND sky130_fd_sc_hd__decap_3
XFILLER_1_48 VPWR VGND VPWR VGND sky130_fd_sc_hd__decap_3
XFILLER_18_334 VPWR VGND VPWR VGND sky130_fd_sc_hd__decap_3
XFILLER_45_131 VPWR VGND VPWR VGND sky130_fd_sc_hd__decap_3
XFILLER_60_112 VPWR VGND VPWR VGND sky130_fd_sc_hd__decap_3
XFILLER_18_378 VPWR VGND VPWR VGND sky130_fd_sc_hd__decap_3
XFILLER_33_326 VPWR VGND VPWR VGND sky130_fd_sc_hd__decap_3
XFILLER_33_337 VPWR VGND VPWR VGND sky130_fd_sc_hd__decap_3
XFILLER_45_175 VPWR VGND VPWR VGND sky130_fd_sc_hd__decap_3
XFILLER_45_164 VPWR VGND VPWR VGND sky130_fd_sc_hd__decap_3
XFILLER_60_189 VPWR VGND VPWR VGND sky130_fd_sc_hd__decap_3
XFILLER_60_156 VPWR VGND VPWR VGND sky130_fd_sc_hd__decap_3
XFILLER_41_370 VPWR VGND VPWR VGND sky130_fd_sc_hd__decap_3
X_289_ VGND VPWR VPWR VGND clknet_2_1__leaf_clk_regs net24 _034_ genblk1\[1\].fa_inst.b
+ _289_/a_1462_47# _289_/a_543_47# _289_/a_651_413# _289_/a_193_47# _289_/a_805_47#
+ _289_/a_448_47# _289_/a_639_47# _289_/a_1283_21# _289_/a_761_289# _289_/a_1108_47#
+ _289_/a_1217_47# _289_/a_1270_413# _289_/a_27_47# sky130_fd_sc_hd__dfrtp_1
Xinput3 VGND VPWR net3 a[11] VPWR VGND input3/a_27_47# sky130_fd_sc_hd__buf_1
XFILLER_36_153 VPWR VGND VPWR VGND sky130_fd_sc_hd__decap_3
XFILLER_36_186 VPWR VGND VPWR VGND sky130_fd_sc_hd__decap_3
XFILLER_24_304 VPWR VGND VPWR VGND sky130_fd_sc_hd__decap_3
XFILLER_24_315 VPWR VGND VPWR VGND sky130_fd_sc_hd__decap_3
XFILLER_51_101 VPWR VGND VPWR VGND sky130_fd_sc_hd__decap_3
XFILLER_36_197 VPWR VGND VPWR VGND sky130_fd_sc_hd__decap_3
XFILLER_24_348 VPWR VGND VPWR VGND sky130_fd_sc_hd__decap_3
XFILLER_51_134 VPWR VGND VPWR VGND sky130_fd_sc_hd__decap_3
XFILLER_51_178 VPWR VGND VPWR VGND sky130_fd_sc_hd__decap_3
XFILLER_32_392 VPWR VGND VPWR VGND sky130_fd_sc_hd__decap_3
XFILLER_10_35 VPWR VGND VPWR VGND sky130_fd_sc_hd__decap_3
XFILLER_10_24 VPWR VGND VPWR VGND sky130_fd_sc_hd__decap_3
XFILLER_59_234 VPWR VGND VPWR VGND sky130_fd_sc_hd__decap_3
XFILLER_59_267 VPWR VGND VPWR VGND sky130_fd_sc_hd__decap_3
XFILLER_19_66 VPWR VGND VPWR VGND sky130_fd_sc_hd__decap_3
XFILLER_27_131 VPWR VGND VPWR VGND sky130_fd_sc_hd__decap_3
XFILLER_27_175 VPWR VGND VPWR VGND sky130_fd_sc_hd__decap_3
XFILLER_27_164 VPWR VGND VPWR VGND sky130_fd_sc_hd__decap_3
XFILLER_15_337 VPWR VGND VPWR VGND sky130_fd_sc_hd__decap_3
XFILLER_42_123 VPWR VGND VPWR VGND sky130_fd_sc_hd__decap_3
XFILLER_35_87 VPWR VGND VPWR VGND sky130_fd_sc_hd__decap_3
XFILLER_30_318 VPWR VGND VPWR VGND sky130_fd_sc_hd__decap_3
XFILLER_42_156 VPWR VGND VPWR VGND sky130_fd_sc_hd__decap_3
X_212_ net58 _007_ VPWR VGND VPWR VGND sky130_fd_sc_hd__inv_2
XFILLER_23_370 VPWR VGND VPWR VGND sky130_fd_sc_hd__decap_3
XFILLER_42_189 VPWR VGND VPWR VGND sky130_fd_sc_hd__decap_3
X_143_ VGND VPWR VGND VPWR _064_ _058_ _057_ _059_ _143_/a_215_297# _143_/a_27_413#
+ _143_/a_298_297# _143_/a_382_47# sky130_fd_sc_hd__a21bo_1
XFILLER_51_86 VPWR VGND VPWR VGND sky130_fd_sc_hd__decap_3
XFILLER_32_9 VPWR VGND VPWR VGND sky130_fd_sc_hd__decap_3
XFILLER_18_153 VPWR VGND VPWR VGND sky130_fd_sc_hd__decap_3
XFILLER_33_101 VPWR VGND VPWR VGND sky130_fd_sc_hd__decap_3
XFILLER_33_134 VPWR VGND VPWR VGND sky130_fd_sc_hd__decap_3
XFILLER_33_178 VPWR VGND VPWR VGND sky130_fd_sc_hd__decap_3
XFILLER_21_318 VPWR VGND VPWR VGND sky130_fd_sc_hd__decap_3
XFILLER_14_381 VPWR VGND VPWR VGND sky130_fd_sc_hd__decap_3
XFILLER_2_80 VPWR VGND VPWR VGND sky130_fd_sc_hd__decap_3
XFILLER_56_215 VPWR VGND VPWR VGND sky130_fd_sc_hd__decap_3
XFILLER_2_91 VPWR VGND VPWR VGND sky130_fd_sc_hd__decap_3
XFILLER_56_248 VPWR VGND VPWR VGND sky130_fd_sc_hd__decap_3
XFILLER_56_259 VPWR VGND VPWR VGND sky130_fd_sc_hd__decap_3
XFILLER_64_281 VPWR VGND VPWR VGND sky130_fd_sc_hd__decap_3
XFILLER_24_123 VPWR VGND VPWR VGND sky130_fd_sc_hd__decap_3
XFILLER_24_156 VPWR VGND VPWR VGND sky130_fd_sc_hd__decap_3
XFILLER_24_189 VPWR VGND VPWR VGND sky130_fd_sc_hd__decap_3
XPHY_EDGE_ROW_25_Left_131 VPWR VGND VPWR VGND sky130_fd_sc_hd__decap_3
XFILLER_20_340 VPWR VGND VPWR VGND sky130_fd_sc_hd__decap_3
XFILLER_21_12 VPWR VGND VPWR VGND sky130_fd_sc_hd__decap_3
XFILLER_20_384 VPWR VGND VPWR VGND sky130_fd_sc_hd__decap_3
XPHY_EDGE_ROW_34_Left_140 VPWR VGND VPWR VGND sky130_fd_sc_hd__decap_3
XFILLER_47_237 VPWR VGND VPWR VGND sky130_fd_sc_hd__decap_3
XFILLER_62_218 VPWR VGND VPWR VGND sky130_fd_sc_hd__decap_3
XFILLER_46_53 VPWR VGND VPWR VGND sky130_fd_sc_hd__decap_3
XFILLER_55_270 VPWR VGND VPWR VGND sky130_fd_sc_hd__decap_3
XFILLER_55_281 VPWR VGND VPWR VGND sky130_fd_sc_hd__decap_3
XFILLER_15_134 VPWR VGND VPWR VGND sky130_fd_sc_hd__decap_3
XFILLER_46_97 VPWR VGND VPWR VGND sky130_fd_sc_hd__decap_3
XFILLER_62_41 VPWR VGND VPWR VGND sky130_fd_sc_hd__decap_3
XFILLER_30_115 VPWR VGND VPWR VGND sky130_fd_sc_hd__decap_3
XFILLER_62_85 VPWR VGND VPWR VGND sky130_fd_sc_hd__decap_3
XFILLER_62_74 VPWR VGND VPWR VGND sky130_fd_sc_hd__decap_3
XFILLER_11_340 VPWR VGND VPWR VGND sky130_fd_sc_hd__decap_3
XFILLER_30_159 VPWR VGND VPWR VGND sky130_fd_sc_hd__decap_3
XFILLER_11_373 VPWR VGND VPWR VGND sky130_fd_sc_hd__decap_3
XFILLER_7_36 VPWR VGND VPWR VGND sky130_fd_sc_hd__decap_3
XFILLER_7_355 VPWR VGND VPWR VGND sky130_fd_sc_hd__decap_3
X_126_ VPWR VGND VGND VPWR _050_ genblk1\[0\].fa_inst.b genblk1\[0\].fa_inst.a _126_/a_150_297#
+ _126_/a_68_297# sky130_fd_sc_hd__or2_1
XFILLER_7_388 VPWR VGND VPWR VGND sky130_fd_sc_hd__decap_3
XFILLER_30_6 VPWR VGND VPWR VGND sky130_fd_sc_hd__decap_3
XPHY_EDGE_ROW_12_1_Left_118 VPWR VGND VPWR VGND sky130_fd_sc_hd__decap_3
XFILLER_38_215 VPWR VGND VPWR VGND sky130_fd_sc_hd__decap_3
XFILLER_38_248 VPWR VGND VPWR VGND sky130_fd_sc_hd__decap_3
XFILLER_38_259 VPWR VGND VPWR VGND sky130_fd_sc_hd__decap_3
XFILLER_46_292 VPWR VGND VPWR VGND sky130_fd_sc_hd__decap_3
XFILLER_61_240 VPWR VGND VPWR VGND sky130_fd_sc_hd__decap_3
XFILLER_61_284 VPWR VGND VPWR VGND sky130_fd_sc_hd__decap_3
XFILLER_61_273 VPWR VGND VPWR VGND sky130_fd_sc_hd__decap_3
XFILLER_21_137 VPWR VGND VPWR VGND sky130_fd_sc_hd__decap_3
XFILLER_21_159 VPWR VGND VPWR VGND sky130_fd_sc_hd__decap_3
XFILLER_29_237 VPWR VGND VPWR VGND sky130_fd_sc_hd__decap_3
XFILLER_44_218 VPWR VGND VPWR VGND sky130_fd_sc_hd__decap_3
XFILLER_16_12 VPWR VGND VPWR VGND sky130_fd_sc_hd__decap_3
XFILLER_37_270 VPWR VGND VPWR VGND sky130_fd_sc_hd__decap_3
XFILLER_37_281 VPWR VGND VPWR VGND sky130_fd_sc_hd__decap_3
XFILLER_16_56 VPWR VGND VPWR VGND sky130_fd_sc_hd__decap_3
XFILLER_52_262 VPWR VGND VPWR VGND sky130_fd_sc_hd__decap_3
XFILLER_52_295 VPWR VGND VPWR VGND sky130_fd_sc_hd__decap_3
XFILLER_12_115 VPWR VGND VPWR VGND sky130_fd_sc_hd__decap_3
XFILLER_12_159 VPWR VGND VPWR VGND sky130_fd_sc_hd__decap_3
XFILLER_32_44 VPWR VGND VPWR VGND sky130_fd_sc_hd__decap_3
XFILLER_32_88 VPWR VGND VPWR VGND sky130_fd_sc_hd__decap_3
XFILLER_4_369 VPWR VGND VPWR VGND sky130_fd_sc_hd__decap_3
XFILLER_57_52 VPWR VGND VPWR VGND sky130_fd_sc_hd__decap_3
XFILLER_57_63 VPWR VGND VPWR VGND sky130_fd_sc_hd__decap_3
XFILLER_28_292 VPWR VGND VPWR VGND sky130_fd_sc_hd__decap_3
XFILLER_31_402 VPWR VGND VPWR VGND sky130_fd_sc_hd__decap_3
XFILLER_43_240 VPWR VGND VPWR VGND sky130_fd_sc_hd__decap_3
XFILLER_43_273 VPWR VGND VPWR VGND sky130_fd_sc_hd__decap_3
XFILLER_43_284 VPWR VGND VPWR VGND sky130_fd_sc_hd__decap_3
XPHY_EDGE_ROW_10_2_Right_96 VPWR VGND VPWR VGND sky130_fd_sc_hd__decap_3
XFILLER_7_152 VPWR VGND VPWR VGND sky130_fd_sc_hd__decap_3
XFILLER_3_391 VPWR VGND VPWR VGND sky130_fd_sc_hd__decap_3
XFILLER_26_218 VPWR VGND VPWR VGND sky130_fd_sc_hd__decap_3
XFILLER_34_262 VPWR VGND VPWR VGND sky130_fd_sc_hd__decap_3
XFILLER_34_295 VPWR VGND VPWR VGND sky130_fd_sc_hd__decap_3
XFILLER_1_328 VPWR VGND VPWR VGND sky130_fd_sc_hd__decap_3
XFILLER_57_343 VPWR VGND VPWR VGND sky130_fd_sc_hd__decap_3
XFILLER_57_332 VPWR VGND VPWR VGND sky130_fd_sc_hd__decap_3
XFILLER_57_376 VPWR VGND VPWR VGND sky130_fd_sc_hd__decap_3
XFILLER_27_44 VPWR VGND VPWR VGND sky130_fd_sc_hd__decap_3
XFILLER_27_66 VPWR VGND VPWR VGND sky130_fd_sc_hd__decap_3
XFILLER_27_99 VPWR VGND VPWR VGND sky130_fd_sc_hd__decap_3
XFILLER_25_240 VPWR VGND VPWR VGND sky130_fd_sc_hd__decap_3
XFILLER_25_273 VPWR VGND VPWR VGND sky130_fd_sc_hd__decap_3
XFILLER_25_284 VPWR VGND VPWR VGND sky130_fd_sc_hd__decap_3
XFILLER_40_221 VPWR VGND VPWR VGND sky130_fd_sc_hd__decap_3
XFILLER_43_87 VPWR VGND VPWR VGND sky130_fd_sc_hd__decap_3
XFILLER_40_265 VPWR VGND VPWR VGND sky130_fd_sc_hd__decap_3
XFILLER_40_298 VPWR VGND VPWR VGND sky130_fd_sc_hd__decap_3
XFILLER_4_133 VPWR VGND VPWR VGND sky130_fd_sc_hd__decap_3
XPHY_EDGE_ROW_2_2_Left_23 VPWR VGND VPWR VGND sky130_fd_sc_hd__decap_3
XFILLER_4_144 VPWR VGND VPWR VGND sky130_fd_sc_hd__decap_3
XFILLER_4_177 VPWR VGND VPWR VGND sky130_fd_sc_hd__decap_3
XFILLER_0_372 VPWR VGND VPWR VGND sky130_fd_sc_hd__decap_3
XFILLER_48_321 VPWR VGND VPWR VGND sky130_fd_sc_hd__decap_3
XFILLER_0_394 VPWR VGND VPWR VGND sky130_fd_sc_hd__decap_3
XFILLER_63_302 VPWR VGND VPWR VGND sky130_fd_sc_hd__decap_3
XFILLER_48_365 VPWR VGND VPWR VGND sky130_fd_sc_hd__decap_3
XFILLER_48_354 VPWR VGND VPWR VGND sky130_fd_sc_hd__decap_3
XFILLER_63_346 VPWR VGND VPWR VGND sky130_fd_sc_hd__decap_3
XFILLER_48_398 VPWR VGND VPWR VGND sky130_fd_sc_hd__decap_3
XFILLER_63_379 VPWR VGND VPWR VGND sky130_fd_sc_hd__decap_3
XFILLER_31_243 VPWR VGND VPWR VGND sky130_fd_sc_hd__decap_3
XFILLER_31_276 VPWR VGND VPWR VGND sky130_fd_sc_hd__decap_3
XFILLER_31_287 VPWR VGND VPWR VGND sky130_fd_sc_hd__decap_3
XFILLER_39_343 VPWR VGND VPWR VGND sky130_fd_sc_hd__decap_3
XFILLER_39_332 VPWR VGND VPWR VGND sky130_fd_sc_hd__decap_3
XFILLER_39_376 VPWR VGND VPWR VGND sky130_fd_sc_hd__decap_3
XFILLER_54_324 VPWR VGND VPWR VGND sky130_fd_sc_hd__decap_3
XFILLER_54_368 VPWR VGND VPWR VGND sky130_fd_sc_hd__decap_3
XFILLER_54_357 VPWR VGND VPWR VGND sky130_fd_sc_hd__decap_3
Xfanout58 VPWR VGND net58 net62 VPWR VGND fanout58/a_27_47# sky130_fd_sc_hd__buf_4
XFILLER_22_265 VPWR VGND VPWR VGND sky130_fd_sc_hd__decap_3
XFILLER_13_57 VPWR VGND VPWR VGND sky130_fd_sc_hd__decap_3
XFILLER_13_46 VPWR VGND VPWR VGND sky130_fd_sc_hd__decap_3
XFILLER_22_298 VPWR VGND VPWR VGND sky130_fd_sc_hd__decap_3
XFILLER_1_125 VPWR VGND VPWR VGND sky130_fd_sc_hd__decap_3
XFILLER_8_6 VPWR VGND VPWR VGND sky130_fd_sc_hd__decap_3
XFILLER_1_158 VPWR VGND VPWR VGND sky130_fd_sc_hd__decap_3
XFILLER_1_169 VPWR VGND VPWR VGND sky130_fd_sc_hd__decap_3
XFILLER_38_21 VPWR VGND VPWR VGND sky130_fd_sc_hd__decap_3
XFILLER_38_32 VPWR VGND VPWR VGND sky130_fd_sc_hd__decap_3
XFILLER_45_302 VPWR VGND VPWR VGND sky130_fd_sc_hd__decap_3
XFILLER_38_76 VPWR VGND VPWR VGND sky130_fd_sc_hd__decap_3
XFILLER_38_65 VPWR VGND VPWR VGND sky130_fd_sc_hd__decap_3
XFILLER_57_140 VPWR VGND VPWR VGND sky130_fd_sc_hd__decap_3
XFILLER_57_184 VPWR VGND VPWR VGND sky130_fd_sc_hd__decap_3
XFILLER_45_379 VPWR VGND VPWR VGND sky130_fd_sc_hd__decap_3
XFILLER_45_346 VPWR VGND VPWR VGND sky130_fd_sc_hd__decap_3
XFILLER_60_327 VPWR VGND VPWR VGND sky130_fd_sc_hd__decap_3
XFILLER_54_53 VPWR VGND VPWR VGND sky130_fd_sc_hd__decap_3
XFILLER_62_9 VPWR VGND VPWR VGND sky130_fd_sc_hd__decap_3
XFILLER_48_162 VPWR VGND VPWR VGND sky130_fd_sc_hd__decap_3
XFILLER_36_324 VPWR VGND VPWR VGND sky130_fd_sc_hd__decap_3
XFILLER_63_143 VPWR VGND VPWR VGND sky130_fd_sc_hd__decap_3
XFILLER_36_357 VPWR VGND VPWR VGND sky130_fd_sc_hd__decap_3
XFILLER_36_368 VPWR VGND VPWR VGND sky130_fd_sc_hd__decap_3
XFILLER_63_187 VPWR VGND VPWR VGND sky130_fd_sc_hd__decap_3
XFILLER_51_305 VPWR VGND VPWR VGND sky130_fd_sc_hd__decap_3
XFILLER_51_349 VPWR VGND VPWR VGND sky130_fd_sc_hd__decap_3
XPHY_EDGE_ROW_15_1_Right_14 VPWR VGND VPWR VGND sky130_fd_sc_hd__decap_3
XFILLER_5_91 VPWR VGND VPWR VGND sky130_fd_sc_hd__decap_3
XFILLER_27_302 VPWR VGND VPWR VGND sky130_fd_sc_hd__decap_3
XFILLER_39_140 VPWR VGND VPWR VGND sky130_fd_sc_hd__decap_3
XFILLER_39_184 VPWR VGND VPWR VGND sky130_fd_sc_hd__decap_3
XFILLER_54_121 VPWR VGND VPWR VGND sky130_fd_sc_hd__decap_3
XFILLER_27_346 VPWR VGND VPWR VGND sky130_fd_sc_hd__decap_3
XFILLER_42_327 VPWR VGND VPWR VGND sky130_fd_sc_hd__decap_3
XFILLER_27_379 VPWR VGND VPWR VGND sky130_fd_sc_hd__decap_3
XFILLER_54_165 VPWR VGND VPWR VGND sky130_fd_sc_hd__decap_3
XFILLER_24_12 VPWR VGND VPWR VGND sky130_fd_sc_hd__decap_3
XFILLER_50_360 VPWR VGND VPWR VGND sky130_fd_sc_hd__decap_3
XFILLER_24_56 VPWR VGND VPWR VGND sky130_fd_sc_hd__decap_3
XFILLER_50_371 VPWR VGND VPWR VGND sky130_fd_sc_hd__decap_3
XFILLER_40_44 VPWR VGND VPWR VGND sky130_fd_sc_hd__decap_3
XFILLER_40_88 VPWR VGND VPWR VGND sky130_fd_sc_hd__decap_3
XFILLER_49_53 VPWR VGND VPWR VGND sky130_fd_sc_hd__decap_3
XFILLER_49_97 VPWR VGND VPWR VGND sky130_fd_sc_hd__decap_3
XFILLER_1_27 VPWR VGND VPWR VGND sky130_fd_sc_hd__decap_3
XFILLER_18_346 VPWR VGND VPWR VGND sky130_fd_sc_hd__decap_3
XFILLER_18_357 VPWR VGND VPWR VGND sky130_fd_sc_hd__decap_3
XFILLER_45_143 VPWR VGND VPWR VGND sky130_fd_sc_hd__decap_3
XFILLER_33_305 VPWR VGND VPWR VGND sky130_fd_sc_hd__decap_3
XFILLER_45_187 VPWR VGND VPWR VGND sky130_fd_sc_hd__decap_3
XFILLER_60_124 VPWR VGND VPWR VGND sky130_fd_sc_hd__decap_3
XFILLER_33_349 VPWR VGND VPWR VGND sky130_fd_sc_hd__decap_3
XFILLER_60_168 VPWR VGND VPWR VGND sky130_fd_sc_hd__decap_3
XFILLER_41_393 VPWR VGND VPWR VGND sky130_fd_sc_hd__decap_3
XFILLER_41_382 VPWR VGND VPWR VGND sky130_fd_sc_hd__decap_3
X_288_ VGND VPWR VPWR VGND clknet_2_0__leaf_clk_regs net17 _033_ genblk1\[0\].fa_inst.b
+ _288_/a_1462_47# _288_/a_543_47# _288_/a_651_413# _288_/a_193_47# _288_/a_805_47#
+ _288_/a_448_47# _288_/a_639_47# _288_/a_1283_21# _288_/a_761_289# _288_/a_1108_47#
+ _288_/a_1217_47# _288_/a_1270_413# _288_/a_27_47# sky130_fd_sc_hd__dfrtp_1
XFILLER_39_3 VPWR VGND VPWR VGND sky130_fd_sc_hd__decap_3
Xinput4 VGND VPWR net4 a[12] VPWR VGND input4/a_27_47# sky130_fd_sc_hd__buf_1
XFILLER_36_121 VPWR VGND VPWR VGND sky130_fd_sc_hd__decap_3
XFILLER_36_165 VPWR VGND VPWR VGND sky130_fd_sc_hd__decap_3
XFILLER_24_327 VPWR VGND VPWR VGND sky130_fd_sc_hd__decap_3
XPHY_EDGE_ROW_6_1_Left_112 VPWR VGND VPWR VGND sky130_fd_sc_hd__decap_3
XFILLER_51_113 VPWR VGND VPWR VGND sky130_fd_sc_hd__decap_3
XFILLER_51_146 VPWR VGND VPWR VGND sky130_fd_sc_hd__decap_3
XFILLER_32_360 VPWR VGND VPWR VGND sky130_fd_sc_hd__decap_3
XFILLER_32_371 VPWR VGND VPWR VGND sky130_fd_sc_hd__decap_3
XFILLER_59_202 VPWR VGND VPWR VGND sky130_fd_sc_hd__decap_3
XFILLER_59_246 VPWR VGND VPWR VGND sky130_fd_sc_hd__decap_3
XFILLER_19_12 VPWR VGND VPWR VGND sky130_fd_sc_hd__decap_3
XFILLER_19_78 VPWR VGND VPWR VGND sky130_fd_sc_hd__decap_3
XFILLER_27_143 VPWR VGND VPWR VGND sky130_fd_sc_hd__decap_3
XFILLER_42_102 VPWR VGND VPWR VGND sky130_fd_sc_hd__decap_3
XFILLER_15_349 VPWR VGND VPWR VGND sky130_fd_sc_hd__decap_3
XFILLER_35_44 VPWR VGND VPWR VGND sky130_fd_sc_hd__decap_3
XFILLER_35_66 VPWR VGND VPWR VGND sky130_fd_sc_hd__decap_3
XFILLER_27_187 VPWR VGND VPWR VGND sky130_fd_sc_hd__decap_3
XFILLER_42_135 VPWR VGND VPWR VGND sky130_fd_sc_hd__decap_3
XFILLER_35_99 VPWR VGND VPWR VGND sky130_fd_sc_hd__decap_3
XFILLER_42_168 VPWR VGND VPWR VGND sky130_fd_sc_hd__decap_3
X_211_ net58 _006_ VPWR VGND VPWR VGND sky130_fd_sc_hd__inv_2
XFILLER_23_382 VPWR VGND VPWR VGND sky130_fd_sc_hd__decap_3
XFILLER_23_393 VPWR VGND VPWR VGND sky130_fd_sc_hd__decap_3
X_142_ VPWR VGND VGND VPWR _061_ _063_ _062_ _142_/a_113_47# sky130_fd_sc_hd__nand2_1
Xclkbuf_2_3__f_clk_regs VGND VPWR VGND VPWR clknet_0_clk_regs clknet_2_3__leaf_clk_regs
+ clkbuf_2_3__f_clk_regs/a_110_47# sky130_fd_sc_hd__clkbuf_16
XFILLER_51_43 VPWR VGND VPWR VGND sky130_fd_sc_hd__decap_3
XFILLER_51_98 VPWR VGND VPWR VGND sky130_fd_sc_hd__decap_3
XFILLER_25_9 VPWR VGND VPWR VGND sky130_fd_sc_hd__decap_3
XFILLER_18_121 VPWR VGND VPWR VGND sky130_fd_sc_hd__decap_3
XFILLER_18_165 VPWR VGND VPWR VGND sky130_fd_sc_hd__decap_3
XFILLER_33_113 VPWR VGND VPWR VGND sky130_fd_sc_hd__decap_3
XFILLER_33_146 VPWR VGND VPWR VGND sky130_fd_sc_hd__decap_3
XFILLER_14_360 VPWR VGND VPWR VGND sky130_fd_sc_hd__decap_3
XFILLER_14_393 VPWR VGND VPWR VGND sky130_fd_sc_hd__decap_3
XFILLER_41_190 VPWR VGND VPWR VGND sky130_fd_sc_hd__decap_3
XPHY_EDGE_ROW_4_2_Right_90 VPWR VGND VPWR VGND sky130_fd_sc_hd__decap_3
XFILLER_56_227 VPWR VGND VPWR VGND sky130_fd_sc_hd__decap_3
XFILLER_49_290 VPWR VGND VPWR VGND sky130_fd_sc_hd__decap_3
XFILLER_64_293 VPWR VGND VPWR VGND sky130_fd_sc_hd__decap_3
XFILLER_64_271 VPWR VGND VPWR VGND sky130_fd_sc_hd__decap_3
XFILLER_24_135 VPWR VGND VPWR VGND sky130_fd_sc_hd__decap_3
XFILLER_24_168 VPWR VGND VPWR VGND sky130_fd_sc_hd__decap_3
XFILLER_32_190 VPWR VGND VPWR VGND sky130_fd_sc_hd__decap_3
XFILLER_20_363 VPWR VGND VPWR VGND sky130_fd_sc_hd__decap_3
XFILLER_21_24 VPWR VGND VPWR VGND sky130_fd_sc_hd__decap_3
XFILLER_21_35 VPWR VGND VPWR VGND sky130_fd_sc_hd__decap_3
XFILLER_20_396 VPWR VGND VPWR VGND sky130_fd_sc_hd__decap_3
XFILLER_21_68 VPWR VGND VPWR VGND sky130_fd_sc_hd__decap_3
XFILLER_47_205 VPWR VGND VPWR VGND sky130_fd_sc_hd__decap_3
XFILLER_46_32 VPWR VGND VPWR VGND sky130_fd_sc_hd__decap_3
XFILLER_46_21 VPWR VGND VPWR VGND sky130_fd_sc_hd__decap_3
XFILLER_47_249 VPWR VGND VPWR VGND sky130_fd_sc_hd__decap_3
XFILLER_46_65 VPWR VGND VPWR VGND sky130_fd_sc_hd__decap_3
XFILLER_55_293 VPWR VGND VPWR VGND sky130_fd_sc_hd__decap_3
XFILLER_15_102 VPWR VGND VPWR VGND sky130_fd_sc_hd__decap_3
XFILLER_15_113 VPWR VGND VPWR VGND sky130_fd_sc_hd__decap_3
XFILLER_15_146 VPWR VGND VPWR VGND sky130_fd_sc_hd__decap_3
XFILLER_62_53 VPWR VGND VPWR VGND sky130_fd_sc_hd__decap_3
XFILLER_30_127 VPWR VGND VPWR VGND sky130_fd_sc_hd__decap_3
XFILLER_62_97 VPWR VGND VPWR VGND sky130_fd_sc_hd__decap_3
XFILLER_23_190 VPWR VGND VPWR VGND sky130_fd_sc_hd__decap_3
XFILLER_11_352 VPWR VGND VPWR VGND sky130_fd_sc_hd__decap_3
XFILLER_7_15 VPWR VGND VPWR VGND sky130_fd_sc_hd__decap_3
XFILLER_11_385 VPWR VGND VPWR VGND sky130_fd_sc_hd__decap_3
XFILLER_7_334 VPWR VGND VPWR VGND sky130_fd_sc_hd__decap_3
X_125_ net57 _000_ VPWR VGND VPWR VGND sky130_fd_sc_hd__inv_2
XFILLER_7_367 VPWR VGND VPWR VGND sky130_fd_sc_hd__decap_3
XFILLER_23_6 VPWR VGND VPWR VGND sky130_fd_sc_hd__decap_3
XFILLER_38_227 VPWR VGND VPWR VGND sky130_fd_sc_hd__decap_3
XFILLER_53_208 VPWR VGND VPWR VGND sky130_fd_sc_hd__decap_3
XFILLER_46_271 VPWR VGND VPWR VGND sky130_fd_sc_hd__decap_3
XFILLER_61_252 VPWR VGND VPWR VGND sky130_fd_sc_hd__decap_3
XFILLER_61_296 VPWR VGND VPWR VGND sky130_fd_sc_hd__decap_3
XFILLER_21_116 VPWR VGND VPWR VGND sky130_fd_sc_hd__decap_3
XFILLER_29_205 VPWR VGND VPWR VGND sky130_fd_sc_hd__decap_3
XFILLER_29_249 VPWR VGND VPWR VGND sky130_fd_sc_hd__decap_3
XFILLER_16_35 VPWR VGND VPWR VGND sky130_fd_sc_hd__decap_3
XFILLER_37_293 VPWR VGND VPWR VGND sky130_fd_sc_hd__decap_3
XFILLER_16_68 VPWR VGND VPWR VGND sky130_fd_sc_hd__decap_3
XFILLER_52_230 VPWR VGND VPWR VGND sky130_fd_sc_hd__decap_3
XFILLER_12_127 VPWR VGND VPWR VGND sky130_fd_sc_hd__decap_3
XFILLER_52_274 VPWR VGND VPWR VGND sky130_fd_sc_hd__decap_3
XFILLER_32_12 VPWR VGND VPWR VGND sky130_fd_sc_hd__decap_3
XFILLER_32_56 VPWR VGND VPWR VGND sky130_fd_sc_hd__decap_3
XFILLER_32_78 VPWR VGND VPWR VGND sky130_fd_sc_hd__decap_3
XFILLER_20_171 VPWR VGND VPWR VGND sky130_fd_sc_hd__decap_3
XFILLER_4_337 VPWR VGND VPWR VGND sky130_fd_sc_hd__decap_3
XFILLER_57_86 VPWR VGND VPWR VGND sky130_fd_sc_hd__decap_3
XFILLER_35_208 VPWR VGND VPWR VGND sky130_fd_sc_hd__decap_3
XFILLER_28_271 VPWR VGND VPWR VGND sky130_fd_sc_hd__decap_3
XFILLER_43_252 VPWR VGND VPWR VGND sky130_fd_sc_hd__decap_3
XFILLER_43_296 VPWR VGND VPWR VGND sky130_fd_sc_hd__decap_3
XFILLER_7_131 VPWR VGND VPWR VGND sky130_fd_sc_hd__decap_3
XFILLER_7_175 VPWR VGND VPWR VGND sky130_fd_sc_hd__decap_3
XFILLER_7_164 VPWR VGND VPWR VGND sky130_fd_sc_hd__decap_3
XFILLER_3_370 VPWR VGND VPWR VGND sky130_fd_sc_hd__decap_3
XFILLER_21_3 VPWR VGND VPWR VGND sky130_fd_sc_hd__decap_3
XPHY_EDGE_ROW_53_Left_159 VPWR VGND VPWR VGND sky130_fd_sc_hd__decap_3
XFILLER_34_230 VPWR VGND VPWR VGND sky130_fd_sc_hd__decap_3
XFILLER_34_274 VPWR VGND VPWR VGND sky130_fd_sc_hd__decap_3
XPHY_EDGE_ROW_62_Left_168 VPWR VGND VPWR VGND sky130_fd_sc_hd__decap_3
XFILLER_8_80 VPWR VGND VPWR VGND sky130_fd_sc_hd__decap_3
XFILLER_8_91 VPWR VGND VPWR VGND sky130_fd_sc_hd__decap_3
XFILLER_57_355 VPWR VGND VPWR VGND sky130_fd_sc_hd__decap_3
XFILLER_27_12 VPWR VGND VPWR VGND sky130_fd_sc_hd__decap_3
XFILLER_57_388 VPWR VGND VPWR VGND sky130_fd_sc_hd__decap_3
XFILLER_27_78 VPWR VGND VPWR VGND sky130_fd_sc_hd__decap_3
XFILLER_25_252 VPWR VGND VPWR VGND sky130_fd_sc_hd__decap_3
XFILLER_40_200 VPWR VGND VPWR VGND sky130_fd_sc_hd__decap_3
XFILLER_25_296 VPWR VGND VPWR VGND sky130_fd_sc_hd__decap_3
XFILLER_40_233 VPWR VGND VPWR VGND sky130_fd_sc_hd__decap_3
XFILLER_43_66 VPWR VGND VPWR VGND sky130_fd_sc_hd__decap_3
XFILLER_40_277 VPWR VGND VPWR VGND sky130_fd_sc_hd__decap_3
XFILLER_4_156 VPWR VGND VPWR VGND sky130_fd_sc_hd__decap_3
XFILLER_4_38 VPWR VGND VPWR VGND sky130_fd_sc_hd__decap_3
XPHY_EDGE_ROW_17_2_Left_38 VPWR VGND VPWR VGND sky130_fd_sc_hd__decap_3
XFILLER_0_340 VPWR VGND VPWR VGND sky130_fd_sc_hd__decap_3
XFILLER_48_333 VPWR VGND VPWR VGND sky130_fd_sc_hd__decap_3
XFILLER_48_377 VPWR VGND VPWR VGND sky130_fd_sc_hd__decap_3
XFILLER_63_314 VPWR VGND VPWR VGND sky130_fd_sc_hd__decap_3
XFILLER_63_358 VPWR VGND VPWR VGND sky130_fd_sc_hd__decap_3
XFILLER_31_211 VPWR VGND VPWR VGND sky130_fd_sc_hd__decap_3
XFILLER_31_255 VPWR VGND VPWR VGND sky130_fd_sc_hd__decap_3
XFILLER_31_299 VPWR VGND VPWR VGND sky130_fd_sc_hd__decap_3
XFILLER_58_119 VPWR VGND VPWR VGND sky130_fd_sc_hd__decap_3
XFILLER_39_311 VPWR VGND VPWR VGND sky130_fd_sc_hd__decap_3
XFILLER_39_355 VPWR VGND VPWR VGND sky130_fd_sc_hd__decap_3
XFILLER_39_399 VPWR VGND VPWR VGND sky130_fd_sc_hd__decap_3
XFILLER_54_336 VPWR VGND VPWR VGND sky130_fd_sc_hd__decap_3
XFILLER_39_388 VPWR VGND VPWR VGND sky130_fd_sc_hd__decap_3
XFILLER_22_200 VPWR VGND VPWR VGND sky130_fd_sc_hd__decap_3
XFILLER_62_380 VPWR VGND VPWR VGND sky130_fd_sc_hd__decap_3
Xfanout59 VPWR VGND net59 net61 VPWR VGND fanout59/a_27_47# sky130_fd_sc_hd__buf_4
XFILLER_22_244 VPWR VGND VPWR VGND sky130_fd_sc_hd__decap_3
XFILLER_22_277 VPWR VGND VPWR VGND sky130_fd_sc_hd__decap_3
XFILLER_1_137 VPWR VGND VPWR VGND sky130_fd_sc_hd__decap_3
XFILLER_49_119 VPWR VGND VPWR VGND sky130_fd_sc_hd__decap_3
XFILLER_38_44 VPWR VGND VPWR VGND sky130_fd_sc_hd__decap_3
XFILLER_38_88 VPWR VGND VPWR VGND sky130_fd_sc_hd__decap_3
XFILLER_57_152 VPWR VGND VPWR VGND sky130_fd_sc_hd__decap_3
XFILLER_45_314 VPWR VGND VPWR VGND sky130_fd_sc_hd__decap_3
XFILLER_57_196 VPWR VGND VPWR VGND sky130_fd_sc_hd__decap_3
XFILLER_45_358 VPWR VGND VPWR VGND sky130_fd_sc_hd__decap_3
XFILLER_54_32 VPWR VGND VPWR VGND sky130_fd_sc_hd__decap_3
XFILLER_54_21 VPWR VGND VPWR VGND sky130_fd_sc_hd__decap_3
XFILLER_54_65 VPWR VGND VPWR VGND sky130_fd_sc_hd__decap_3
XFILLER_60_339 VPWR VGND VPWR VGND sky130_fd_sc_hd__decap_3
XFILLER_55_9 VPWR VGND VPWR VGND sky130_fd_sc_hd__decap_3
XFILLER_48_141 VPWR VGND VPWR VGND sky130_fd_sc_hd__decap_3
XFILLER_36_336 VPWR VGND VPWR VGND sky130_fd_sc_hd__decap_3
XFILLER_48_174 VPWR VGND VPWR VGND sky130_fd_sc_hd__decap_3
XFILLER_63_155 VPWR VGND VPWR VGND sky130_fd_sc_hd__decap_3
XFILLER_63_122 VPWR VGND VPWR VGND sky130_fd_sc_hd__decap_3
XFILLER_51_317 VPWR VGND VPWR VGND sky130_fd_sc_hd__decap_3
XFILLER_63_199 VPWR VGND VPWR VGND sky130_fd_sc_hd__decap_3
XFILLER_44_380 VPWR VGND VPWR VGND sky130_fd_sc_hd__decap_3
XFILLER_39_152 VPWR VGND VPWR VGND sky130_fd_sc_hd__decap_3
XFILLER_27_314 VPWR VGND VPWR VGND sky130_fd_sc_hd__decap_3
XFILLER_27_358 VPWR VGND VPWR VGND sky130_fd_sc_hd__decap_3
XFILLER_54_133 VPWR VGND VPWR VGND sky130_fd_sc_hd__decap_3
XFILLER_54_144 VPWR VGND VPWR VGND sky130_fd_sc_hd__decap_3
XFILLER_39_196 VPWR VGND VPWR VGND sky130_fd_sc_hd__decap_3
XFILLER_54_177 VPWR VGND VPWR VGND sky130_fd_sc_hd__decap_3
XFILLER_42_339 VPWR VGND VPWR VGND sky130_fd_sc_hd__decap_3
XFILLER_24_24 VPWR VGND VPWR VGND sky130_fd_sc_hd__decap_3
XFILLER_24_35 VPWR VGND VPWR VGND sky130_fd_sc_hd__decap_3
XFILLER_50_383 VPWR VGND VPWR VGND sky130_fd_sc_hd__decap_3
XFILLER_24_68 VPWR VGND VPWR VGND sky130_fd_sc_hd__decap_3
Xclkbuf_2_2__f_clk_regs VGND VPWR VGND VPWR clknet_0_clk_regs clknet_2_2__leaf_clk_regs
+ clkbuf_2_2__f_clk_regs/a_110_47# sky130_fd_sc_hd__clkbuf_16
XFILLER_40_12 VPWR VGND VPWR VGND sky130_fd_sc_hd__decap_3
XFILLER_40_56 VPWR VGND VPWR VGND sky130_fd_sc_hd__decap_3
XFILLER_2_402 VPWR VGND VPWR VGND sky130_fd_sc_hd__decap_3
XFILLER_49_76 VPWR VGND VPWR VGND sky130_fd_sc_hd__decap_3
XFILLER_1_39 VPWR VGND VPWR VGND sky130_fd_sc_hd__decap_3
XFILLER_45_100 VPWR VGND VPWR VGND sky130_fd_sc_hd__decap_3
XFILLER_45_122 VPWR VGND VPWR VGND sky130_fd_sc_hd__decap_3
XFILLER_60_103 VPWR VGND VPWR VGND sky130_fd_sc_hd__decap_3
XFILLER_18_369 VPWR VGND VPWR VGND sky130_fd_sc_hd__decap_3
XFILLER_33_317 VPWR VGND VPWR VGND sky130_fd_sc_hd__decap_3
XFILLER_45_155 VPWR VGND VPWR VGND sky130_fd_sc_hd__decap_3
XFILLER_60_136 VPWR VGND VPWR VGND sky130_fd_sc_hd__decap_3
XFILLER_26_380 VPWR VGND VPWR VGND sky130_fd_sc_hd__decap_3
XFILLER_45_199 VPWR VGND VPWR VGND sky130_fd_sc_hd__decap_3
XFILLER_60_147 VPWR VGND VPWR VGND sky130_fd_sc_hd__decap_3
XFILLER_41_361 VPWR VGND VPWR VGND sky130_fd_sc_hd__decap_3
X_287_ VGND VPWR VPWR VGND clknet_2_3__leaf_clk_regs net7 _032_ genblk1\[15\].fa_inst.a
+ _287_/a_1462_47# _287_/a_543_47# _287_/a_651_413# _287_/a_193_47# _287_/a_805_47#
+ _287_/a_448_47# _287_/a_639_47# _287_/a_1283_21# _287_/a_761_289# _287_/a_1108_47#
+ _287_/a_1217_47# _287_/a_1270_413# _287_/a_27_47# sky130_fd_sc_hd__dfrtp_1
XFILLER_53_6 VPWR VGND VPWR VGND sky130_fd_sc_hd__decap_3
Xinput5 VGND VPWR net5 a[13] VPWR VGND input5/a_27_47# sky130_fd_sc_hd__buf_1
XFILLER_36_133 VPWR VGND VPWR VGND sky130_fd_sc_hd__decap_3
XFILLER_36_144 VPWR VGND VPWR VGND sky130_fd_sc_hd__decap_3
XFILLER_36_177 VPWR VGND VPWR VGND sky130_fd_sc_hd__decap_3
XFILLER_24_339 VPWR VGND VPWR VGND sky130_fd_sc_hd__decap_3
XFILLER_17_391 VPWR VGND VPWR VGND sky130_fd_sc_hd__decap_3
XFILLER_51_125 VPWR VGND VPWR VGND sky130_fd_sc_hd__decap_3
XFILLER_51_158 VPWR VGND VPWR VGND sky130_fd_sc_hd__decap_3
XFILLER_51_169 VPWR VGND VPWR VGND sky130_fd_sc_hd__decap_3
XFILLER_32_383 VPWR VGND VPWR VGND sky130_fd_sc_hd__decap_3
XFILLER_10_15 VPWR VGND VPWR VGND sky130_fd_sc_hd__decap_3
XFILLER_59_225 VPWR VGND VPWR VGND sky130_fd_sc_hd__decap_3
XFILLER_59_214 VPWR VGND VPWR VGND sky130_fd_sc_hd__decap_3
XFILLER_59_258 VPWR VGND VPWR VGND sky130_fd_sc_hd__decap_3
XFILLER_19_46 VPWR VGND VPWR VGND sky130_fd_sc_hd__decap_3
XFILLER_19_57 VPWR VGND VPWR VGND sky130_fd_sc_hd__decap_3
XFILLER_27_122 VPWR VGND VPWR VGND sky130_fd_sc_hd__decap_3
XFILLER_35_12 VPWR VGND VPWR VGND sky130_fd_sc_hd__decap_3
XFILLER_27_155 VPWR VGND VPWR VGND sky130_fd_sc_hd__decap_3
XFILLER_27_199 VPWR VGND VPWR VGND sky130_fd_sc_hd__decap_3
XFILLER_42_114 VPWR VGND VPWR VGND sky130_fd_sc_hd__decap_3
XFILLER_35_78 VPWR VGND VPWR VGND sky130_fd_sc_hd__decap_3
XFILLER_30_309 VPWR VGND VPWR VGND sky130_fd_sc_hd__decap_3
XFILLER_42_147 VPWR VGND VPWR VGND sky130_fd_sc_hd__decap_3
X_210_ net58 _005_ VPWR VGND VPWR VGND sky130_fd_sc_hd__inv_2
XFILLER_23_361 VPWR VGND VPWR VGND sky130_fd_sc_hd__decap_3
X_141_ VPWR VGND VGND VPWR genblk1\[3\].fa_inst.b _062_ genblk1\[3\].fa_inst.a _141_/a_113_47#
+ sky130_fd_sc_hd__nand2_1
XFILLER_50_180 VPWR VGND VPWR VGND sky130_fd_sc_hd__decap_3
XFILLER_51_77 VPWR VGND VPWR VGND sky130_fd_sc_hd__decap_3
XFILLER_51_66 VPWR VGND VPWR VGND sky130_fd_sc_hd__decap_3
XPHY_EDGE_ROW_23_Right_44 VPWR VGND VPWR VGND sky130_fd_sc_hd__decap_3
XFILLER_18_9 VPWR VGND VPWR VGND sky130_fd_sc_hd__decap_3
XFILLER_18_100 VPWR VGND VPWR VGND sky130_fd_sc_hd__decap_3
XFILLER_58_280 VPWR VGND VPWR VGND sky130_fd_sc_hd__decap_3
XFILLER_18_133 VPWR VGND VPWR VGND sky130_fd_sc_hd__decap_3
XFILLER_18_144 VPWR VGND VPWR VGND sky130_fd_sc_hd__decap_3
XFILLER_18_177 VPWR VGND VPWR VGND sky130_fd_sc_hd__decap_3
XFILLER_33_125 VPWR VGND VPWR VGND sky130_fd_sc_hd__decap_3
XFILLER_33_158 VPWR VGND VPWR VGND sky130_fd_sc_hd__decap_3
XFILLER_33_169 VPWR VGND VPWR VGND sky130_fd_sc_hd__decap_3
XFILLER_21_309 VPWR VGND VPWR VGND sky130_fd_sc_hd__decap_3
XFILLER_14_372 VPWR VGND VPWR VGND sky130_fd_sc_hd__decap_3
XPHY_EDGE_ROW_32_Right_53 VPWR VGND VPWR VGND sky130_fd_sc_hd__decap_3
XFILLER_51_3 VPWR VGND VPWR VGND sky130_fd_sc_hd__decap_3
XPHY_EDGE_ROW_41_Right_62 VPWR VGND VPWR VGND sky130_fd_sc_hd__decap_3
XFILLER_2_71 VPWR VGND VPWR VGND sky130_fd_sc_hd__decap_3
XFILLER_56_206 VPWR VGND VPWR VGND sky130_fd_sc_hd__decap_3
XFILLER_56_239 VPWR VGND VPWR VGND sky130_fd_sc_hd__decap_3
XFILLER_52_401 VPWR VGND VPWR VGND sky130_fd_sc_hd__decap_3
XFILLER_24_114 VPWR VGND VPWR VGND sky130_fd_sc_hd__decap_3
XPHY_EDGE_ROW_50_Right_71 VPWR VGND VPWR VGND sky130_fd_sc_hd__decap_3
XFILLER_24_147 VPWR VGND VPWR VGND sky130_fd_sc_hd__decap_3
XFILLER_20_331 VPWR VGND VPWR VGND sky130_fd_sc_hd__decap_3
XFILLER_20_375 VPWR VGND VPWR VGND sky130_fd_sc_hd__decap_3
XFILLER_47_228 VPWR VGND VPWR VGND sky130_fd_sc_hd__decap_3
XFILLER_47_217 VPWR VGND VPWR VGND sky130_fd_sc_hd__decap_3
XFILLER_62_209 VPWR VGND VPWR VGND sky130_fd_sc_hd__decap_3
XFILLER_46_44 VPWR VGND VPWR VGND sky130_fd_sc_hd__decap_3
XFILLER_46_77 VPWR VGND VPWR VGND sky130_fd_sc_hd__decap_3
XFILLER_55_261 VPWR VGND VPWR VGND sky130_fd_sc_hd__decap_3
XFILLER_15_125 VPWR VGND VPWR VGND sky130_fd_sc_hd__decap_3
XFILLER_46_88 VPWR VGND VPWR VGND sky130_fd_sc_hd__decap_3
XFILLER_62_21 VPWR VGND VPWR VGND sky130_fd_sc_hd__decap_3
XFILLER_15_169 VPWR VGND VPWR VGND sky130_fd_sc_hd__decap_3
XFILLER_15_158 VPWR VGND VPWR VGND sky130_fd_sc_hd__decap_3
XFILLER_62_32 VPWR VGND VPWR VGND sky130_fd_sc_hd__decap_3
XFILLER_30_106 VPWR VGND VPWR VGND sky130_fd_sc_hd__decap_3
XFILLER_62_65 VPWR VGND VPWR VGND sky130_fd_sc_hd__decap_3
XFILLER_11_331 VPWR VGND VPWR VGND sky130_fd_sc_hd__decap_3
XFILLER_11_364 VPWR VGND VPWR VGND sky130_fd_sc_hd__decap_3
XFILLER_7_27 VPWR VGND VPWR VGND sky130_fd_sc_hd__decap_3
XFILLER_11_397 VPWR VGND VPWR VGND sky130_fd_sc_hd__decap_3
XFILLER_7_346 VPWR VGND VPWR VGND sky130_fd_sc_hd__decap_3
XFILLER_11_80 VPWR VGND VPWR VGND sky130_fd_sc_hd__decap_3
XFILLER_38_206 VPWR VGND VPWR VGND sky130_fd_sc_hd__decap_3
XFILLER_16_6 VPWR VGND VPWR VGND sky130_fd_sc_hd__decap_3
XFILLER_38_239 VPWR VGND VPWR VGND sky130_fd_sc_hd__decap_3
XFILLER_34_401 VPWR VGND VPWR VGND sky130_fd_sc_hd__decap_3
XFILLER_61_220 VPWR VGND VPWR VGND sky130_fd_sc_hd__decap_3
XFILLER_46_283 VPWR VGND VPWR VGND sky130_fd_sc_hd__decap_3
XFILLER_61_231 VPWR VGND VPWR VGND sky130_fd_sc_hd__decap_3
XFILLER_61_264 VPWR VGND VPWR VGND sky130_fd_sc_hd__decap_3
XFILLER_21_128 VPWR VGND VPWR VGND sky130_fd_sc_hd__decap_3
Xinput30 VGND VPWR net30 b[7] VPWR VGND input30/a_75_212# sky130_fd_sc_hd__clkbuf_1
XFILLER_6_390 VPWR VGND VPWR VGND sky130_fd_sc_hd__decap_3
XFILLER_29_217 VPWR VGND VPWR VGND sky130_fd_sc_hd__decap_3
XFILLER_29_228 VPWR VGND VPWR VGND sky130_fd_sc_hd__decap_3
XFILLER_44_209 VPWR VGND VPWR VGND sky130_fd_sc_hd__decap_3
XFILLER_37_261 VPWR VGND VPWR VGND sky130_fd_sc_hd__decap_3
XFILLER_16_47 VPWR VGND VPWR VGND sky130_fd_sc_hd__decap_3
XFILLER_52_253 VPWR VGND VPWR VGND sky130_fd_sc_hd__decap_3
XFILLER_52_242 VPWR VGND VPWR VGND sky130_fd_sc_hd__decap_3
XFILLER_40_404 VPWR VGND VPWR VGND sky130_fd_sc_hd__decap_3
XFILLER_12_106 VPWR VGND VPWR VGND sky130_fd_sc_hd__decap_3
XFILLER_52_286 VPWR VGND VPWR VGND sky130_fd_sc_hd__decap_3
XFILLER_32_24 VPWR VGND VPWR VGND sky130_fd_sc_hd__decap_3
XFILLER_32_35 VPWR VGND VPWR VGND sky130_fd_sc_hd__decap_3
XFILLER_20_150 VPWR VGND VPWR VGND sky130_fd_sc_hd__decap_3
XFILLER_4_349 VPWR VGND VPWR VGND sky130_fd_sc_hd__decap_3
XFILLER_57_43 VPWR VGND VPWR VGND sky130_fd_sc_hd__decap_3
XFILLER_57_98 VPWR VGND VPWR VGND sky130_fd_sc_hd__decap_3
XFILLER_28_283 VPWR VGND VPWR VGND sky130_fd_sc_hd__decap_3
XFILLER_43_220 VPWR VGND VPWR VGND sky130_fd_sc_hd__decap_3
XFILLER_43_231 VPWR VGND VPWR VGND sky130_fd_sc_hd__decap_3
XPHY_EDGE_ROW_5_1_Right_4 VPWR VGND VPWR VGND sky130_fd_sc_hd__decap_3
XFILLER_43_264 VPWR VGND VPWR VGND sky130_fd_sc_hd__decap_3
XFILLER_11_161 VPWR VGND VPWR VGND sky130_fd_sc_hd__decap_3
XFILLER_11_172 VPWR VGND VPWR VGND sky130_fd_sc_hd__decap_3
XFILLER_7_143 VPWR VGND VPWR VGND sky130_fd_sc_hd__decap_3
XFILLER_3_382 VPWR VGND VPWR VGND sky130_fd_sc_hd__decap_3
XFILLER_26_209 VPWR VGND VPWR VGND sky130_fd_sc_hd__decap_3
XFILLER_34_242 VPWR VGND VPWR VGND sky130_fd_sc_hd__decap_3
XFILLER_34_253 VPWR VGND VPWR VGND sky130_fd_sc_hd__decap_3
XFILLER_22_404 VPWR VGND VPWR VGND sky130_fd_sc_hd__decap_3
XFILLER_34_286 VPWR VGND VPWR VGND sky130_fd_sc_hd__decap_3
XFILLER_57_323 VPWR VGND VPWR VGND sky130_fd_sc_hd__decap_3
XFILLER_57_367 VPWR VGND VPWR VGND sky130_fd_sc_hd__decap_3
XFILLER_27_57 VPWR VGND VPWR VGND sky130_fd_sc_hd__decap_3
XFILLER_25_220 VPWR VGND VPWR VGND sky130_fd_sc_hd__decap_3
XFILLER_25_231 VPWR VGND VPWR VGND sky130_fd_sc_hd__decap_3
XFILLER_25_264 VPWR VGND VPWR VGND sky130_fd_sc_hd__decap_3
XFILLER_43_12 VPWR VGND VPWR VGND sky130_fd_sc_hd__decap_3
XFILLER_43_45 VPWR VGND VPWR VGND sky130_fd_sc_hd__decap_3
XFILLER_40_212 VPWR VGND VPWR VGND sky130_fd_sc_hd__decap_3
XPHY_EDGE_ROW_11_1_Left_117 VPWR VGND VPWR VGND sky130_fd_sc_hd__decap_3
XFILLER_43_78 VPWR VGND VPWR VGND sky130_fd_sc_hd__decap_3
XFILLER_40_256 VPWR VGND VPWR VGND sky130_fd_sc_hd__decap_3
XFILLER_40_245 VPWR VGND VPWR VGND sky130_fd_sc_hd__decap_3
XFILLER_40_289 VPWR VGND VPWR VGND sky130_fd_sc_hd__decap_3
XFILLER_4_124 VPWR VGND VPWR VGND sky130_fd_sc_hd__decap_3
XFILLER_4_168 VPWR VGND VPWR VGND sky130_fd_sc_hd__decap_3
XFILLER_48_301 VPWR VGND VPWR VGND sky130_fd_sc_hd__decap_3
XFILLER_0_363 VPWR VGND VPWR VGND sky130_fd_sc_hd__decap_3
XFILLER_48_312 VPWR VGND VPWR VGND sky130_fd_sc_hd__decap_3
XFILLER_0_385 VPWR VGND VPWR VGND sky130_fd_sc_hd__decap_3
XFILLER_48_345 VPWR VGND VPWR VGND sky130_fd_sc_hd__decap_3
XFILLER_63_337 VPWR VGND VPWR VGND sky130_fd_sc_hd__decap_3
XFILLER_63_326 VPWR VGND VPWR VGND sky130_fd_sc_hd__decap_3
XFILLER_48_389 VPWR VGND VPWR VGND sky130_fd_sc_hd__decap_3
XFILLER_31_234 VPWR VGND VPWR VGND sky130_fd_sc_hd__decap_3
XFILLER_31_267 VPWR VGND VPWR VGND sky130_fd_sc_hd__decap_3
XFILLER_39_323 VPWR VGND VPWR VGND sky130_fd_sc_hd__decap_3
XFILLER_39_367 VPWR VGND VPWR VGND sky130_fd_sc_hd__decap_3
XFILLER_54_315 VPWR VGND VPWR VGND sky130_fd_sc_hd__decap_3
XFILLER_54_304 VPWR VGND VPWR VGND sky130_fd_sc_hd__decap_3
XFILLER_54_348 VPWR VGND VPWR VGND sky130_fd_sc_hd__decap_3
XFILLER_62_392 VPWR VGND VPWR VGND sky130_fd_sc_hd__decap_3
XFILLER_22_212 VPWR VGND VPWR VGND sky130_fd_sc_hd__decap_3
Xclkbuf_2_1__f_clk_regs VGND VPWR VGND VPWR clknet_0_clk_regs clknet_2_1__leaf_clk_regs
+ clkbuf_2_1__f_clk_regs/a_110_47# sky130_fd_sc_hd__clkbuf_16
XFILLER_22_256 VPWR VGND VPWR VGND sky130_fd_sc_hd__decap_3
XFILLER_13_37 VPWR VGND VPWR VGND sky130_fd_sc_hd__decap_3
XFILLER_22_289 VPWR VGND VPWR VGND sky130_fd_sc_hd__decap_3
XFILLER_1_116 VPWR VGND VPWR VGND sky130_fd_sc_hd__decap_3
XFILLER_1_105 VPWR VGND VPWR VGND sky130_fd_sc_hd__decap_3
XFILLER_1_149 VPWR VGND VPWR VGND sky130_fd_sc_hd__decap_3
XFILLER_38_12 VPWR VGND VPWR VGND sky130_fd_sc_hd__decap_3
XFILLER_49_109 VPWR VGND VPWR VGND sky130_fd_sc_hd__decap_3
XFILLER_38_56 VPWR VGND VPWR VGND sky130_fd_sc_hd__decap_3
XFILLER_57_131 VPWR VGND VPWR VGND sky130_fd_sc_hd__decap_3
XFILLER_45_326 VPWR VGND VPWR VGND sky130_fd_sc_hd__decap_3
XFILLER_57_175 VPWR VGND VPWR VGND sky130_fd_sc_hd__decap_3
XFILLER_57_164 VPWR VGND VPWR VGND sky130_fd_sc_hd__decap_3
XFILLER_45_337 VPWR VGND VPWR VGND sky130_fd_sc_hd__decap_3
XFILLER_60_318 VPWR VGND VPWR VGND sky130_fd_sc_hd__decap_3
XFILLER_54_44 VPWR VGND VPWR VGND sky130_fd_sc_hd__decap_3
XFILLER_53_370 VPWR VGND VPWR VGND sky130_fd_sc_hd__decap_3
XFILLER_54_77 VPWR VGND VPWR VGND sky130_fd_sc_hd__decap_3
XFILLER_54_88 VPWR VGND VPWR VGND sky130_fd_sc_hd__decap_3
XFILLER_5_400 VPWR VGND VPWR VGND sky130_fd_sc_hd__decap_3
XFILLER_48_9 VPWR VGND VPWR VGND sky130_fd_sc_hd__decap_3
XFILLER_48_120 VPWR VGND VPWR VGND sky130_fd_sc_hd__decap_3
XFILLER_48_153 VPWR VGND VPWR VGND sky130_fd_sc_hd__decap_3
XFILLER_36_304 VPWR VGND VPWR VGND sky130_fd_sc_hd__decap_3
XFILLER_36_315 VPWR VGND VPWR VGND sky130_fd_sc_hd__decap_3
XFILLER_48_186 VPWR VGND VPWR VGND sky130_fd_sc_hd__decap_3
XFILLER_63_134 VPWR VGND VPWR VGND sky130_fd_sc_hd__decap_3
XFILLER_36_348 VPWR VGND VPWR VGND sky130_fd_sc_hd__decap_3
XFILLER_48_197 VPWR VGND VPWR VGND sky130_fd_sc_hd__decap_3
XFILLER_63_178 VPWR VGND VPWR VGND sky130_fd_sc_hd__decap_3
XFILLER_51_329 VPWR VGND VPWR VGND sky130_fd_sc_hd__decap_3
XFILLER_44_392 VPWR VGND VPWR VGND sky130_fd_sc_hd__decap_3
XFILLER_5_60 VPWR VGND VPWR VGND sky130_fd_sc_hd__decap_3
XFILLER_5_82 VPWR VGND VPWR VGND sky130_fd_sc_hd__decap_3
XFILLER_39_131 VPWR VGND VPWR VGND sky130_fd_sc_hd__decap_3
XFILLER_27_326 VPWR VGND VPWR VGND sky130_fd_sc_hd__decap_3
XFILLER_39_175 VPWR VGND VPWR VGND sky130_fd_sc_hd__decap_3
XFILLER_39_164 VPWR VGND VPWR VGND sky130_fd_sc_hd__decap_3
XFILLER_27_337 VPWR VGND VPWR VGND sky130_fd_sc_hd__decap_3
XFILLER_42_318 VPWR VGND VPWR VGND sky130_fd_sc_hd__decap_3
XFILLER_54_156 VPWR VGND VPWR VGND sky130_fd_sc_hd__decap_3
XFILLER_35_370 VPWR VGND VPWR VGND sky130_fd_sc_hd__decap_3
XFILLER_54_189 VPWR VGND VPWR VGND sky130_fd_sc_hd__decap_3
XFILLER_50_351 VPWR VGND VPWR VGND sky130_fd_sc_hd__decap_3
XFILLER_24_47 VPWR VGND VPWR VGND sky130_fd_sc_hd__decap_3
XFILLER_50_395 VPWR VGND VPWR VGND sky130_fd_sc_hd__decap_3
XFILLER_40_35 VPWR VGND VPWR VGND sky130_fd_sc_hd__decap_3
XFILLER_40_24 VPWR VGND VPWR VGND sky130_fd_sc_hd__decap_3
XFILLER_40_79 VPWR VGND VPWR VGND sky130_fd_sc_hd__decap_3
XFILLER_49_44 VPWR VGND VPWR VGND sky130_fd_sc_hd__decap_3
XFILLER_49_88 VPWR VGND VPWR VGND sky130_fd_sc_hd__decap_3
XFILLER_1_18 VPWR VGND VPWR VGND sky130_fd_sc_hd__decap_3
XFILLER_18_337 VPWR VGND VPWR VGND sky130_fd_sc_hd__decap_3
XFILLER_45_134 VPWR VGND VPWR VGND sky130_fd_sc_hd__decap_3
XFILLER_45_178 VPWR VGND VPWR VGND sky130_fd_sc_hd__decap_3
XFILLER_60_115 VPWR VGND VPWR VGND sky130_fd_sc_hd__decap_3
XFILLER_33_329 VPWR VGND VPWR VGND sky130_fd_sc_hd__decap_3
XFILLER_26_392 VPWR VGND VPWR VGND sky130_fd_sc_hd__decap_3
XFILLER_60_159 VPWR VGND VPWR VGND sky130_fd_sc_hd__decap_3
XFILLER_41_340 VPWR VGND VPWR VGND sky130_fd_sc_hd__decap_3
XFILLER_41_373 VPWR VGND VPWR VGND sky130_fd_sc_hd__decap_3
XFILLER_14_80 VPWR VGND VPWR VGND sky130_fd_sc_hd__decap_3
X_286_ VGND VPWR VPWR VGND clknet_2_3__leaf_clk_regs net6 _031_ genblk1\[14\].fa_inst.a
+ _286_/a_1462_47# _286_/a_543_47# _286_/a_651_413# _286_/a_193_47# _286_/a_805_47#
+ _286_/a_448_47# _286_/a_639_47# _286_/a_1283_21# _286_/a_761_289# _286_/a_1108_47#
+ _286_/a_1217_47# _286_/a_1270_413# _286_/a_27_47# sky130_fd_sc_hd__dfrtp_1
XFILLER_14_91 VPWR VGND VPWR VGND sky130_fd_sc_hd__decap_3
XFILLER_46_6 VPWR VGND VPWR VGND sky130_fd_sc_hd__decap_3
Xinput6 VGND VPWR net6 a[14] VPWR VGND input6/a_27_47# sky130_fd_sc_hd__buf_1
XFILLER_36_156 VPWR VGND VPWR VGND sky130_fd_sc_hd__decap_3
XFILLER_24_318 VPWR VGND VPWR VGND sky130_fd_sc_hd__decap_3
XFILLER_36_189 VPWR VGND VPWR VGND sky130_fd_sc_hd__decap_3
XFILLER_17_370 VPWR VGND VPWR VGND sky130_fd_sc_hd__decap_3
XFILLER_51_104 VPWR VGND VPWR VGND sky130_fd_sc_hd__decap_3
XFILLER_51_137 VPWR VGND VPWR VGND sky130_fd_sc_hd__decap_3
XFILLER_32_351 VPWR VGND VPWR VGND sky130_fd_sc_hd__decap_3
XFILLER_32_395 VPWR VGND VPWR VGND sky130_fd_sc_hd__decap_3
XFILLER_10_38 VPWR VGND VPWR VGND sky130_fd_sc_hd__decap_3
XFILLER_59_237 VPWR VGND VPWR VGND sky130_fd_sc_hd__decap_3
XFILLER_19_69 VPWR VGND VPWR VGND sky130_fd_sc_hd__decap_3
XPHY_EDGE_ROW_20_1_Left_126 VPWR VGND VPWR VGND sky130_fd_sc_hd__decap_3
XFILLER_27_134 VPWR VGND VPWR VGND sky130_fd_sc_hd__decap_3
XFILLER_35_57 VPWR VGND VPWR VGND sky130_fd_sc_hd__decap_3
XFILLER_27_178 VPWR VGND VPWR VGND sky130_fd_sc_hd__decap_3
XFILLER_42_126 VPWR VGND VPWR VGND sky130_fd_sc_hd__decap_3
XFILLER_23_340 VPWR VGND VPWR VGND sky130_fd_sc_hd__decap_3
XFILLER_42_159 VPWR VGND VPWR VGND sky130_fd_sc_hd__decap_3
XFILLER_23_373 VPWR VGND VPWR VGND sky130_fd_sc_hd__decap_3
XFILLER_51_12 VPWR VGND VPWR VGND sky130_fd_sc_hd__decap_3
X_140_ VPWR VGND VGND VPWR _061_ genblk1\[3\].fa_inst.b genblk1\[3\].fa_inst.a _140_/a_150_297#
+ _140_/a_68_297# sky130_fd_sc_hd__or2_1
XFILLER_50_192 VPWR VGND VPWR VGND sky130_fd_sc_hd__decap_3
XFILLER_51_89 VPWR VGND VPWR VGND sky130_fd_sc_hd__decap_3
XFILLER_58_292 VPWR VGND VPWR VGND sky130_fd_sc_hd__decap_3
XFILLER_18_112 VPWR VGND VPWR VGND sky130_fd_sc_hd__decap_3
XPHY_EDGE_ROW_14_1_Right_13 VPWR VGND VPWR VGND sky130_fd_sc_hd__decap_3
XFILLER_18_156 VPWR VGND VPWR VGND sky130_fd_sc_hd__decap_3
XFILLER_33_104 VPWR VGND VPWR VGND sky130_fd_sc_hd__decap_3
XFILLER_14_340 VPWR VGND VPWR VGND sky130_fd_sc_hd__decap_3
XFILLER_33_137 VPWR VGND VPWR VGND sky130_fd_sc_hd__decap_3
XFILLER_14_384 VPWR VGND VPWR VGND sky130_fd_sc_hd__decap_3
XFILLER_41_181 VPWR VGND VPWR VGND sky130_fd_sc_hd__decap_3
X_269_ VGND VPWR VPWR VGND clknet_2_3__leaf_clk_regs genblk1\[14\].fa_inst.s _014_
+ net44 _269_/a_1462_47# _269_/a_543_47# _269_/a_651_413# _269_/a_193_47# _269_/a_805_47#
+ _269_/a_448_47# _269_/a_639_47# _269_/a_1283_21# _269_/a_761_289# _269_/a_1108_47#
+ _269_/a_1217_47# _269_/a_1270_413# _269_/a_27_47# sky130_fd_sc_hd__dfrtp_1
XFILLER_2_50 VPWR VGND VPWR VGND sky130_fd_sc_hd__decap_3
XFILLER_56_218 VPWR VGND VPWR VGND sky130_fd_sc_hd__decap_3
XFILLER_2_94 VPWR VGND VPWR VGND sky130_fd_sc_hd__decap_3
XFILLER_49_270 VPWR VGND VPWR VGND sky130_fd_sc_hd__decap_3
XFILLER_49_281 VPWR VGND VPWR VGND sky130_fd_sc_hd__decap_3
XFILLER_64_240 VPWR VGND VPWR VGND sky130_fd_sc_hd__decap_3
XFILLER_64_284 VPWR VGND VPWR VGND sky130_fd_sc_hd__decap_3
XFILLER_64_262 VPWR VGND VPWR VGND sky130_fd_sc_hd__decap_3
XFILLER_24_126 VPWR VGND VPWR VGND sky130_fd_sc_hd__decap_3
XFILLER_24_159 VPWR VGND VPWR VGND sky130_fd_sc_hd__decap_3
XFILLER_32_181 VPWR VGND VPWR VGND sky130_fd_sc_hd__decap_3
XFILLER_20_343 VPWR VGND VPWR VGND sky130_fd_sc_hd__decap_3
XFILLER_20_354 VPWR VGND VPWR VGND sky130_fd_sc_hd__decap_3
XFILLER_21_15 VPWR VGND VPWR VGND sky130_fd_sc_hd__decap_3
XFILLER_20_387 VPWR VGND VPWR VGND sky130_fd_sc_hd__decap_3
XFILLER_46_12 VPWR VGND VPWR VGND sky130_fd_sc_hd__decap_3
XFILLER_46_56 VPWR VGND VPWR VGND sky130_fd_sc_hd__decap_3
XFILLER_55_240 VPWR VGND VPWR VGND sky130_fd_sc_hd__decap_3
XFILLER_43_402 VPWR VGND VPWR VGND sky130_fd_sc_hd__decap_3
XFILLER_55_284 VPWR VGND VPWR VGND sky130_fd_sc_hd__decap_3
XFILLER_55_273 VPWR VGND VPWR VGND sky130_fd_sc_hd__decap_3
XFILLER_15_137 VPWR VGND VPWR VGND sky130_fd_sc_hd__decap_3
XFILLER_62_44 VPWR VGND VPWR VGND sky130_fd_sc_hd__decap_3
XFILLER_30_118 VPWR VGND VPWR VGND sky130_fd_sc_hd__decap_3
XFILLER_62_88 VPWR VGND VPWR VGND sky130_fd_sc_hd__decap_3
XFILLER_62_77 VPWR VGND VPWR VGND sky130_fd_sc_hd__decap_3
XFILLER_23_181 VPWR VGND VPWR VGND sky130_fd_sc_hd__decap_3
XFILLER_11_343 VPWR VGND VPWR VGND sky130_fd_sc_hd__decap_3
XFILLER_11_376 VPWR VGND VPWR VGND sky130_fd_sc_hd__decap_3
XFILLER_7_39 VPWR VGND VPWR VGND sky130_fd_sc_hd__decap_3
XFILLER_7_358 VPWR VGND VPWR VGND sky130_fd_sc_hd__decap_3
XPHY_EDGE_ROW_5_1_Left_111 VPWR VGND VPWR VGND sky130_fd_sc_hd__decap_3
XFILLER_11_92 VPWR VGND VPWR VGND sky130_fd_sc_hd__decap_3
XFILLER_30_9 VPWR VGND VPWR VGND sky130_fd_sc_hd__decap_3
XFILLER_38_218 VPWR VGND VPWR VGND sky130_fd_sc_hd__decap_3
XFILLER_46_262 VPWR VGND VPWR VGND sky130_fd_sc_hd__decap_3
XFILLER_61_243 VPWR VGND VPWR VGND sky130_fd_sc_hd__decap_3
XFILLER_46_295 VPWR VGND VPWR VGND sky130_fd_sc_hd__decap_3
XFILLER_61_287 VPWR VGND VPWR VGND sky130_fd_sc_hd__decap_3
XFILLER_61_276 VPWR VGND VPWR VGND sky130_fd_sc_hd__decap_3
Xinput31 VGND VPWR net31 b[8] VPWR VGND input31/a_75_212# sky130_fd_sc_hd__clkbuf_1
Xinput20 VGND VPWR net20 b[12] VPWR VGND input20/a_75_212# sky130_fd_sc_hd__clkbuf_1
XFILLER_37_240 VPWR VGND VPWR VGND sky130_fd_sc_hd__decap_3
XFILLER_16_15 VPWR VGND VPWR VGND sky130_fd_sc_hd__decap_3
XFILLER_37_273 VPWR VGND VPWR VGND sky130_fd_sc_hd__decap_3
XFILLER_37_284 VPWR VGND VPWR VGND sky130_fd_sc_hd__decap_3
XFILLER_16_59 VPWR VGND VPWR VGND sky130_fd_sc_hd__decap_3
XFILLER_52_221 VPWR VGND VPWR VGND sky130_fd_sc_hd__decap_3
XFILLER_12_118 VPWR VGND VPWR VGND sky130_fd_sc_hd__decap_3
XFILLER_52_265 VPWR VGND VPWR VGND sky130_fd_sc_hd__decap_3
XFILLER_52_298 VPWR VGND VPWR VGND sky130_fd_sc_hd__decap_3
XFILLER_32_47 VPWR VGND VPWR VGND sky130_fd_sc_hd__decap_3
XFILLER_20_162 VPWR VGND VPWR VGND sky130_fd_sc_hd__decap_3
XFILLER_4_328 VPWR VGND VPWR VGND sky130_fd_sc_hd__decap_3
XFILLER_16_402 VPWR VGND VPWR VGND sky130_fd_sc_hd__decap_3
XFILLER_28_262 VPWR VGND VPWR VGND sky130_fd_sc_hd__decap_3
XFILLER_28_295 VPWR VGND VPWR VGND sky130_fd_sc_hd__decap_3
XFILLER_43_243 VPWR VGND VPWR VGND sky130_fd_sc_hd__decap_3
XFILLER_43_276 VPWR VGND VPWR VGND sky130_fd_sc_hd__decap_3
XFILLER_43_287 VPWR VGND VPWR VGND sky130_fd_sc_hd__decap_3
XFILLER_11_140 VPWR VGND VPWR VGND sky130_fd_sc_hd__decap_3
XFILLER_7_122 VPWR VGND VPWR VGND sky130_fd_sc_hd__decap_3
XFILLER_7_100 VPWR VGND VPWR VGND sky130_fd_sc_hd__decap_3
XFILLER_7_155 VPWR VGND VPWR VGND sky130_fd_sc_hd__decap_3
XFILLER_22_91 VPWR VGND VPWR VGND sky130_fd_sc_hd__decap_3
XFILLER_3_361 VPWR VGND VPWR VGND sky130_fd_sc_hd__decap_3
XFILLER_3_394 VPWR VGND VPWR VGND sky130_fd_sc_hd__decap_3
XFILLER_34_221 VPWR VGND VPWR VGND sky130_fd_sc_hd__decap_3
Xclkbuf_2_0__f_clk_regs VGND VPWR VGND VPWR clknet_0_clk_regs clknet_2_0__leaf_clk_regs
+ clkbuf_2_0__f_clk_regs/a_110_47# sky130_fd_sc_hd__clkbuf_16
XFILLER_34_265 VPWR VGND VPWR VGND sky130_fd_sc_hd__decap_3
XFILLER_34_298 VPWR VGND VPWR VGND sky130_fd_sc_hd__decap_3
XFILLER_8_71 VPWR VGND VPWR VGND sky130_fd_sc_hd__decap_3
XFILLER_57_346 VPWR VGND VPWR VGND sky130_fd_sc_hd__decap_3
XFILLER_57_379 VPWR VGND VPWR VGND sky130_fd_sc_hd__decap_3
XFILLER_27_47 VPWR VGND VPWR VGND sky130_fd_sc_hd__decap_3
XFILLER_27_69 VPWR VGND VPWR VGND sky130_fd_sc_hd__decap_3
XFILLER_25_243 VPWR VGND VPWR VGND sky130_fd_sc_hd__decap_3
XFILLER_25_276 VPWR VGND VPWR VGND sky130_fd_sc_hd__decap_3
XFILLER_25_287 VPWR VGND VPWR VGND sky130_fd_sc_hd__decap_3
XFILLER_40_224 VPWR VGND VPWR VGND sky130_fd_sc_hd__decap_3
XFILLER_43_57 VPWR VGND VPWR VGND sky130_fd_sc_hd__decap_3
XFILLER_40_268 VPWR VGND VPWR VGND sky130_fd_sc_hd__decap_3
XFILLER_4_147 VPWR VGND VPWR VGND sky130_fd_sc_hd__decap_3
XFILLER_4_136 VPWR VGND VPWR VGND sky130_fd_sc_hd__decap_3
XFILLER_0_331 VPWR VGND VPWR VGND sky130_fd_sc_hd__decap_3
XFILLER_48_324 VPWR VGND VPWR VGND sky130_fd_sc_hd__decap_3
XFILLER_0_397 VPWR VGND VPWR VGND sky130_fd_sc_hd__decap_3
XFILLER_0_375 VPWR VGND VPWR VGND sky130_fd_sc_hd__decap_3
XFILLER_48_368 VPWR VGND VPWR VGND sky130_fd_sc_hd__decap_3
XFILLER_48_357 VPWR VGND VPWR VGND sky130_fd_sc_hd__decap_3
XFILLER_63_305 VPWR VGND VPWR VGND sky130_fd_sc_hd__decap_3
XFILLER_63_349 VPWR VGND VPWR VGND sky130_fd_sc_hd__decap_3
XFILLER_17_91 VPWR VGND VPWR VGND sky130_fd_sc_hd__decap_3
XFILLER_31_202 VPWR VGND VPWR VGND sky130_fd_sc_hd__decap_3
XFILLER_31_246 VPWR VGND VPWR VGND sky130_fd_sc_hd__decap_3
XFILLER_39_302 VPWR VGND VPWR VGND sky130_fd_sc_hd__decap_3
XFILLER_39_346 VPWR VGND VPWR VGND sky130_fd_sc_hd__decap_3
XFILLER_54_327 VPWR VGND VPWR VGND sky130_fd_sc_hd__decap_3
XFILLER_39_379 VPWR VGND VPWR VGND sky130_fd_sc_hd__decap_3
XFILLER_62_360 VPWR VGND VPWR VGND sky130_fd_sc_hd__decap_3
XFILLER_62_371 VPWR VGND VPWR VGND sky130_fd_sc_hd__decap_3
XFILLER_22_268 VPWR VGND VPWR VGND sky130_fd_sc_hd__decap_3
XFILLER_13_49 VPWR VGND VPWR VGND sky130_fd_sc_hd__decap_3
XFILLER_1_128 VPWR VGND VPWR VGND sky130_fd_sc_hd__decap_3
XFILLER_8_9 VPWR VGND VPWR VGND sky130_fd_sc_hd__decap_3
XFILLER_38_35 VPWR VGND VPWR VGND sky130_fd_sc_hd__decap_3
XFILLER_38_24 VPWR VGND VPWR VGND sky130_fd_sc_hd__decap_3
XFILLER_38_79 VPWR VGND VPWR VGND sky130_fd_sc_hd__decap_3
XFILLER_57_143 VPWR VGND VPWR VGND sky130_fd_sc_hd__decap_3
XFILLER_45_305 VPWR VGND VPWR VGND sky130_fd_sc_hd__decap_3
XFILLER_57_187 VPWR VGND VPWR VGND sky130_fd_sc_hd__decap_3
XFILLER_45_349 VPWR VGND VPWR VGND sky130_fd_sc_hd__decap_3
XFILLER_54_12 VPWR VGND VPWR VGND sky130_fd_sc_hd__decap_3
XFILLER_54_56 VPWR VGND VPWR VGND sky130_fd_sc_hd__decap_3
XFILLER_53_393 VPWR VGND VPWR VGND sky130_fd_sc_hd__decap_3
XFILLER_53_382 VPWR VGND VPWR VGND sky130_fd_sc_hd__decap_3
XFILLER_0_150 VPWR VGND VPWR VGND sky130_fd_sc_hd__decap_3
XFILLER_48_132 VPWR VGND VPWR VGND sky130_fd_sc_hd__decap_3
XFILLER_63_102 VPWR VGND VPWR VGND sky130_fd_sc_hd__decap_3
XFILLER_36_327 VPWR VGND VPWR VGND sky130_fd_sc_hd__decap_3
XFILLER_48_165 VPWR VGND VPWR VGND sky130_fd_sc_hd__decap_3
XFILLER_63_146 VPWR VGND VPWR VGND sky130_fd_sc_hd__decap_3
XFILLER_63_113 VPWR VGND VPWR VGND sky130_fd_sc_hd__decap_3
XFILLER_51_308 VPWR VGND VPWR VGND sky130_fd_sc_hd__decap_3
XFILLER_44_371 VPWR VGND VPWR VGND sky130_fd_sc_hd__decap_3
XFILLER_44_360 VPWR VGND VPWR VGND sky130_fd_sc_hd__decap_3
XFILLER_5_94 VPWR VGND VPWR VGND sky130_fd_sc_hd__decap_3
XFILLER_39_143 VPWR VGND VPWR VGND sky130_fd_sc_hd__decap_3
XFILLER_27_305 VPWR VGND VPWR VGND sky130_fd_sc_hd__decap_3
XFILLER_27_349 VPWR VGND VPWR VGND sky130_fd_sc_hd__decap_3
XFILLER_39_187 VPWR VGND VPWR VGND sky130_fd_sc_hd__decap_3
XFILLER_54_124 VPWR VGND VPWR VGND sky130_fd_sc_hd__decap_3
XFILLER_54_168 VPWR VGND VPWR VGND sky130_fd_sc_hd__decap_3
XFILLER_24_15 VPWR VGND VPWR VGND sky130_fd_sc_hd__decap_3
XFILLER_35_382 VPWR VGND VPWR VGND sky130_fd_sc_hd__decap_3
XPHY_EDGE_ROW_59_Left_165 VPWR VGND VPWR VGND sky130_fd_sc_hd__decap_3
XFILLER_50_330 VPWR VGND VPWR VGND sky130_fd_sc_hd__decap_3
XFILLER_35_393 VPWR VGND VPWR VGND sky130_fd_sc_hd__decap_3
XFILLER_50_374 VPWR VGND VPWR VGND sky130_fd_sc_hd__decap_3
XFILLER_24_59 VPWR VGND VPWR VGND sky130_fd_sc_hd__decap_3
XFILLER_40_47 VPWR VGND VPWR VGND sky130_fd_sc_hd__decap_3
XFILLER_6_6 VPWR VGND VPWR VGND sky130_fd_sc_hd__decap_3
XFILLER_49_12 VPWR VGND VPWR VGND sky130_fd_sc_hd__decap_3
XFILLER_18_349 VPWR VGND VPWR VGND sky130_fd_sc_hd__decap_3
XFILLER_45_113 VPWR VGND VPWR VGND sky130_fd_sc_hd__decap_3
XFILLER_33_308 VPWR VGND VPWR VGND sky130_fd_sc_hd__decap_3
XFILLER_45_146 VPWR VGND VPWR VGND sky130_fd_sc_hd__decap_3
XFILLER_60_127 VPWR VGND VPWR VGND sky130_fd_sc_hd__decap_3
XFILLER_26_360 VPWR VGND VPWR VGND sky130_fd_sc_hd__decap_3
XFILLER_26_371 VPWR VGND VPWR VGND sky130_fd_sc_hd__decap_3
XFILLER_53_190 VPWR VGND VPWR VGND sky130_fd_sc_hd__decap_3
XFILLER_41_385 VPWR VGND VPWR VGND sky130_fd_sc_hd__decap_3
XFILLER_41_352 VPWR VGND VPWR VGND sky130_fd_sc_hd__decap_3
XFILLER_41_396 VPWR VGND VPWR VGND sky130_fd_sc_hd__decap_3
X_285_ VGND VPWR VPWR VGND clknet_2_3__leaf_clk_regs net5 _030_ genblk1\[13\].fa_inst.a
+ _285_/a_1462_47# _285_/a_543_47# _285_/a_651_413# _285_/a_193_47# _285_/a_805_47#
+ _285_/a_448_47# _285_/a_639_47# _285_/a_1283_21# _285_/a_761_289# _285_/a_1108_47#
+ _285_/a_1217_47# _285_/a_1270_413# _285_/a_27_47# sky130_fd_sc_hd__dfrtp_1
XFILLER_30_91 VPWR VGND VPWR VGND sky130_fd_sc_hd__decap_3
XFILLER_39_6 VPWR VGND VPWR VGND sky130_fd_sc_hd__decap_3
Xinput7 VGND VPWR net7 a[15] VPWR VGND input7/a_27_47# sky130_fd_sc_hd__buf_1
XFILLER_36_124 VPWR VGND VPWR VGND sky130_fd_sc_hd__decap_3
XFILLER_36_168 VPWR VGND VPWR VGND sky130_fd_sc_hd__decap_3
XFILLER_17_382 VPWR VGND VPWR VGND sky130_fd_sc_hd__decap_3
XFILLER_51_116 VPWR VGND VPWR VGND sky130_fd_sc_hd__decap_3
XFILLER_32_330 VPWR VGND VPWR VGND sky130_fd_sc_hd__decap_3
XFILLER_51_149 VPWR VGND VPWR VGND sky130_fd_sc_hd__decap_3
XFILLER_32_374 VPWR VGND VPWR VGND sky130_fd_sc_hd__decap_3
XFILLER_59_205 VPWR VGND VPWR VGND sky130_fd_sc_hd__decap_3
XFILLER_59_249 VPWR VGND VPWR VGND sky130_fd_sc_hd__decap_3
XFILLER_19_37 VPWR VGND VPWR VGND sky130_fd_sc_hd__decap_3
XFILLER_27_113 VPWR VGND VPWR VGND sky130_fd_sc_hd__decap_3
XFILLER_27_102 VPWR VGND VPWR VGND sky130_fd_sc_hd__decap_3
XFILLER_27_146 VPWR VGND VPWR VGND sky130_fd_sc_hd__decap_3
XFILLER_35_47 VPWR VGND VPWR VGND sky130_fd_sc_hd__decap_3
XFILLER_42_105 VPWR VGND VPWR VGND sky130_fd_sc_hd__decap_3
XFILLER_35_69 VPWR VGND VPWR VGND sky130_fd_sc_hd__decap_3
XFILLER_35_190 VPWR VGND VPWR VGND sky130_fd_sc_hd__decap_3
XFILLER_23_352 VPWR VGND VPWR VGND sky130_fd_sc_hd__decap_3
XFILLER_23_385 VPWR VGND VPWR VGND sky130_fd_sc_hd__decap_3
XFILLER_23_396 VPWR VGND VPWR VGND sky130_fd_sc_hd__decap_3
XFILLER_50_171 VPWR VGND VPWR VGND sky130_fd_sc_hd__decap_3
XFILLER_51_57 VPWR VGND VPWR VGND sky130_fd_sc_hd__decap_3
XFILLER_51_46 VPWR VGND VPWR VGND sky130_fd_sc_hd__decap_3
XFILLER_58_271 VPWR VGND VPWR VGND sky130_fd_sc_hd__decap_3
XFILLER_18_124 VPWR VGND VPWR VGND sky130_fd_sc_hd__decap_3
XFILLER_18_168 VPWR VGND VPWR VGND sky130_fd_sc_hd__decap_3
XFILLER_33_116 VPWR VGND VPWR VGND sky130_fd_sc_hd__decap_3
XFILLER_33_149 VPWR VGND VPWR VGND sky130_fd_sc_hd__decap_3
XFILLER_14_363 VPWR VGND VPWR VGND sky130_fd_sc_hd__decap_3
XFILLER_14_396 VPWR VGND VPWR VGND sky130_fd_sc_hd__decap_3
XFILLER_25_91 VPWR VGND VPWR VGND sky130_fd_sc_hd__decap_3
XFILLER_41_193 VPWR VGND VPWR VGND sky130_fd_sc_hd__decap_3
X_268_ VGND VPWR VPWR VGND clknet_2_3__leaf_clk_regs genblk1\[13\].fa_inst.s _013_
+ net43 _268_/a_1462_47# _268_/a_543_47# _268_/a_651_413# _268_/a_193_47# _268_/a_805_47#
+ _268_/a_448_47# _268_/a_639_47# _268_/a_1283_21# _268_/a_761_289# _268_/a_1108_47#
+ _268_/a_1217_47# _268_/a_1270_413# _268_/a_27_47# sky130_fd_sc_hd__dfrtp_1
XFILLER_41_90 VPWR VGND VPWR VGND sky130_fd_sc_hd__decap_3
X_199_ VGND VPWR _108_ genblk1\[14\].fa_inst.s _107_ VPWR VGND _199_/a_129_47# _199_/a_47_47#
+ _199_/a_285_47# _199_/a_377_297# sky130_fd_sc_hd__xnor2_1
XFILLER_37_3 VPWR VGND VPWR VGND sky130_fd_sc_hd__decap_3
XFILLER_2_62 VPWR VGND VPWR VGND sky130_fd_sc_hd__decap_3
XFILLER_49_293 VPWR VGND VPWR VGND sky130_fd_sc_hd__decap_3
XFILLER_64_274 VPWR VGND VPWR VGND sky130_fd_sc_hd__decap_3
XFILLER_64_296 VPWR VGND VPWR VGND sky130_fd_sc_hd__decap_3
XFILLER_32_193 VPWR VGND VPWR VGND sky130_fd_sc_hd__decap_3
XFILLER_20_366 VPWR VGND VPWR VGND sky130_fd_sc_hd__decap_3
XFILLER_20_399 VPWR VGND VPWR VGND sky130_fd_sc_hd__decap_3
XFILLER_21_38 VPWR VGND VPWR VGND sky130_fd_sc_hd__decap_3
XFILLER_47_208 VPWR VGND VPWR VGND sky130_fd_sc_hd__decap_3
XFILLER_46_24 VPWR VGND VPWR VGND sky130_fd_sc_hd__decap_3
XFILLER_46_35 VPWR VGND VPWR VGND sky130_fd_sc_hd__decap_3
XFILLER_46_68 VPWR VGND VPWR VGND sky130_fd_sc_hd__decap_3
XFILLER_55_252 VPWR VGND VPWR VGND sky130_fd_sc_hd__decap_3
XFILLER_15_105 VPWR VGND VPWR VGND sky130_fd_sc_hd__decap_3
XFILLER_15_116 VPWR VGND VPWR VGND sky130_fd_sc_hd__decap_3
XFILLER_62_12 VPWR VGND VPWR VGND sky130_fd_sc_hd__decap_3
XFILLER_55_296 VPWR VGND VPWR VGND sky130_fd_sc_hd__decap_3
XFILLER_15_149 VPWR VGND VPWR VGND sky130_fd_sc_hd__decap_3
XFILLER_62_56 VPWR VGND VPWR VGND sky130_fd_sc_hd__decap_3
XFILLER_11_355 VPWR VGND VPWR VGND sky130_fd_sc_hd__decap_3
XFILLER_7_18 VPWR VGND VPWR VGND sky130_fd_sc_hd__decap_3
XFILLER_23_193 VPWR VGND VPWR VGND sky130_fd_sc_hd__decap_3
XFILLER_11_388 VPWR VGND VPWR VGND sky130_fd_sc_hd__decap_3
XFILLER_7_337 VPWR VGND VPWR VGND sky130_fd_sc_hd__decap_3
XFILLER_11_71 VPWR VGND VPWR VGND sky130_fd_sc_hd__decap_3
XFILLER_23_9 VPWR VGND VPWR VGND sky130_fd_sc_hd__decap_3
XFILLER_19_400 VPWR VGND VPWR VGND sky130_fd_sc_hd__decap_3
XFILLER_46_230 VPWR VGND VPWR VGND sky130_fd_sc_hd__decap_3
XFILLER_61_211 VPWR VGND VPWR VGND sky130_fd_sc_hd__decap_3
XFILLER_46_274 VPWR VGND VPWR VGND sky130_fd_sc_hd__decap_3
XFILLER_61_255 VPWR VGND VPWR VGND sky130_fd_sc_hd__decap_3
XFILLER_61_299 VPWR VGND VPWR VGND sky130_fd_sc_hd__decap_3
XFILLER_14_171 VPWR VGND VPWR VGND sky130_fd_sc_hd__decap_3
XFILLER_21_119 VPWR VGND VPWR VGND sky130_fd_sc_hd__decap_3
Xinput10 VGND VPWR net10 a[3] VPWR VGND input10/a_75_212# sky130_fd_sc_hd__clkbuf_1
Xinput21 VGND VPWR net21 b[13] VPWR VGND input21/a_75_212# sky130_fd_sc_hd__clkbuf_1
Xinput32 VGND VPWR net32 b[9] VPWR VGND input32/a_75_212# sky130_fd_sc_hd__clkbuf_1
XFILLER_6_381 VPWR VGND VPWR VGND sky130_fd_sc_hd__decap_3
XPHY_EDGE_ROW_12_2_Left_33 VPWR VGND VPWR VGND sky130_fd_sc_hd__decap_3
XFILLER_29_208 VPWR VGND VPWR VGND sky130_fd_sc_hd__decap_3
XFILLER_37_252 VPWR VGND VPWR VGND sky130_fd_sc_hd__decap_3
XFILLER_52_200 VPWR VGND VPWR VGND sky130_fd_sc_hd__decap_3
XFILLER_16_38 VPWR VGND VPWR VGND sky130_fd_sc_hd__decap_3
XFILLER_37_296 VPWR VGND VPWR VGND sky130_fd_sc_hd__decap_3
XFILLER_52_233 VPWR VGND VPWR VGND sky130_fd_sc_hd__decap_3
XFILLER_52_277 VPWR VGND VPWR VGND sky130_fd_sc_hd__decap_3
XFILLER_32_15 VPWR VGND VPWR VGND sky130_fd_sc_hd__decap_3
XFILLER_20_141 VPWR VGND VPWR VGND sky130_fd_sc_hd__decap_3
XFILLER_32_59 VPWR VGND VPWR VGND sky130_fd_sc_hd__decap_3
XFILLER_20_174 VPWR VGND VPWR VGND sky130_fd_sc_hd__decap_3
XFILLER_57_12 VPWR VGND VPWR VGND sky130_fd_sc_hd__decap_3
XFILLER_28_230 VPWR VGND VPWR VGND sky130_fd_sc_hd__decap_3
XFILLER_57_89 VPWR VGND VPWR VGND sky130_fd_sc_hd__decap_3
XFILLER_28_274 VPWR VGND VPWR VGND sky130_fd_sc_hd__decap_3
XFILLER_43_211 VPWR VGND VPWR VGND sky130_fd_sc_hd__decap_3
XFILLER_43_255 VPWR VGND VPWR VGND sky130_fd_sc_hd__decap_3
XFILLER_43_299 VPWR VGND VPWR VGND sky130_fd_sc_hd__decap_3
XFILLER_11_152 VPWR VGND VPWR VGND sky130_fd_sc_hd__decap_3
XFILLER_7_134 VPWR VGND VPWR VGND sky130_fd_sc_hd__decap_3
XFILLER_22_81 VPWR VGND VPWR VGND sky130_fd_sc_hd__decap_3
XFILLER_3_340 VPWR VGND VPWR VGND sky130_fd_sc_hd__decap_3
XFILLER_3_373 VPWR VGND VPWR VGND sky130_fd_sc_hd__decap_3
XFILLER_21_6 VPWR VGND VPWR VGND sky130_fd_sc_hd__decap_3
XFILLER_34_200 VPWR VGND VPWR VGND sky130_fd_sc_hd__decap_3
XPHY_EDGE_ROW_29_Right_50 VPWR VGND VPWR VGND sky130_fd_sc_hd__decap_3
XFILLER_34_233 VPWR VGND VPWR VGND sky130_fd_sc_hd__decap_3
XPHY_EDGE_ROW_22_Left_128 VPWR VGND VPWR VGND sky130_fd_sc_hd__decap_3
XFILLER_34_277 VPWR VGND VPWR VGND sky130_fd_sc_hd__decap_3
XFILLER_8_94 VPWR VGND VPWR VGND sky130_fd_sc_hd__decap_3
XPHY_EDGE_ROW_31_Left_137 VPWR VGND VPWR VGND sky130_fd_sc_hd__decap_3
XFILLER_57_314 VPWR VGND VPWR VGND sky130_fd_sc_hd__decap_3
XFILLER_57_358 VPWR VGND VPWR VGND sky130_fd_sc_hd__decap_3
XFILLER_27_15 VPWR VGND VPWR VGND sky130_fd_sc_hd__decap_3
XFILLER_25_211 VPWR VGND VPWR VGND sky130_fd_sc_hd__decap_3
XPHY_EDGE_ROW_40_Left_146 VPWR VGND VPWR VGND sky130_fd_sc_hd__decap_3
XFILLER_25_255 VPWR VGND VPWR VGND sky130_fd_sc_hd__decap_3
XFILLER_25_299 VPWR VGND VPWR VGND sky130_fd_sc_hd__decap_3
XFILLER_40_203 VPWR VGND VPWR VGND sky130_fd_sc_hd__decap_3
XFILLER_43_69 VPWR VGND VPWR VGND sky130_fd_sc_hd__decap_3
XFILLER_40_236 VPWR VGND VPWR VGND sky130_fd_sc_hd__decap_3
XFILLER_4_159 VPWR VGND VPWR VGND sky130_fd_sc_hd__decap_3
XFILLER_0_354 VPWR VGND VPWR VGND sky130_fd_sc_hd__decap_3
XFILLER_0_343 VPWR VGND VPWR VGND sky130_fd_sc_hd__decap_3
XFILLER_48_336 VPWR VGND VPWR VGND sky130_fd_sc_hd__decap_3
XFILLER_63_317 VPWR VGND VPWR VGND sky130_fd_sc_hd__decap_3
XFILLER_56_380 VPWR VGND VPWR VGND sky130_fd_sc_hd__decap_3
XFILLER_31_214 VPWR VGND VPWR VGND sky130_fd_sc_hd__decap_3
XFILLER_31_225 VPWR VGND VPWR VGND sky130_fd_sc_hd__decap_3
XFILLER_31_258 VPWR VGND VPWR VGND sky130_fd_sc_hd__decap_3
XFILLER_33_80 VPWR VGND VPWR VGND sky130_fd_sc_hd__decap_3
XFILLER_39_314 VPWR VGND VPWR VGND sky130_fd_sc_hd__decap_3
XFILLER_39_358 VPWR VGND VPWR VGND sky130_fd_sc_hd__decap_3
XFILLER_54_339 VPWR VGND VPWR VGND sky130_fd_sc_hd__decap_3
XFILLER_62_383 VPWR VGND VPWR VGND sky130_fd_sc_hd__decap_3
XFILLER_22_203 VPWR VGND VPWR VGND sky130_fd_sc_hd__decap_3
XFILLER_22_247 VPWR VGND VPWR VGND sky130_fd_sc_hd__decap_3
XFILLER_30_280 VPWR VGND VPWR VGND sky130_fd_sc_hd__decap_3
XFILLER_38_47 VPWR VGND VPWR VGND sky130_fd_sc_hd__decap_3
XFILLER_57_122 VPWR VGND VPWR VGND sky130_fd_sc_hd__decap_3
XFILLER_45_317 VPWR VGND VPWR VGND sky130_fd_sc_hd__decap_3
XFILLER_57_155 VPWR VGND VPWR VGND sky130_fd_sc_hd__decap_3
XFILLER_38_380 VPWR VGND VPWR VGND sky130_fd_sc_hd__decap_3
XFILLER_57_199 VPWR VGND VPWR VGND sky130_fd_sc_hd__decap_3
XFILLER_60_309 VPWR VGND VPWR VGND sky130_fd_sc_hd__decap_3
XFILLER_54_35 VPWR VGND VPWR VGND sky130_fd_sc_hd__decap_3
XFILLER_53_361 VPWR VGND VPWR VGND sky130_fd_sc_hd__decap_3
XFILLER_54_68 VPWR VGND VPWR VGND sky130_fd_sc_hd__decap_3
XFILLER_0_162 VPWR VGND VPWR VGND sky130_fd_sc_hd__decap_3
XFILLER_48_144 VPWR VGND VPWR VGND sky130_fd_sc_hd__decap_3
XFILLER_48_177 VPWR VGND VPWR VGND sky130_fd_sc_hd__decap_3
XFILLER_63_125 VPWR VGND VPWR VGND sky130_fd_sc_hd__decap_3
XFILLER_28_80 VPWR VGND VPWR VGND sky130_fd_sc_hd__decap_3
XFILLER_36_339 VPWR VGND VPWR VGND sky130_fd_sc_hd__decap_3
XFILLER_63_169 VPWR VGND VPWR VGND sky130_fd_sc_hd__decap_3
XFILLER_63_158 VPWR VGND VPWR VGND sky130_fd_sc_hd__decap_3
XFILLER_44_383 VPWR VGND VPWR VGND sky130_fd_sc_hd__decap_3
XPHY_EDGE_ROW_10_1_Left_116 VPWR VGND VPWR VGND sky130_fd_sc_hd__decap_3
XFILLER_39_122 VPWR VGND VPWR VGND sky130_fd_sc_hd__decap_3
XFILLER_27_317 VPWR VGND VPWR VGND sky130_fd_sc_hd__decap_3
XFILLER_39_155 VPWR VGND VPWR VGND sky130_fd_sc_hd__decap_3
XFILLER_54_136 VPWR VGND VPWR VGND sky130_fd_sc_hd__decap_3
XFILLER_39_199 VPWR VGND VPWR VGND sky130_fd_sc_hd__decap_3
XFILLER_42_309 VPWR VGND VPWR VGND sky130_fd_sc_hd__decap_3
XFILLER_54_147 VPWR VGND VPWR VGND sky130_fd_sc_hd__decap_3
XFILLER_35_361 VPWR VGND VPWR VGND sky130_fd_sc_hd__decap_3
XFILLER_62_180 VPWR VGND VPWR VGND sky130_fd_sc_hd__decap_3
XFILLER_50_342 VPWR VGND VPWR VGND sky130_fd_sc_hd__decap_3
XFILLER_24_38 VPWR VGND VPWR VGND sky130_fd_sc_hd__decap_3
XFILLER_50_386 VPWR VGND VPWR VGND sky130_fd_sc_hd__decap_3
XFILLER_40_15 VPWR VGND VPWR VGND sky130_fd_sc_hd__decap_3
XFILLER_40_59 VPWR VGND VPWR VGND sky130_fd_sc_hd__decap_3
XFILLER_49_57 VPWR VGND VPWR VGND sky130_fd_sc_hd__decap_3
XFILLER_49_79 VPWR VGND VPWR VGND sky130_fd_sc_hd__decap_3
XFILLER_18_328 VPWR VGND VPWR VGND sky130_fd_sc_hd__decap_3
XFILLER_45_103 VPWR VGND VPWR VGND sky130_fd_sc_hd__decap_3
XFILLER_45_125 VPWR VGND VPWR VGND sky130_fd_sc_hd__decap_3
XFILLER_45_158 VPWR VGND VPWR VGND sky130_fd_sc_hd__decap_3
XFILLER_45_169 VPWR VGND VPWR VGND sky130_fd_sc_hd__decap_3
XFILLER_60_106 VPWR VGND VPWR VGND sky130_fd_sc_hd__decap_3
XFILLER_26_383 VPWR VGND VPWR VGND sky130_fd_sc_hd__decap_3
XFILLER_41_320 VPWR VGND VPWR VGND sky130_fd_sc_hd__decap_3
XFILLER_41_364 VPWR VGND VPWR VGND sky130_fd_sc_hd__decap_3
XFILLER_14_71 VPWR VGND VPWR VGND sky130_fd_sc_hd__decap_3
X_284_ VGND VPWR VPWR VGND clknet_2_3__leaf_clk_regs net4 _029_ genblk1\[12\].fa_inst.a
+ _284_/a_1462_47# _284_/a_543_47# _284_/a_651_413# _284_/a_193_47# _284_/a_805_47#
+ _284_/a_448_47# _284_/a_639_47# _284_/a_1283_21# _284_/a_761_289# _284_/a_1108_47#
+ _284_/a_1217_47# _284_/a_1270_413# _284_/a_27_47# sky130_fd_sc_hd__dfrtp_1
XFILLER_53_9 VPWR VGND VPWR VGND sky130_fd_sc_hd__decap_3
XFILLER_30_70 VPWR VGND VPWR VGND sky130_fd_sc_hd__decap_3
Xinput8 VGND VPWR net8 a[1] VPWR VGND input8/a_75_212# sky130_fd_sc_hd__clkbuf_1
XFILLER_39_90 VPWR VGND VPWR VGND sky130_fd_sc_hd__decap_3
XFILLER_36_136 VPWR VGND VPWR VGND sky130_fd_sc_hd__decap_3
XFILLER_36_147 VPWR VGND VPWR VGND sky130_fd_sc_hd__decap_3
XFILLER_24_309 VPWR VGND VPWR VGND sky130_fd_sc_hd__decap_3
XFILLER_17_361 VPWR VGND VPWR VGND sky130_fd_sc_hd__decap_3
XFILLER_51_128 VPWR VGND VPWR VGND sky130_fd_sc_hd__decap_3
XFILLER_17_394 VPWR VGND VPWR VGND sky130_fd_sc_hd__decap_3
XFILLER_44_180 VPWR VGND VPWR VGND sky130_fd_sc_hd__decap_3
XFILLER_32_342 VPWR VGND VPWR VGND sky130_fd_sc_hd__decap_3
XFILLER_32_386 VPWR VGND VPWR VGND sky130_fd_sc_hd__decap_3
XFILLER_10_18 VPWR VGND VPWR VGND sky130_fd_sc_hd__decap_3
XFILLER_10_29 VPWR VGND VPWR VGND sky130_fd_sc_hd__decap_3
XFILLER_59_228 VPWR VGND VPWR VGND sky130_fd_sc_hd__decap_3
XFILLER_59_217 VPWR VGND VPWR VGND sky130_fd_sc_hd__decap_3
XFILLER_19_49 VPWR VGND VPWR VGND sky130_fd_sc_hd__decap_3
XFILLER_27_125 VPWR VGND VPWR VGND sky130_fd_sc_hd__decap_3
XFILLER_35_15 VPWR VGND VPWR VGND sky130_fd_sc_hd__decap_3
XFILLER_27_158 VPWR VGND VPWR VGND sky130_fd_sc_hd__decap_3
XFILLER_27_169 VPWR VGND VPWR VGND sky130_fd_sc_hd__decap_3
XFILLER_42_117 VPWR VGND VPWR VGND sky130_fd_sc_hd__decap_3
XFILLER_23_320 VPWR VGND VPWR VGND sky130_fd_sc_hd__decap_3
XFILLER_23_364 VPWR VGND VPWR VGND sky130_fd_sc_hd__decap_3
XFILLER_50_150 VPWR VGND VPWR VGND sky130_fd_sc_hd__decap_3
XFILLER_50_183 VPWR VGND VPWR VGND sky130_fd_sc_hd__decap_3
XFILLER_58_283 VPWR VGND VPWR VGND sky130_fd_sc_hd__decap_3
XFILLER_46_401 VPWR VGND VPWR VGND sky130_fd_sc_hd__decap_3
XFILLER_18_103 VPWR VGND VPWR VGND sky130_fd_sc_hd__decap_3
XFILLER_18_136 VPWR VGND VPWR VGND sky130_fd_sc_hd__decap_3
XFILLER_18_147 VPWR VGND VPWR VGND sky130_fd_sc_hd__decap_3
XFILLER_14_331 VPWR VGND VPWR VGND sky130_fd_sc_hd__decap_3
XFILLER_26_180 VPWR VGND VPWR VGND sky130_fd_sc_hd__decap_3
XFILLER_33_128 VPWR VGND VPWR VGND sky130_fd_sc_hd__decap_3
XFILLER_14_375 VPWR VGND VPWR VGND sky130_fd_sc_hd__decap_3
XFILLER_41_172 VPWR VGND VPWR VGND sky130_fd_sc_hd__decap_3
XFILLER_41_161 VPWR VGND VPWR VGND sky130_fd_sc_hd__decap_3
X_267_ VGND VPWR VPWR VGND clknet_2_3__leaf_clk_regs genblk1\[12\].fa_inst.s _012_
+ net42 _267_/a_1462_47# _267_/a_543_47# _267_/a_651_413# _267_/a_193_47# _267_/a_805_47#
+ _267_/a_448_47# _267_/a_639_47# _267_/a_1283_21# _267_/a_761_289# _267_/a_1108_47#
+ _267_/a_1217_47# _267_/a_1270_413# _267_/a_27_47# sky130_fd_sc_hd__dfrtp_1
X_198_ VGND VPWR VGND VPWR _108_ _104_ _101_ _102_ _198_/a_215_297# _198_/a_27_413#
+ _198_/a_298_297# _198_/a_382_47# sky130_fd_sc_hd__a21bo_1
XFILLER_51_6 VPWR VGND VPWR VGND sky130_fd_sc_hd__decap_3
XFILLER_2_41 VPWR VGND VPWR VGND sky130_fd_sc_hd__decap_3
XFILLER_56_209 VPWR VGND VPWR VGND sky130_fd_sc_hd__decap_3
XFILLER_2_74 VPWR VGND VPWR VGND sky130_fd_sc_hd__decap_3
XFILLER_2_85 VPWR VGND VPWR VGND sky130_fd_sc_hd__decap_3
XFILLER_49_261 VPWR VGND VPWR VGND sky130_fd_sc_hd__decap_3
XFILLER_64_231 VPWR VGND VPWR VGND sky130_fd_sc_hd__decap_3
XFILLER_64_253 VPWR VGND VPWR VGND sky130_fd_sc_hd__decap_3
XFILLER_52_404 VPWR VGND VPWR VGND sky130_fd_sc_hd__decap_3
XFILLER_24_117 VPWR VGND VPWR VGND sky130_fd_sc_hd__decap_3
XFILLER_32_172 VPWR VGND VPWR VGND sky130_fd_sc_hd__decap_3
XFILLER_20_334 VPWR VGND VPWR VGND sky130_fd_sc_hd__decap_3
XFILLER_20_378 VPWR VGND VPWR VGND sky130_fd_sc_hd__decap_3
XFILLER_28_401 VPWR VGND VPWR VGND sky130_fd_sc_hd__decap_3
XFILLER_46_47 VPWR VGND VPWR VGND sky130_fd_sc_hd__decap_3
XFILLER_55_220 VPWR VGND VPWR VGND sky130_fd_sc_hd__decap_3
XFILLER_55_231 VPWR VGND VPWR VGND sky130_fd_sc_hd__decap_3
XFILLER_55_264 VPWR VGND VPWR VGND sky130_fd_sc_hd__decap_3
XFILLER_15_128 VPWR VGND VPWR VGND sky130_fd_sc_hd__decap_3
XFILLER_62_24 VPWR VGND VPWR VGND sky130_fd_sc_hd__decap_3
XFILLER_62_35 VPWR VGND VPWR VGND sky130_fd_sc_hd__decap_3
XFILLER_30_109 VPWR VGND VPWR VGND sky130_fd_sc_hd__decap_3
XFILLER_62_68 VPWR VGND VPWR VGND sky130_fd_sc_hd__decap_3
XFILLER_23_172 VPWR VGND VPWR VGND sky130_fd_sc_hd__decap_3
XFILLER_23_161 VPWR VGND VPWR VGND sky130_fd_sc_hd__decap_3
XFILLER_11_334 VPWR VGND VPWR VGND sky130_fd_sc_hd__decap_3
XFILLER_11_367 VPWR VGND VPWR VGND sky130_fd_sc_hd__decap_3
XFILLER_7_349 VPWR VGND VPWR VGND sky130_fd_sc_hd__decap_3
XFILLER_11_83 VPWR VGND VPWR VGND sky130_fd_sc_hd__decap_3
XFILLER_38_209 VPWR VGND VPWR VGND sky130_fd_sc_hd__decap_3
XFILLER_16_9 VPWR VGND VPWR VGND sky130_fd_sc_hd__decap_3
XFILLER_46_242 VPWR VGND VPWR VGND sky130_fd_sc_hd__decap_3
XFILLER_34_404 VPWR VGND VPWR VGND sky130_fd_sc_hd__decap_3
XFILLER_46_253 VPWR VGND VPWR VGND sky130_fd_sc_hd__decap_3
XFILLER_61_234 VPWR VGND VPWR VGND sky130_fd_sc_hd__decap_3
XFILLER_46_286 VPWR VGND VPWR VGND sky130_fd_sc_hd__decap_3
XFILLER_61_267 VPWR VGND VPWR VGND sky130_fd_sc_hd__decap_3
XFILLER_14_150 VPWR VGND VPWR VGND sky130_fd_sc_hd__decap_3
Xinput22 VGND VPWR net22 b[14] VPWR VGND input22/a_75_212# sky130_fd_sc_hd__clkbuf_1
Xinput11 VGND VPWR net11 a[4] VPWR VGND input11/a_75_212# sky130_fd_sc_hd__clkbuf_1
Xinput33 VGND VPWR net33 cin VPWR VGND input33/a_27_47# sky130_fd_sc_hd__buf_1
XFILLER_6_360 VPWR VGND VPWR VGND sky130_fd_sc_hd__decap_3
XFILLER_6_393 VPWR VGND VPWR VGND sky130_fd_sc_hd__decap_3
Xclkbuf_1_0__f_clk VGND VPWR VGND VPWR clknet_0_clk clknet_1_0__leaf_clk clkbuf_1_0__f_clk/a_110_47#
+ sky130_fd_sc_hd__clkbuf_16
XFILLER_37_231 VPWR VGND VPWR VGND sky130_fd_sc_hd__decap_3
XFILLER_37_220 VPWR VGND VPWR VGND sky130_fd_sc_hd__decap_3
XFILLER_37_264 VPWR VGND VPWR VGND sky130_fd_sc_hd__decap_3
XFILLER_52_212 VPWR VGND VPWR VGND sky130_fd_sc_hd__decap_3
XFILLER_12_109 VPWR VGND VPWR VGND sky130_fd_sc_hd__decap_3
XFILLER_52_256 VPWR VGND VPWR VGND sky130_fd_sc_hd__decap_3
XFILLER_52_245 VPWR VGND VPWR VGND sky130_fd_sc_hd__decap_3
XFILLER_52_289 VPWR VGND VPWR VGND sky130_fd_sc_hd__decap_3
XFILLER_32_38 VPWR VGND VPWR VGND sky130_fd_sc_hd__decap_3
XFILLER_20_153 VPWR VGND VPWR VGND sky130_fd_sc_hd__decap_3
XPHY_EDGE_ROW_13_1_Right_12 VPWR VGND VPWR VGND sky130_fd_sc_hd__decap_3
XFILLER_57_57 VPWR VGND VPWR VGND sky130_fd_sc_hd__decap_3
XFILLER_57_46 VPWR VGND VPWR VGND sky130_fd_sc_hd__decap_3
XFILLER_28_253 VPWR VGND VPWR VGND sky130_fd_sc_hd__decap_3
XFILLER_28_242 VPWR VGND VPWR VGND sky130_fd_sc_hd__decap_3
XFILLER_28_286 VPWR VGND VPWR VGND sky130_fd_sc_hd__decap_3
XFILLER_43_234 VPWR VGND VPWR VGND sky130_fd_sc_hd__decap_3
XFILLER_43_267 VPWR VGND VPWR VGND sky130_fd_sc_hd__decap_3
XFILLER_11_131 VPWR VGND VPWR VGND sky130_fd_sc_hd__decap_3
XFILLER_11_164 VPWR VGND VPWR VGND sky130_fd_sc_hd__decap_3
XFILLER_7_113 VPWR VGND VPWR VGND sky130_fd_sc_hd__decap_3
XFILLER_11_175 VPWR VGND VPWR VGND sky130_fd_sc_hd__decap_3
XFILLER_7_146 VPWR VGND VPWR VGND sky130_fd_sc_hd__decap_3
XFILLER_3_352 VPWR VGND VPWR VGND sky130_fd_sc_hd__decap_3
XFILLER_3_385 VPWR VGND VPWR VGND sky130_fd_sc_hd__decap_3
XFILLER_14_6 VPWR VGND VPWR VGND sky130_fd_sc_hd__decap_3
XFILLER_47_90 VPWR VGND VPWR VGND sky130_fd_sc_hd__decap_3
XFILLER_34_212 VPWR VGND VPWR VGND sky130_fd_sc_hd__decap_3
XFILLER_34_256 VPWR VGND VPWR VGND sky130_fd_sc_hd__decap_3
XFILLER_34_245 VPWR VGND VPWR VGND sky130_fd_sc_hd__decap_3
XFILLER_34_289 VPWR VGND VPWR VGND sky130_fd_sc_hd__decap_3
XFILLER_57_326 VPWR VGND VPWR VGND sky130_fd_sc_hd__decap_3
XFILLER_57_337 VPWR VGND VPWR VGND sky130_fd_sc_hd__decap_3
XFILLER_27_38 VPWR VGND VPWR VGND sky130_fd_sc_hd__decap_3
XPHY_EDGE_ROW_4_1_Left_110 VPWR VGND VPWR VGND sky130_fd_sc_hd__decap_3
XFILLER_25_234 VPWR VGND VPWR VGND sky130_fd_sc_hd__decap_3
XFILLER_25_267 VPWR VGND VPWR VGND sky130_fd_sc_hd__decap_3
XFILLER_43_15 VPWR VGND VPWR VGND sky130_fd_sc_hd__decap_3
XFILLER_40_215 VPWR VGND VPWR VGND sky130_fd_sc_hd__decap_3
XFILLER_43_48 VPWR VGND VPWR VGND sky130_fd_sc_hd__decap_3
XFILLER_40_248 VPWR VGND VPWR VGND sky130_fd_sc_hd__decap_3
XFILLER_40_259 VPWR VGND VPWR VGND sky130_fd_sc_hd__decap_3
XFILLER_4_127 VPWR VGND VPWR VGND sky130_fd_sc_hd__decap_3
XPHY_EDGE_ROW_6_2_Left_27 VPWR VGND VPWR VGND sky130_fd_sc_hd__decap_3
XFILLER_48_315 VPWR VGND VPWR VGND sky130_fd_sc_hd__decap_3
XFILLER_48_304 VPWR VGND VPWR VGND sky130_fd_sc_hd__decap_3
XFILLER_0_388 VPWR VGND VPWR VGND sky130_fd_sc_hd__decap_3
XFILLER_0_366 VPWR VGND VPWR VGND sky130_fd_sc_hd__decap_3
XFILLER_48_348 VPWR VGND VPWR VGND sky130_fd_sc_hd__decap_3
XFILLER_63_329 VPWR VGND VPWR VGND sky130_fd_sc_hd__decap_3
XFILLER_56_392 VPWR VGND VPWR VGND sky130_fd_sc_hd__decap_3
XFILLER_17_82 VPWR VGND VPWR VGND sky130_fd_sc_hd__decap_3
XFILLER_31_237 VPWR VGND VPWR VGND sky130_fd_sc_hd__decap_3
XFILLER_33_92 VPWR VGND VPWR VGND sky130_fd_sc_hd__decap_3
XFILLER_39_326 VPWR VGND VPWR VGND sky130_fd_sc_hd__decap_3
XFILLER_39_337 VPWR VGND VPWR VGND sky130_fd_sc_hd__decap_3
XFILLER_54_318 VPWR VGND VPWR VGND sky130_fd_sc_hd__decap_3
XFILLER_47_370 VPWR VGND VPWR VGND sky130_fd_sc_hd__decap_3
XFILLER_62_351 VPWR VGND VPWR VGND sky130_fd_sc_hd__decap_3
XFILLER_22_215 VPWR VGND VPWR VGND sky130_fd_sc_hd__decap_3
XFILLER_62_395 VPWR VGND VPWR VGND sky130_fd_sc_hd__decap_3
XFILLER_22_259 VPWR VGND VPWR VGND sky130_fd_sc_hd__decap_3
XFILLER_30_292 VPWR VGND VPWR VGND sky130_fd_sc_hd__decap_3
XFILLER_1_119 VPWR VGND VPWR VGND sky130_fd_sc_hd__decap_3
XFILLER_1_108 VPWR VGND VPWR VGND sky130_fd_sc_hd__decap_3
XFILLER_38_15 VPWR VGND VPWR VGND sky130_fd_sc_hd__decap_3
XFILLER_57_101 VPWR VGND VPWR VGND sky130_fd_sc_hd__decap_3
XFILLER_38_59 VPWR VGND VPWR VGND sky130_fd_sc_hd__decap_3
XFILLER_57_134 VPWR VGND VPWR VGND sky130_fd_sc_hd__decap_3
XFILLER_57_178 VPWR VGND VPWR VGND sky130_fd_sc_hd__decap_3
XFILLER_45_329 VPWR VGND VPWR VGND sky130_fd_sc_hd__decap_3
XFILLER_38_392 VPWR VGND VPWR VGND sky130_fd_sc_hd__decap_3
XFILLER_53_340 VPWR VGND VPWR VGND sky130_fd_sc_hd__decap_3
XFILLER_54_47 VPWR VGND VPWR VGND sky130_fd_sc_hd__decap_3
XFILLER_53_373 VPWR VGND VPWR VGND sky130_fd_sc_hd__decap_3
XPHY_EDGE_ROW_48_Right_69 VPWR VGND VPWR VGND sky130_fd_sc_hd__decap_3
XFILLER_21_281 VPWR VGND VPWR VGND sky130_fd_sc_hd__decap_3
XPHY_EDGE_ROW_57_Right_78 VPWR VGND VPWR VGND sky130_fd_sc_hd__decap_3
XFILLER_0_141 VPWR VGND VPWR VGND sky130_fd_sc_hd__decap_3
XFILLER_48_123 VPWR VGND VPWR VGND sky130_fd_sc_hd__decap_3
XFILLER_36_318 VPWR VGND VPWR VGND sky130_fd_sc_hd__decap_3
XFILLER_48_156 VPWR VGND VPWR VGND sky130_fd_sc_hd__decap_3
XFILLER_63_137 VPWR VGND VPWR VGND sky130_fd_sc_hd__decap_3
XFILLER_29_370 VPWR VGND VPWR VGND sky130_fd_sc_hd__decap_3
XFILLER_48_189 VPWR VGND VPWR VGND sky130_fd_sc_hd__decap_3
XFILLER_44_351 VPWR VGND VPWR VGND sky130_fd_sc_hd__decap_3
XFILLER_44_395 VPWR VGND VPWR VGND sky130_fd_sc_hd__decap_3
XFILLER_44_80 VPWR VGND VPWR VGND sky130_fd_sc_hd__decap_3
XFILLER_5_85 VPWR VGND VPWR VGND sky130_fd_sc_hd__decap_3
XFILLER_39_134 VPWR VGND VPWR VGND sky130_fd_sc_hd__decap_3
XFILLER_27_329 VPWR VGND VPWR VGND sky130_fd_sc_hd__decap_3
XFILLER_39_178 VPWR VGND VPWR VGND sky130_fd_sc_hd__decap_3
XFILLER_35_340 VPWR VGND VPWR VGND sky130_fd_sc_hd__decap_3
XFILLER_54_159 VPWR VGND VPWR VGND sky130_fd_sc_hd__decap_3
XFILLER_35_373 VPWR VGND VPWR VGND sky130_fd_sc_hd__decap_3
XFILLER_62_192 VPWR VGND VPWR VGND sky130_fd_sc_hd__decap_3
XFILLER_50_321 VPWR VGND VPWR VGND sky130_fd_sc_hd__decap_3
XFILLER_50_365 VPWR VGND VPWR VGND sky130_fd_sc_hd__decap_3
XFILLER_50_354 VPWR VGND VPWR VGND sky130_fd_sc_hd__decap_3
XFILLER_50_398 VPWR VGND VPWR VGND sky130_fd_sc_hd__decap_3
XFILLER_40_38 VPWR VGND VPWR VGND sky130_fd_sc_hd__decap_3
XFILLER_49_47 VPWR VGND VPWR VGND sky130_fd_sc_hd__decap_3
XFILLER_45_137 VPWR VGND VPWR VGND sky130_fd_sc_hd__decap_3
XFILLER_60_118 VPWR VGND VPWR VGND sky130_fd_sc_hd__decap_3
XFILLER_26_351 VPWR VGND VPWR VGND sky130_fd_sc_hd__decap_3
XFILLER_41_332 VPWR VGND VPWR VGND sky130_fd_sc_hd__decap_3
XFILLER_26_395 VPWR VGND VPWR VGND sky130_fd_sc_hd__decap_3
XFILLER_53_181 VPWR VGND VPWR VGND sky130_fd_sc_hd__decap_3
XFILLER_41_376 VPWR VGND VPWR VGND sky130_fd_sc_hd__decap_3
XFILLER_41_343 VPWR VGND VPWR VGND sky130_fd_sc_hd__decap_3
X_283_ VGND VPWR VPWR VGND clknet_2_2__leaf_clk_regs net3 _028_ genblk1\[11\].fa_inst.a
+ _283_/a_1462_47# _283_/a_543_47# _283_/a_651_413# _283_/a_193_47# _283_/a_805_47#
+ _283_/a_448_47# _283_/a_639_47# _283_/a_1283_21# _283_/a_761_289# _283_/a_1108_47#
+ _283_/a_1217_47# _283_/a_1270_413# _283_/a_27_47# sky130_fd_sc_hd__dfrtp_1
XFILLER_14_94 VPWR VGND VPWR VGND sky130_fd_sc_hd__decap_3
XFILLER_46_9 VPWR VGND VPWR VGND sky130_fd_sc_hd__decap_3
Xinput9 VGND VPWR net9 a[2] VPWR VGND input9/a_75_212# sky130_fd_sc_hd__clkbuf_1
XFILLER_36_159 VPWR VGND VPWR VGND sky130_fd_sc_hd__decap_3
XFILLER_17_340 VPWR VGND VPWR VGND sky130_fd_sc_hd__decap_3
XFILLER_17_373 VPWR VGND VPWR VGND sky130_fd_sc_hd__decap_3
XFILLER_55_90 VPWR VGND VPWR VGND sky130_fd_sc_hd__decap_3
XFILLER_32_321 VPWR VGND VPWR VGND sky130_fd_sc_hd__decap_3
XFILLER_44_192 VPWR VGND VPWR VGND sky130_fd_sc_hd__decap_3
XFILLER_32_354 VPWR VGND VPWR VGND sky130_fd_sc_hd__decap_3
XFILLER_32_365 VPWR VGND VPWR VGND sky130_fd_sc_hd__decap_3
XFILLER_32_398 VPWR VGND VPWR VGND sky130_fd_sc_hd__decap_3
XFILLER_55_402 VPWR VGND VPWR VGND sky130_fd_sc_hd__decap_3
XFILLER_27_137 VPWR VGND VPWR VGND sky130_fd_sc_hd__decap_3
XFILLER_35_38 VPWR VGND VPWR VGND sky130_fd_sc_hd__decap_3
XFILLER_35_181 VPWR VGND VPWR VGND sky130_fd_sc_hd__decap_3
XFILLER_23_332 VPWR VGND VPWR VGND sky130_fd_sc_hd__decap_3
XFILLER_42_129 VPWR VGND VPWR VGND sky130_fd_sc_hd__decap_3
XFILLER_23_343 VPWR VGND VPWR VGND sky130_fd_sc_hd__decap_3
XFILLER_23_376 VPWR VGND VPWR VGND sky130_fd_sc_hd__decap_3
XFILLER_51_15 VPWR VGND VPWR VGND sky130_fd_sc_hd__decap_3
XFILLER_50_162 VPWR VGND VPWR VGND sky130_fd_sc_hd__decap_3
XFILLER_58_262 VPWR VGND VPWR VGND sky130_fd_sc_hd__decap_3
XFILLER_18_115 VPWR VGND VPWR VGND sky130_fd_sc_hd__decap_3
XFILLER_58_295 VPWR VGND VPWR VGND sky130_fd_sc_hd__decap_3
XFILLER_18_159 VPWR VGND VPWR VGND sky130_fd_sc_hd__decap_3
XFILLER_33_107 VPWR VGND VPWR VGND sky130_fd_sc_hd__decap_3
XFILLER_14_354 VPWR VGND VPWR VGND sky130_fd_sc_hd__decap_3
XFILLER_14_343 VPWR VGND VPWR VGND sky130_fd_sc_hd__decap_3
XFILLER_26_192 VPWR VGND VPWR VGND sky130_fd_sc_hd__decap_3
XFILLER_41_140 VPWR VGND VPWR VGND sky130_fd_sc_hd__decap_3
XFILLER_14_387 VPWR VGND VPWR VGND sky130_fd_sc_hd__decap_3
XFILLER_25_82 VPWR VGND VPWR VGND sky130_fd_sc_hd__decap_3
XFILLER_41_184 VPWR VGND VPWR VGND sky130_fd_sc_hd__decap_3
X_266_ VGND VPWR VPWR VGND clknet_2_3__leaf_clk_regs genblk1\[11\].fa_inst.s _011_
+ net41 _266_/a_1462_47# _266_/a_543_47# _266_/a_651_413# _266_/a_193_47# _266_/a_805_47#
+ _266_/a_448_47# _266_/a_639_47# _266_/a_1283_21# _266_/a_761_289# _266_/a_1108_47#
+ _266_/a_1217_47# _266_/a_1270_413# _266_/a_27_47# sky130_fd_sc_hd__dfrtp_1
XFILLER_41_81 VPWR VGND VPWR VGND sky130_fd_sc_hd__decap_3
X_197_ VPWR VGND VGND VPWR _105_ _107_ _106_ _197_/a_113_47# sky130_fd_sc_hd__nand2_1
XFILLER_44_6 VPWR VGND VPWR VGND sky130_fd_sc_hd__decap_3
XFILLER_2_53 VPWR VGND VPWR VGND sky130_fd_sc_hd__decap_3
XFILLER_49_240 VPWR VGND VPWR VGND sky130_fd_sc_hd__decap_3
XFILLER_49_273 VPWR VGND VPWR VGND sky130_fd_sc_hd__decap_3
XFILLER_49_284 VPWR VGND VPWR VGND sky130_fd_sc_hd__decap_3
XFILLER_64_243 VPWR VGND VPWR VGND sky130_fd_sc_hd__decap_3
XFILLER_64_221 VPWR VGND VPWR VGND sky130_fd_sc_hd__decap_3
XFILLER_2_97 VPWR VGND VPWR VGND sky130_fd_sc_hd__decap_3
XFILLER_64_265 VPWR VGND VPWR VGND sky130_fd_sc_hd__decap_3
XFILLER_64_287 VPWR VGND VPWR VGND sky130_fd_sc_hd__decap_3
XFILLER_24_129 VPWR VGND VPWR VGND sky130_fd_sc_hd__decap_3
XFILLER_32_184 VPWR VGND VPWR VGND sky130_fd_sc_hd__decap_3
XFILLER_20_346 VPWR VGND VPWR VGND sky130_fd_sc_hd__decap_3
XFILLER_20_357 VPWR VGND VPWR VGND sky130_fd_sc_hd__decap_3
XFILLER_21_18 VPWR VGND VPWR VGND sky130_fd_sc_hd__decap_3
XFILLER_9_391 VPWR VGND VPWR VGND sky130_fd_sc_hd__decap_3
XFILLER_21_29 VPWR VGND VPWR VGND sky130_fd_sc_hd__decap_3
XFILLER_46_15 VPWR VGND VPWR VGND sky130_fd_sc_hd__decap_3
XFILLER_46_59 VPWR VGND VPWR VGND sky130_fd_sc_hd__decap_3
XFILLER_55_243 VPWR VGND VPWR VGND sky130_fd_sc_hd__decap_3
XFILLER_55_276 VPWR VGND VPWR VGND sky130_fd_sc_hd__decap_3
XFILLER_55_287 VPWR VGND VPWR VGND sky130_fd_sc_hd__decap_3
XFILLER_23_140 VPWR VGND VPWR VGND sky130_fd_sc_hd__decap_3
XFILLER_62_47 VPWR VGND VPWR VGND sky130_fd_sc_hd__decap_3
XFILLER_11_346 VPWR VGND VPWR VGND sky130_fd_sc_hd__decap_3
XFILLER_23_184 VPWR VGND VPWR VGND sky130_fd_sc_hd__decap_3
XFILLER_11_51 VPWR VGND VPWR VGND sky130_fd_sc_hd__decap_3
XFILLER_11_95 VPWR VGND VPWR VGND sky130_fd_sc_hd__decap_3
XFILLER_46_221 VPWR VGND VPWR VGND sky130_fd_sc_hd__decap_3
XFILLER_61_202 VPWR VGND VPWR VGND sky130_fd_sc_hd__decap_3
XFILLER_46_265 VPWR VGND VPWR VGND sky130_fd_sc_hd__decap_3
XFILLER_46_298 VPWR VGND VPWR VGND sky130_fd_sc_hd__decap_3
XFILLER_36_81 VPWR VGND VPWR VGND sky130_fd_sc_hd__decap_3
XFILLER_61_246 VPWR VGND VPWR VGND sky130_fd_sc_hd__decap_3
XFILLER_14_162 VPWR VGND VPWR VGND sky130_fd_sc_hd__decap_3
Xinput12 VGND VPWR net12 a[5] VPWR VGND input12/a_75_212# sky130_fd_sc_hd__clkbuf_1
XFILLER_52_91 VPWR VGND VPWR VGND sky130_fd_sc_hd__decap_3
Xinput34 VPWR VGND net34 delay_sel[0] VPWR VGND input34/a_27_47# sky130_fd_sc_hd__buf_2
Xinput23 VGND VPWR net23 b[15] VPWR VGND input23/a_75_212# sky130_fd_sc_hd__clkbuf_1
X_249_ net60 _044_ VPWR VGND VPWR VGND sky130_fd_sc_hd__inv_2
XFILLER_10_390 VPWR VGND VPWR VGND sky130_fd_sc_hd__decap_3
XFILLER_6_372 VPWR VGND VPWR VGND sky130_fd_sc_hd__decap_3
XFILLER_37_243 VPWR VGND VPWR VGND sky130_fd_sc_hd__decap_3
XFILLER_37_276 VPWR VGND VPWR VGND sky130_fd_sc_hd__decap_3
XFILLER_16_18 VPWR VGND VPWR VGND sky130_fd_sc_hd__decap_3
XFILLER_37_287 VPWR VGND VPWR VGND sky130_fd_sc_hd__decap_3
XFILLER_52_224 VPWR VGND VPWR VGND sky130_fd_sc_hd__decap_3
XFILLER_52_268 VPWR VGND VPWR VGND sky130_fd_sc_hd__decap_3
XFILLER_20_132 VPWR VGND VPWR VGND sky130_fd_sc_hd__decap_3
XFILLER_20_165 VPWR VGND VPWR VGND sky130_fd_sc_hd__decap_3
XFILLER_28_221 VPWR VGND VPWR VGND sky130_fd_sc_hd__decap_3
XFILLER_28_265 VPWR VGND VPWR VGND sky130_fd_sc_hd__decap_3
XFILLER_28_298 VPWR VGND VPWR VGND sky130_fd_sc_hd__decap_3
XFILLER_43_202 VPWR VGND VPWR VGND sky130_fd_sc_hd__decap_3
XFILLER_43_246 VPWR VGND VPWR VGND sky130_fd_sc_hd__decap_3
XFILLER_51_290 VPWR VGND VPWR VGND sky130_fd_sc_hd__decap_3
XFILLER_11_143 VPWR VGND VPWR VGND sky130_fd_sc_hd__decap_3
XFILLER_7_103 VPWR VGND VPWR VGND sky130_fd_sc_hd__decap_3
XFILLER_7_125 VPWR VGND VPWR VGND sky130_fd_sc_hd__decap_3
XFILLER_22_50 VPWR VGND VPWR VGND sky130_fd_sc_hd__decap_3
XFILLER_7_169 VPWR VGND VPWR VGND sky130_fd_sc_hd__decap_3
XFILLER_7_158 VPWR VGND VPWR VGND sky130_fd_sc_hd__decap_3
XFILLER_22_72 VPWR VGND VPWR VGND sky130_fd_sc_hd__decap_3
XFILLER_22_94 VPWR VGND VPWR VGND sky130_fd_sc_hd__decap_3
XFILLER_3_331 VPWR VGND VPWR VGND sky130_fd_sc_hd__decap_3
XFILLER_3_397 VPWR VGND VPWR VGND sky130_fd_sc_hd__decap_3
XFILLER_3_364 VPWR VGND VPWR VGND sky130_fd_sc_hd__decap_3
XFILLER_34_224 VPWR VGND VPWR VGND sky130_fd_sc_hd__decap_3
XFILLER_34_268 VPWR VGND VPWR VGND sky130_fd_sc_hd__decap_3
XFILLER_63_90 VPWR VGND VPWR VGND sky130_fd_sc_hd__decap_3
XFILLER_8_41 VPWR VGND VPWR VGND sky130_fd_sc_hd__decap_3
XFILLER_8_74 VPWR VGND VPWR VGND sky130_fd_sc_hd__decap_3
XFILLER_8_85 VPWR VGND VPWR VGND sky130_fd_sc_hd__decap_3
XFILLER_57_349 VPWR VGND VPWR VGND sky130_fd_sc_hd__decap_3
XFILLER_25_202 VPWR VGND VPWR VGND sky130_fd_sc_hd__decap_3
XFILLER_25_246 VPWR VGND VPWR VGND sky130_fd_sc_hd__decap_3
XFILLER_33_290 VPWR VGND VPWR VGND sky130_fd_sc_hd__decap_3
XFILLER_40_227 VPWR VGND VPWR VGND sky130_fd_sc_hd__decap_3
XFILLER_0_334 VPWR VGND VPWR VGND sky130_fd_sc_hd__decap_3
XFILLER_0_378 VPWR VGND VPWR VGND sky130_fd_sc_hd__decap_3
XFILLER_48_327 VPWR VGND VPWR VGND sky130_fd_sc_hd__decap_3
XFILLER_63_308 VPWR VGND VPWR VGND sky130_fd_sc_hd__decap_3
XFILLER_56_371 VPWR VGND VPWR VGND sky130_fd_sc_hd__decap_3
XFILLER_56_360 VPWR VGND VPWR VGND sky130_fd_sc_hd__decap_3
XFILLER_17_50 VPWR VGND VPWR VGND sky130_fd_sc_hd__decap_3
XFILLER_17_94 VPWR VGND VPWR VGND sky130_fd_sc_hd__decap_3
XFILLER_31_205 VPWR VGND VPWR VGND sky130_fd_sc_hd__decap_3
XFILLER_31_249 VPWR VGND VPWR VGND sky130_fd_sc_hd__decap_3
XFILLER_33_60 VPWR VGND VPWR VGND sky130_fd_sc_hd__decap_3
XFILLER_3_161 VPWR VGND VPWR VGND sky130_fd_sc_hd__decap_3
XFILLER_3_172 VPWR VGND VPWR VGND sky130_fd_sc_hd__decap_3
XFILLER_39_305 VPWR VGND VPWR VGND sky130_fd_sc_hd__decap_3
XFILLER_39_349 VPWR VGND VPWR VGND sky130_fd_sc_hd__decap_3
Xhold1 net75 cin_q VPWR VGND VGND VPWR hold1/a_49_47# hold1/a_285_47# hold1/a_391_47#
+ sky130_fd_sc_hd__dlygate4sd3_1
XFILLER_47_382 VPWR VGND VPWR VGND sky130_fd_sc_hd__decap_3
XFILLER_62_330 VPWR VGND VPWR VGND sky130_fd_sc_hd__decap_3
XFILLER_47_393 VPWR VGND VPWR VGND sky130_fd_sc_hd__decap_3
XFILLER_62_374 VPWR VGND VPWR VGND sky130_fd_sc_hd__decap_3
XFILLER_22_238 VPWR VGND VPWR VGND sky130_fd_sc_hd__decap_3
XFILLER_30_271 VPWR VGND VPWR VGND sky130_fd_sc_hd__decap_3
XFILLER_38_38 VPWR VGND VPWR VGND sky130_fd_sc_hd__decap_3
XFILLER_57_113 VPWR VGND VPWR VGND sky130_fd_sc_hd__decap_3
XFILLER_45_308 VPWR VGND VPWR VGND sky130_fd_sc_hd__decap_3
XFILLER_57_146 VPWR VGND VPWR VGND sky130_fd_sc_hd__decap_3
XFILLER_38_371 VPWR VGND VPWR VGND sky130_fd_sc_hd__decap_3
XFILLER_38_360 VPWR VGND VPWR VGND sky130_fd_sc_hd__decap_3
XFILLER_54_15 VPWR VGND VPWR VGND sky130_fd_sc_hd__decap_3
XFILLER_53_352 VPWR VGND VPWR VGND sky130_fd_sc_hd__decap_3
XFILLER_54_59 VPWR VGND VPWR VGND sky130_fd_sc_hd__decap_3
XFILLER_53_396 VPWR VGND VPWR VGND sky130_fd_sc_hd__decap_3
XFILLER_53_385 VPWR VGND VPWR VGND sky130_fd_sc_hd__decap_3
XFILLER_21_293 VPWR VGND VPWR VGND sky130_fd_sc_hd__decap_3
XFILLER_0_153 VPWR VGND VPWR VGND sky130_fd_sc_hd__decap_3
XFILLER_0_131 VPWR VGND VPWR VGND sky130_fd_sc_hd__decap_3
XFILLER_48_135 VPWR VGND VPWR VGND sky130_fd_sc_hd__decap_3
XFILLER_48_168 VPWR VGND VPWR VGND sky130_fd_sc_hd__decap_3
XFILLER_63_105 VPWR VGND VPWR VGND sky130_fd_sc_hd__decap_3
XFILLER_63_116 VPWR VGND VPWR VGND sky130_fd_sc_hd__decap_3
XFILLER_28_60 VPWR VGND VPWR VGND sky130_fd_sc_hd__decap_3
XFILLER_29_382 VPWR VGND VPWR VGND sky130_fd_sc_hd__decap_3
XFILLER_63_149 VPWR VGND VPWR VGND sky130_fd_sc_hd__decap_3
XFILLER_44_330 VPWR VGND VPWR VGND sky130_fd_sc_hd__decap_3
XFILLER_29_393 VPWR VGND VPWR VGND sky130_fd_sc_hd__decap_3
XFILLER_44_374 VPWR VGND VPWR VGND sky130_fd_sc_hd__decap_3
XFILLER_60_91 VPWR VGND VPWR VGND sky130_fd_sc_hd__decap_3
XFILLER_60_80 VPWR VGND VPWR VGND sky130_fd_sc_hd__decap_3
XFILLER_5_97 VPWR VGND VPWR VGND sky130_fd_sc_hd__decap_3
XFILLER_39_113 VPWR VGND VPWR VGND sky130_fd_sc_hd__decap_3
XFILLER_39_102 VPWR VGND VPWR VGND sky130_fd_sc_hd__decap_3
XFILLER_27_308 VPWR VGND VPWR VGND sky130_fd_sc_hd__decap_3
XFILLER_39_146 VPWR VGND VPWR VGND sky130_fd_sc_hd__decap_3
XFILLER_54_127 VPWR VGND VPWR VGND sky130_fd_sc_hd__decap_3
XFILLER_47_190 VPWR VGND VPWR VGND sky130_fd_sc_hd__decap_3
XFILLER_35_352 VPWR VGND VPWR VGND sky130_fd_sc_hd__decap_3
XFILLER_62_171 VPWR VGND VPWR VGND sky130_fd_sc_hd__decap_3
XFILLER_50_333 VPWR VGND VPWR VGND sky130_fd_sc_hd__decap_3
XFILLER_24_18 VPWR VGND VPWR VGND sky130_fd_sc_hd__decap_3
XFILLER_35_385 VPWR VGND VPWR VGND sky130_fd_sc_hd__decap_3
XFILLER_35_396 VPWR VGND VPWR VGND sky130_fd_sc_hd__decap_3
XFILLER_50_377 VPWR VGND VPWR VGND sky130_fd_sc_hd__decap_3
XPHY_EDGE_ROW_28_Left_134 VPWR VGND VPWR VGND sky130_fd_sc_hd__decap_3
XFILLER_6_9 VPWR VGND VPWR VGND sky130_fd_sc_hd__decap_3
XPHY_EDGE_ROW_37_Left_143 VPWR VGND VPWR VGND sky130_fd_sc_hd__decap_3
XFILLER_45_116 VPWR VGND VPWR VGND sky130_fd_sc_hd__decap_3
XFILLER_26_330 VPWR VGND VPWR VGND sky130_fd_sc_hd__decap_3
XFILLER_45_149 VPWR VGND VPWR VGND sky130_fd_sc_hd__decap_3
XFILLER_26_374 VPWR VGND VPWR VGND sky130_fd_sc_hd__decap_3
XFILLER_41_311 VPWR VGND VPWR VGND sky130_fd_sc_hd__decap_3
XFILLER_53_193 VPWR VGND VPWR VGND sky130_fd_sc_hd__decap_3
XFILLER_41_355 VPWR VGND VPWR VGND sky130_fd_sc_hd__decap_3
XFILLER_41_399 VPWR VGND VPWR VGND sky130_fd_sc_hd__decap_3
XFILLER_41_388 VPWR VGND VPWR VGND sky130_fd_sc_hd__decap_3
X_282_ VGND VPWR VPWR VGND clknet_2_2__leaf_clk_regs net2 _027_ genblk1\[10\].fa_inst.a
+ _282_/a_1462_47# _282_/a_543_47# _282_/a_651_413# _282_/a_193_47# _282_/a_805_47#
+ _282_/a_448_47# _282_/a_639_47# _282_/a_1283_21# _282_/a_761_289# _282_/a_1108_47#
+ _282_/a_1217_47# _282_/a_1270_413# _282_/a_27_47# sky130_fd_sc_hd__dfrtp_1
XPHY_EDGE_ROW_46_Left_152 VPWR VGND VPWR VGND sky130_fd_sc_hd__decap_3
XFILLER_30_50 VPWR VGND VPWR VGND sky130_fd_sc_hd__decap_3
XFILLER_30_94 VPWR VGND VPWR VGND sky130_fd_sc_hd__decap_3
XFILLER_39_9 VPWR VGND VPWR VGND sky130_fd_sc_hd__decap_3
XPHY_EDGE_ROW_55_Left_161 VPWR VGND VPWR VGND sky130_fd_sc_hd__decap_3
XFILLER_29_190 VPWR VGND VPWR VGND sky130_fd_sc_hd__decap_3
XFILLER_36_127 VPWR VGND VPWR VGND sky130_fd_sc_hd__decap_3
XFILLER_17_352 VPWR VGND VPWR VGND sky130_fd_sc_hd__decap_3
XFILLER_51_119 VPWR VGND VPWR VGND sky130_fd_sc_hd__decap_3
XFILLER_17_385 VPWR VGND VPWR VGND sky130_fd_sc_hd__decap_3
XFILLER_44_171 VPWR VGND VPWR VGND sky130_fd_sc_hd__decap_3
XPHY_EDGE_ROW_64_Left_170 VPWR VGND VPWR VGND sky130_fd_sc_hd__decap_3
XFILLER_32_333 VPWR VGND VPWR VGND sky130_fd_sc_hd__decap_3
XFILLER_32_377 VPWR VGND VPWR VGND sky130_fd_sc_hd__decap_3
XFILLER_59_208 VPWR VGND VPWR VGND sky130_fd_sc_hd__decap_3
XFILLER_27_116 VPWR VGND VPWR VGND sky130_fd_sc_hd__decap_3
XFILLER_27_105 VPWR VGND VPWR VGND sky130_fd_sc_hd__decap_3
XFILLER_27_149 VPWR VGND VPWR VGND sky130_fd_sc_hd__decap_3
XFILLER_42_108 VPWR VGND VPWR VGND sky130_fd_sc_hd__decap_3
XFILLER_23_311 VPWR VGND VPWR VGND sky130_fd_sc_hd__decap_3
XFILLER_35_193 VPWR VGND VPWR VGND sky130_fd_sc_hd__decap_3
XFILLER_23_355 VPWR VGND VPWR VGND sky130_fd_sc_hd__decap_3
XFILLER_50_130 VPWR VGND VPWR VGND sky130_fd_sc_hd__decap_3
XFILLER_50_141 VPWR VGND VPWR VGND sky130_fd_sc_hd__decap_3
XFILLER_23_388 VPWR VGND VPWR VGND sky130_fd_sc_hd__decap_3
XFILLER_23_399 VPWR VGND VPWR VGND sky130_fd_sc_hd__decap_3
XFILLER_50_174 VPWR VGND VPWR VGND sky130_fd_sc_hd__decap_3
XFILLER_51_49 VPWR VGND VPWR VGND sky130_fd_sc_hd__decap_3
XFILLER_58_230 VPWR VGND VPWR VGND sky130_fd_sc_hd__decap_3
XFILLER_58_274 VPWR VGND VPWR VGND sky130_fd_sc_hd__decap_3
XFILLER_18_127 VPWR VGND VPWR VGND sky130_fd_sc_hd__decap_3
XFILLER_26_171 VPWR VGND VPWR VGND sky130_fd_sc_hd__decap_3
XFILLER_33_119 VPWR VGND VPWR VGND sky130_fd_sc_hd__decap_3
XFILLER_14_399 VPWR VGND VPWR VGND sky130_fd_sc_hd__decap_3
XFILLER_14_366 VPWR VGND VPWR VGND sky130_fd_sc_hd__decap_3
XFILLER_25_94 VPWR VGND VPWR VGND sky130_fd_sc_hd__decap_3
XFILLER_41_152 VPWR VGND VPWR VGND sky130_fd_sc_hd__decap_3
X_265_ VGND VPWR VPWR VGND clknet_2_3__leaf_clk_regs genblk1\[10\].fa_inst.s _010_
+ net40 _265_/a_1462_47# _265_/a_543_47# _265_/a_651_413# _265_/a_193_47# _265_/a_805_47#
+ _265_/a_448_47# _265_/a_639_47# _265_/a_1283_21# _265_/a_761_289# _265_/a_1108_47#
+ _265_/a_1217_47# _265_/a_1270_413# _265_/a_27_47# sky130_fd_sc_hd__dfrtp_1
XFILLER_41_196 VPWR VGND VPWR VGND sky130_fd_sc_hd__decap_3
XFILLER_41_93 VPWR VGND VPWR VGND sky130_fd_sc_hd__decap_3
X_196_ VPWR VGND VGND VPWR genblk1\[14\].fa_inst.b _106_ genblk1\[14\].fa_inst.a _196_/a_113_47#
+ sky130_fd_sc_hd__nand2_1
XFILLER_37_6 VPWR VGND VPWR VGND sky130_fd_sc_hd__decap_3
XFILLER_2_21 VPWR VGND VPWR VGND sky130_fd_sc_hd__decap_3
XFILLER_2_32 VPWR VGND VPWR VGND sky130_fd_sc_hd__decap_3
XFILLER_64_200 VPWR VGND VPWR VGND sky130_fd_sc_hd__decap_3
XFILLER_2_65 VPWR VGND VPWR VGND sky130_fd_sc_hd__decap_3
XFILLER_49_252 VPWR VGND VPWR VGND sky130_fd_sc_hd__decap_3
XFILLER_49_296 VPWR VGND VPWR VGND sky130_fd_sc_hd__decap_3
XFILLER_64_277 VPWR VGND VPWR VGND sky130_fd_sc_hd__decap_3
XFILLER_64_299 VPWR VGND VPWR VGND sky130_fd_sc_hd__decap_3
XFILLER_32_141 VPWR VGND VPWR VGND sky130_fd_sc_hd__decap_3
XFILLER_9_370 VPWR VGND VPWR VGND sky130_fd_sc_hd__decap_3
XFILLER_20_369 VPWR VGND VPWR VGND sky130_fd_sc_hd__decap_3
XFILLER_46_38 VPWR VGND VPWR VGND sky130_fd_sc_hd__decap_3
XFILLER_55_211 VPWR VGND VPWR VGND sky130_fd_sc_hd__decap_3
XFILLER_15_108 VPWR VGND VPWR VGND sky130_fd_sc_hd__decap_3
XFILLER_55_255 VPWR VGND VPWR VGND sky130_fd_sc_hd__decap_3
XFILLER_55_299 VPWR VGND VPWR VGND sky130_fd_sc_hd__decap_3
XFILLER_15_119 VPWR VGND VPWR VGND sky130_fd_sc_hd__decap_3
XFILLER_62_15 VPWR VGND VPWR VGND sky130_fd_sc_hd__decap_3
XFILLER_62_59 VPWR VGND VPWR VGND sky130_fd_sc_hd__decap_3
XFILLER_23_152 VPWR VGND VPWR VGND sky130_fd_sc_hd__decap_3
XFILLER_23_196 VPWR VGND VPWR VGND sky130_fd_sc_hd__decap_3
XFILLER_11_358 VPWR VGND VPWR VGND sky130_fd_sc_hd__decap_3
XFILLER_11_30 VPWR VGND VPWR VGND sky130_fd_sc_hd__decap_3
XFILLER_11_74 VPWR VGND VPWR VGND sky130_fd_sc_hd__decap_3
XFILLER_19_403 VPWR VGND VPWR VGND sky130_fd_sc_hd__decap_3
XFILLER_46_200 VPWR VGND VPWR VGND sky130_fd_sc_hd__decap_3
XFILLER_46_233 VPWR VGND VPWR VGND sky130_fd_sc_hd__decap_3
XFILLER_61_225 VPWR VGND VPWR VGND sky130_fd_sc_hd__decap_3
XFILLER_61_214 VPWR VGND VPWR VGND sky130_fd_sc_hd__decap_3
XFILLER_36_60 VPWR VGND VPWR VGND sky130_fd_sc_hd__decap_3
XFILLER_46_277 VPWR VGND VPWR VGND sky130_fd_sc_hd__decap_3
XFILLER_61_258 VPWR VGND VPWR VGND sky130_fd_sc_hd__decap_3
XFILLER_14_130 VPWR VGND VPWR VGND sky130_fd_sc_hd__decap_3
XFILLER_14_141 VPWR VGND VPWR VGND sky130_fd_sc_hd__decap_3
XFILLER_14_174 VPWR VGND VPWR VGND sky130_fd_sc_hd__decap_3
Xinput13 VGND VPWR net13 a[6] VPWR VGND input13/a_75_212# sky130_fd_sc_hd__clkbuf_1
XFILLER_52_81 VPWR VGND VPWR VGND sky130_fd_sc_hd__decap_3
Xinput35 VPWR VGND net35 delay_sel[1] VPWR VGND input35/a_27_47# sky130_fd_sc_hd__buf_2
Xinput24 VGND VPWR net24 b[1] VPWR VGND input24/a_27_47# sky130_fd_sc_hd__buf_1
X_248_ net59 _043_ VPWR VGND VPWR VGND sky130_fd_sc_hd__inv_2
XFILLER_6_340 VPWR VGND VPWR VGND sky130_fd_sc_hd__decap_3
X_179_ VGND VPWR _092_ genblk1\[10\].fa_inst.s _091_ VPWR VGND _179_/a_129_47# _179_/a_47_47#
+ _179_/a_285_47# _179_/a_377_297# sky130_fd_sc_hd__xnor2_1
XFILLER_6_384 VPWR VGND VPWR VGND sky130_fd_sc_hd__decap_3
XFILLER_35_3 VPWR VGND VPWR VGND sky130_fd_sc_hd__decap_3
XFILLER_37_211 VPWR VGND VPWR VGND sky130_fd_sc_hd__decap_3
XFILLER_37_255 VPWR VGND VPWR VGND sky130_fd_sc_hd__decap_3
XFILLER_37_299 VPWR VGND VPWR VGND sky130_fd_sc_hd__decap_3
XFILLER_52_203 VPWR VGND VPWR VGND sky130_fd_sc_hd__decap_3
XFILLER_52_236 VPWR VGND VPWR VGND sky130_fd_sc_hd__decap_3
XPHY_EDGE_ROW_9_2_Left_30 VPWR VGND VPWR VGND sky130_fd_sc_hd__decap_3
XFILLER_60_280 VPWR VGND VPWR VGND sky130_fd_sc_hd__decap_3
XFILLER_32_18 VPWR VGND VPWR VGND sky130_fd_sc_hd__decap_3
XFILLER_20_144 VPWR VGND VPWR VGND sky130_fd_sc_hd__decap_3
XFILLER_20_177 VPWR VGND VPWR VGND sky130_fd_sc_hd__decap_3
XFILLER_57_37 VPWR VGND VPWR VGND sky130_fd_sc_hd__decap_3
XFILLER_28_200 VPWR VGND VPWR VGND sky130_fd_sc_hd__decap_3
XFILLER_28_233 VPWR VGND VPWR VGND sky130_fd_sc_hd__decap_3
XFILLER_28_277 VPWR VGND VPWR VGND sky130_fd_sc_hd__decap_3
XFILLER_43_214 VPWR VGND VPWR VGND sky130_fd_sc_hd__decap_3
XFILLER_43_225 VPWR VGND VPWR VGND sky130_fd_sc_hd__decap_3
XFILLER_43_258 VPWR VGND VPWR VGND sky130_fd_sc_hd__decap_3
XFILLER_11_122 VPWR VGND VPWR VGND sky130_fd_sc_hd__decap_3
XFILLER_11_155 VPWR VGND VPWR VGND sky130_fd_sc_hd__decap_3
XPHY_EDGE_ROW_9_1_Right_8 VPWR VGND VPWR VGND sky130_fd_sc_hd__decap_3
XFILLER_7_137 VPWR VGND VPWR VGND sky130_fd_sc_hd__decap_3
XFILLER_3_343 VPWR VGND VPWR VGND sky130_fd_sc_hd__decap_3
XFILLER_3_376 VPWR VGND VPWR VGND sky130_fd_sc_hd__decap_3
XFILLER_21_9 VPWR VGND VPWR VGND sky130_fd_sc_hd__decap_3
XFILLER_47_81 VPWR VGND VPWR VGND sky130_fd_sc_hd__decap_3
XFILLER_34_203 VPWR VGND VPWR VGND sky130_fd_sc_hd__decap_3
XFILLER_34_236 VPWR VGND VPWR VGND sky130_fd_sc_hd__decap_3
XFILLER_42_280 VPWR VGND VPWR VGND sky130_fd_sc_hd__decap_3
XFILLER_8_97 VPWR VGND VPWR VGND sky130_fd_sc_hd__decap_3
XFILLER_57_317 VPWR VGND VPWR VGND sky130_fd_sc_hd__decap_3
XFILLER_25_214 VPWR VGND VPWR VGND sky130_fd_sc_hd__decap_3
XFILLER_25_225 VPWR VGND VPWR VGND sky130_fd_sc_hd__decap_3
XFILLER_25_258 VPWR VGND VPWR VGND sky130_fd_sc_hd__decap_3
XFILLER_40_206 VPWR VGND VPWR VGND sky130_fd_sc_hd__decap_3
XFILLER_40_239 VPWR VGND VPWR VGND sky130_fd_sc_hd__decap_3
XFILLER_4_118 VPWR VGND VPWR VGND sky130_fd_sc_hd__decap_3
XFILLER_0_346 VPWR VGND VPWR VGND sky130_fd_sc_hd__decap_3
XFILLER_0_357 VPWR VGND VPWR VGND sky130_fd_sc_hd__decap_3
XFILLER_48_339 VPWR VGND VPWR VGND sky130_fd_sc_hd__decap_3
XFILLER_56_383 VPWR VGND VPWR VGND sky130_fd_sc_hd__decap_3
XFILLER_17_73 VPWR VGND VPWR VGND sky130_fd_sc_hd__decap_3
XFILLER_31_217 VPWR VGND VPWR VGND sky130_fd_sc_hd__decap_3
XFILLER_24_280 VPWR VGND VPWR VGND sky130_fd_sc_hd__decap_3
XFILLER_31_228 VPWR VGND VPWR VGND sky130_fd_sc_hd__decap_3
XFILLER_8_402 VPWR VGND VPWR VGND sky130_fd_sc_hd__decap_3
XFILLER_33_83 VPWR VGND VPWR VGND sky130_fd_sc_hd__decap_3
XFILLER_3_140 VPWR VGND VPWR VGND sky130_fd_sc_hd__decap_3
XFILLER_39_317 VPWR VGND VPWR VGND sky130_fd_sc_hd__decap_3
XFILLER_58_91 VPWR VGND VPWR VGND sky130_fd_sc_hd__decap_3
XFILLER_54_309 VPWR VGND VPWR VGND sky130_fd_sc_hd__decap_3
XFILLER_47_361 VPWR VGND VPWR VGND sky130_fd_sc_hd__decap_3
XPHY_EDGE_ROW_12_1_Right_11 VPWR VGND VPWR VGND sky130_fd_sc_hd__decap_3
XFILLER_62_342 VPWR VGND VPWR VGND sky130_fd_sc_hd__decap_3
XFILLER_22_206 VPWR VGND VPWR VGND sky130_fd_sc_hd__decap_3
XFILLER_62_386 VPWR VGND VPWR VGND sky130_fd_sc_hd__decap_3
XFILLER_30_283 VPWR VGND VPWR VGND sky130_fd_sc_hd__decap_3
XFILLER_57_125 VPWR VGND VPWR VGND sky130_fd_sc_hd__decap_3
XFILLER_57_158 VPWR VGND VPWR VGND sky130_fd_sc_hd__decap_3
XFILLER_57_169 VPWR VGND VPWR VGND sky130_fd_sc_hd__decap_3
XFILLER_53_320 VPWR VGND VPWR VGND sky130_fd_sc_hd__decap_3
XFILLER_38_383 VPWR VGND VPWR VGND sky130_fd_sc_hd__decap_3
XFILLER_54_38 VPWR VGND VPWR VGND sky130_fd_sc_hd__decap_3
XFILLER_53_364 VPWR VGND VPWR VGND sky130_fd_sc_hd__decap_3
XFILLER_21_272 VPWR VGND VPWR VGND sky130_fd_sc_hd__decap_3
XFILLER_0_165 VPWR VGND VPWR VGND sky130_fd_sc_hd__decap_3
XFILLER_36_309 VPWR VGND VPWR VGND sky130_fd_sc_hd__decap_3
XFILLER_48_147 VPWR VGND VPWR VGND sky130_fd_sc_hd__decap_3
XFILLER_63_128 VPWR VGND VPWR VGND sky130_fd_sc_hd__decap_3
XFILLER_29_361 VPWR VGND VPWR VGND sky130_fd_sc_hd__decap_3
XFILLER_56_180 VPWR VGND VPWR VGND sky130_fd_sc_hd__decap_3
XFILLER_44_342 VPWR VGND VPWR VGND sky130_fd_sc_hd__decap_3
XFILLER_44_386 VPWR VGND VPWR VGND sky130_fd_sc_hd__decap_3
XFILLER_39_125 VPWR VGND VPWR VGND sky130_fd_sc_hd__decap_3
XFILLER_39_158 VPWR VGND VPWR VGND sky130_fd_sc_hd__decap_3
XFILLER_39_169 VPWR VGND VPWR VGND sky130_fd_sc_hd__decap_3
XFILLER_35_320 VPWR VGND VPWR VGND sky130_fd_sc_hd__decap_3
XFILLER_62_150 VPWR VGND VPWR VGND sky130_fd_sc_hd__decap_3
XFILLER_35_364 VPWR VGND VPWR VGND sky130_fd_sc_hd__decap_3
XFILLER_62_183 VPWR VGND VPWR VGND sky130_fd_sc_hd__decap_3
XFILLER_50_312 VPWR VGND VPWR VGND sky130_fd_sc_hd__decap_3
XFILLER_50_301 VPWR VGND VPWR VGND sky130_fd_sc_hd__decap_3
XFILLER_50_345 VPWR VGND VPWR VGND sky130_fd_sc_hd__decap_3
XFILLER_50_389 VPWR VGND VPWR VGND sky130_fd_sc_hd__decap_3
XFILLER_40_18 VPWR VGND VPWR VGND sky130_fd_sc_hd__decap_3
XFILLER_40_29 VPWR VGND VPWR VGND sky130_fd_sc_hd__decap_3
XFILLER_49_38 VPWR VGND VPWR VGND sky130_fd_sc_hd__decap_3
XFILLER_58_401 VPWR VGND VPWR VGND sky130_fd_sc_hd__decap_3
XFILLER_45_106 VPWR VGND VPWR VGND sky130_fd_sc_hd__decap_3
XFILLER_38_180 VPWR VGND VPWR VGND sky130_fd_sc_hd__decap_3
XFILLER_45_128 VPWR VGND VPWR VGND sky130_fd_sc_hd__decap_3
XFILLER_60_109 VPWR VGND VPWR VGND sky130_fd_sc_hd__decap_3
XFILLER_26_342 VPWR VGND VPWR VGND sky130_fd_sc_hd__decap_3
XFILLER_41_323 VPWR VGND VPWR VGND sky130_fd_sc_hd__decap_3
XFILLER_26_386 VPWR VGND VPWR VGND sky130_fd_sc_hd__decap_3
XFILLER_53_172 VPWR VGND VPWR VGND sky130_fd_sc_hd__decap_3
XFILLER_53_161 VPWR VGND VPWR VGND sky130_fd_sc_hd__decap_3
XFILLER_41_367 VPWR VGND VPWR VGND sky130_fd_sc_hd__decap_3
XFILLER_14_41 VPWR VGND VPWR VGND sky130_fd_sc_hd__decap_3
X_281_ VGND VPWR VPWR VGND clknet_2_2__leaf_clk_regs net16 _026_ genblk1\[9\].fa_inst.a
+ _281_/a_1462_47# _281_/a_543_47# _281_/a_651_413# _281_/a_193_47# _281_/a_805_47#
+ _281_/a_448_47# _281_/a_639_47# _281_/a_1283_21# _281_/a_761_289# _281_/a_1108_47#
+ _281_/a_1217_47# _281_/a_1270_413# _281_/a_27_47# sky130_fd_sc_hd__dfrtp_1
XFILLER_14_85 VPWR VGND VPWR VGND sky130_fd_sc_hd__decap_3
XFILLER_14_74 VPWR VGND VPWR VGND sky130_fd_sc_hd__decap_3
XFILLER_30_73 VPWR VGND VPWR VGND sky130_fd_sc_hd__decap_3
XFILLER_39_60 VPWR VGND VPWR VGND sky130_fd_sc_hd__decap_3
XFILLER_39_93 VPWR VGND VPWR VGND sky130_fd_sc_hd__decap_3
XFILLER_17_331 VPWR VGND VPWR VGND sky130_fd_sc_hd__decap_3
XFILLER_17_364 VPWR VGND VPWR VGND sky130_fd_sc_hd__decap_3
XFILLER_55_81 VPWR VGND VPWR VGND sky130_fd_sc_hd__decap_3
XFILLER_44_150 VPWR VGND VPWR VGND sky130_fd_sc_hd__decap_3
XFILLER_32_301 VPWR VGND VPWR VGND sky130_fd_sc_hd__decap_3
XFILLER_32_312 VPWR VGND VPWR VGND sky130_fd_sc_hd__decap_3
XFILLER_17_397 VPWR VGND VPWR VGND sky130_fd_sc_hd__decap_3
XFILLER_44_183 VPWR VGND VPWR VGND sky130_fd_sc_hd__decap_3
XFILLER_32_345 VPWR VGND VPWR VGND sky130_fd_sc_hd__decap_3
XFILLER_32_389 VPWR VGND VPWR VGND sky130_fd_sc_hd__decap_3
XFILLER_27_128 VPWR VGND VPWR VGND sky130_fd_sc_hd__decap_3
XFILLER_35_172 VPWR VGND VPWR VGND sky130_fd_sc_hd__decap_3
XFILLER_35_161 VPWR VGND VPWR VGND sky130_fd_sc_hd__decap_3
XFILLER_23_323 VPWR VGND VPWR VGND sky130_fd_sc_hd__decap_3
XFILLER_23_367 VPWR VGND VPWR VGND sky130_fd_sc_hd__decap_3
XFILLER_50_153 VPWR VGND VPWR VGND sky130_fd_sc_hd__decap_3
XFILLER_50_186 VPWR VGND VPWR VGND sky130_fd_sc_hd__decap_3
XFILLER_50_197 VPWR VGND VPWR VGND sky130_fd_sc_hd__decap_3
XFILLER_58_242 VPWR VGND VPWR VGND sky130_fd_sc_hd__decap_3
XFILLER_58_253 VPWR VGND VPWR VGND sky130_fd_sc_hd__decap_3
XFILLER_46_404 VPWR VGND VPWR VGND sky130_fd_sc_hd__decap_3
XFILLER_18_106 VPWR VGND VPWR VGND sky130_fd_sc_hd__decap_3
XFILLER_58_286 VPWR VGND VPWR VGND sky130_fd_sc_hd__decap_3
XFILLER_26_150 VPWR VGND VPWR VGND sky130_fd_sc_hd__decap_3
XFILLER_14_334 VPWR VGND VPWR VGND sky130_fd_sc_hd__decap_3
XFILLER_25_51 VPWR VGND VPWR VGND sky130_fd_sc_hd__decap_3
XFILLER_26_183 VPWR VGND VPWR VGND sky130_fd_sc_hd__decap_3
XFILLER_41_131 VPWR VGND VPWR VGND sky130_fd_sc_hd__decap_3
XFILLER_14_378 VPWR VGND VPWR VGND sky130_fd_sc_hd__decap_3
XFILLER_25_73 VPWR VGND VPWR VGND sky130_fd_sc_hd__decap_3
XFILLER_41_175 VPWR VGND VPWR VGND sky130_fd_sc_hd__decap_3
XFILLER_41_164 VPWR VGND VPWR VGND sky130_fd_sc_hd__decap_3
X_264_ VGND VPWR VPWR VGND clknet_2_2__leaf_clk_regs genblk1\[9\].fa_inst.s _009_
+ net54 _264_/a_1462_47# _264_/a_543_47# _264_/a_651_413# _264_/a_193_47# _264_/a_805_47#
+ _264_/a_448_47# _264_/a_639_47# _264_/a_1283_21# _264_/a_761_289# _264_/a_1108_47#
+ _264_/a_1217_47# _264_/a_1270_413# _264_/a_27_47# sky130_fd_sc_hd__dfrtp_1
X_195_ VPWR VGND VGND VPWR _105_ genblk1\[14\].fa_inst.b genblk1\[14\].fa_inst.a _195_/a_150_297#
+ _195_/a_68_297# sky130_fd_sc_hd__or2_1
XFILLER_51_9 VPWR VGND VPWR VGND sky130_fd_sc_hd__decap_3
XFILLER_2_44 VPWR VGND VPWR VGND sky130_fd_sc_hd__decap_3
XFILLER_49_220 VPWR VGND VPWR VGND sky130_fd_sc_hd__decap_3
XFILLER_49_231 VPWR VGND VPWR VGND sky130_fd_sc_hd__decap_3
XFILLER_2_77 VPWR VGND VPWR VGND sky130_fd_sc_hd__decap_3
XFILLER_49_264 VPWR VGND VPWR VGND sky130_fd_sc_hd__decap_3
XFILLER_64_234 VPWR VGND VPWR VGND sky130_fd_sc_hd__decap_3
XFILLER_64_212 VPWR VGND VPWR VGND sky130_fd_sc_hd__decap_3
XFILLER_2_88 VPWR VGND VPWR VGND sky130_fd_sc_hd__decap_3
XFILLER_64_256 VPWR VGND VPWR VGND sky130_fd_sc_hd__decap_3
XFILLER_17_172 VPWR VGND VPWR VGND sky130_fd_sc_hd__decap_3
XFILLER_17_161 VPWR VGND VPWR VGND sky130_fd_sc_hd__decap_3
XFILLER_32_120 VPWR VGND VPWR VGND sky130_fd_sc_hd__decap_3
XFILLER_32_175 VPWR VGND VPWR VGND sky130_fd_sc_hd__decap_3
XFILLER_32_197 VPWR VGND VPWR VGND sky130_fd_sc_hd__decap_3
XFILLER_20_337 VPWR VGND VPWR VGND sky130_fd_sc_hd__decap_3
XFILLER_9_382 VPWR VGND VPWR VGND sky130_fd_sc_hd__decap_3
XFILLER_28_404 VPWR VGND VPWR VGND sky130_fd_sc_hd__decap_3
XFILLER_55_234 VPWR VGND VPWR VGND sky130_fd_sc_hd__decap_3
XFILLER_55_267 VPWR VGND VPWR VGND sky130_fd_sc_hd__decap_3
XFILLER_23_131 VPWR VGND VPWR VGND sky130_fd_sc_hd__decap_3
XFILLER_62_38 VPWR VGND VPWR VGND sky130_fd_sc_hd__decap_3
XFILLER_23_164 VPWR VGND VPWR VGND sky130_fd_sc_hd__decap_3
XFILLER_11_337 VPWR VGND VPWR VGND sky130_fd_sc_hd__decap_3
XFILLER_23_175 VPWR VGND VPWR VGND sky130_fd_sc_hd__decap_3
XFILLER_11_42 VPWR VGND VPWR VGND sky130_fd_sc_hd__decap_3
XFILLER_11_86 VPWR VGND VPWR VGND sky130_fd_sc_hd__decap_3
XFILLER_46_212 VPWR VGND VPWR VGND sky130_fd_sc_hd__decap_3
XFILLER_46_256 VPWR VGND VPWR VGND sky130_fd_sc_hd__decap_3
XFILLER_46_245 VPWR VGND VPWR VGND sky130_fd_sc_hd__decap_3
XFILLER_46_289 VPWR VGND VPWR VGND sky130_fd_sc_hd__decap_3
XFILLER_61_237 VPWR VGND VPWR VGND sky130_fd_sc_hd__decap_3
XFILLER_14_153 VPWR VGND VPWR VGND sky130_fd_sc_hd__decap_3
Xinput36 VGND VPWR delay_sel[2] net36 VPWR VGND input36/a_27_47# sky130_fd_sc_hd__clkbuf_2
Xinput14 VGND VPWR net14 a[7] VPWR VGND input14/a_75_212# sky130_fd_sc_hd__clkbuf_1
Xinput25 VGND VPWR net25 b[2] VPWR VGND input25/a_75_212# sky130_fd_sc_hd__clkbuf_1
X_247_ net59 _042_ VPWR VGND VPWR VGND sky130_fd_sc_hd__inv_2
XFILLER_10_381 VPWR VGND VPWR VGND sky130_fd_sc_hd__decap_3
X_178_ VGND VPWR VGND VPWR _092_ _088_ _085_ _086_ _178_/a_215_297# _178_/a_27_413#
+ _178_/a_298_297# _178_/a_382_47# sky130_fd_sc_hd__a21bo_1
XFILLER_6_396 VPWR VGND VPWR VGND sky130_fd_sc_hd__decap_3
XFILLER_6_363 VPWR VGND VPWR VGND sky130_fd_sc_hd__decap_3
XPHY_EDGE_ROW_1_2_Left_22 VPWR VGND VPWR VGND sky130_fd_sc_hd__decap_3
XFILLER_37_234 VPWR VGND VPWR VGND sky130_fd_sc_hd__decap_3
XFILLER_37_267 VPWR VGND VPWR VGND sky130_fd_sc_hd__decap_3
XFILLER_52_215 VPWR VGND VPWR VGND sky130_fd_sc_hd__decap_3
XFILLER_52_248 VPWR VGND VPWR VGND sky130_fd_sc_hd__decap_3
XFILLER_52_259 VPWR VGND VPWR VGND sky130_fd_sc_hd__decap_3
XFILLER_60_292 VPWR VGND VPWR VGND sky130_fd_sc_hd__decap_3
XFILLER_20_123 VPWR VGND VPWR VGND sky130_fd_sc_hd__decap_3
XFILLER_20_156 VPWR VGND VPWR VGND sky130_fd_sc_hd__decap_3
XFILLER_57_49 VPWR VGND VPWR VGND sky130_fd_sc_hd__decap_3
XFILLER_28_212 VPWR VGND VPWR VGND sky130_fd_sc_hd__decap_3
XFILLER_28_256 VPWR VGND VPWR VGND sky130_fd_sc_hd__decap_3
XFILLER_28_245 VPWR VGND VPWR VGND sky130_fd_sc_hd__decap_3
XFILLER_28_289 VPWR VGND VPWR VGND sky130_fd_sc_hd__decap_3
XFILLER_43_237 VPWR VGND VPWR VGND sky130_fd_sc_hd__decap_3
XFILLER_11_101 VPWR VGND VPWR VGND sky130_fd_sc_hd__decap_3
XFILLER_51_270 VPWR VGND VPWR VGND sky130_fd_sc_hd__decap_3
XFILLER_51_281 VPWR VGND VPWR VGND sky130_fd_sc_hd__decap_3
XFILLER_11_134 VPWR VGND VPWR VGND sky130_fd_sc_hd__decap_3
XFILLER_7_116 VPWR VGND VPWR VGND sky130_fd_sc_hd__decap_3
XFILLER_22_41 VPWR VGND VPWR VGND sky130_fd_sc_hd__decap_3
XFILLER_7_149 VPWR VGND VPWR VGND sky130_fd_sc_hd__decap_3
XFILLER_22_85 VPWR VGND VPWR VGND sky130_fd_sc_hd__decap_3
XFILLER_3_388 VPWR VGND VPWR VGND sky130_fd_sc_hd__decap_3
XFILLER_3_355 VPWR VGND VPWR VGND sky130_fd_sc_hd__decap_3
XFILLER_59_370 VPWR VGND VPWR VGND sky130_fd_sc_hd__decap_3
XFILLER_14_9 VPWR VGND VPWR VGND sky130_fd_sc_hd__decap_3
XFILLER_47_60 VPWR VGND VPWR VGND sky130_fd_sc_hd__decap_3
XFILLER_34_215 VPWR VGND VPWR VGND sky130_fd_sc_hd__decap_3
XFILLER_47_93 VPWR VGND VPWR VGND sky130_fd_sc_hd__decap_3
XFILLER_34_248 VPWR VGND VPWR VGND sky130_fd_sc_hd__decap_3
XFILLER_34_259 VPWR VGND VPWR VGND sky130_fd_sc_hd__decap_3
XFILLER_63_81 VPWR VGND VPWR VGND sky130_fd_sc_hd__decap_3
XFILLER_42_292 VPWR VGND VPWR VGND sky130_fd_sc_hd__decap_3
XFILLER_8_32 VPWR VGND VPWR VGND sky130_fd_sc_hd__decap_3
XFILLER_8_21 VPWR VGND VPWR VGND sky130_fd_sc_hd__decap_3
XFILLER_6_171 VPWR VGND VPWR VGND sky130_fd_sc_hd__decap_3
XFILLER_57_329 VPWR VGND VPWR VGND sky130_fd_sc_hd__decap_3
XFILLER_25_237 VPWR VGND VPWR VGND sky130_fd_sc_hd__decap_3
XFILLER_33_270 VPWR VGND VPWR VGND sky130_fd_sc_hd__decap_3
XFILLER_33_281 VPWR VGND VPWR VGND sky130_fd_sc_hd__decap_3
XFILLER_40_218 VPWR VGND VPWR VGND sky130_fd_sc_hd__decap_3
XFILLER_0_369 VPWR VGND VPWR VGND sky130_fd_sc_hd__decap_3
XFILLER_48_318 VPWR VGND VPWR VGND sky130_fd_sc_hd__decap_3
XFILLER_56_351 VPWR VGND VPWR VGND sky130_fd_sc_hd__decap_3
XFILLER_17_41 VPWR VGND VPWR VGND sky130_fd_sc_hd__decap_3
XFILLER_56_395 VPWR VGND VPWR VGND sky130_fd_sc_hd__decap_3
XFILLER_17_85 VPWR VGND VPWR VGND sky130_fd_sc_hd__decap_3
XFILLER_24_292 VPWR VGND VPWR VGND sky130_fd_sc_hd__decap_3
XFILLER_33_95 VPWR VGND VPWR VGND sky130_fd_sc_hd__decap_3
XFILLER_3_152 VPWR VGND VPWR VGND sky130_fd_sc_hd__decap_3
XFILLER_58_81 VPWR VGND VPWR VGND sky130_fd_sc_hd__decap_3
XFILLER_39_329 VPWR VGND VPWR VGND sky130_fd_sc_hd__decap_3
XFILLER_47_340 VPWR VGND VPWR VGND sky130_fd_sc_hd__decap_3
XFILLER_47_373 VPWR VGND VPWR VGND sky130_fd_sc_hd__decap_3
XFILLER_62_321 VPWR VGND VPWR VGND sky130_fd_sc_hd__decap_3
XFILLER_62_365 VPWR VGND VPWR VGND sky130_fd_sc_hd__decap_3
XFILLER_62_354 VPWR VGND VPWR VGND sky130_fd_sc_hd__decap_3
XFILLER_62_398 VPWR VGND VPWR VGND sky130_fd_sc_hd__decap_3
XFILLER_30_262 VPWR VGND VPWR VGND sky130_fd_sc_hd__decap_3
XFILLER_30_295 VPWR VGND VPWR VGND sky130_fd_sc_hd__decap_3
XFILLER_38_18 VPWR VGND VPWR VGND sky130_fd_sc_hd__decap_3
XFILLER_57_104 VPWR VGND VPWR VGND sky130_fd_sc_hd__decap_3
XFILLER_57_137 VPWR VGND VPWR VGND sky130_fd_sc_hd__decap_3
XFILLER_38_351 VPWR VGND VPWR VGND sky130_fd_sc_hd__decap_3
XFILLER_38_395 VPWR VGND VPWR VGND sky130_fd_sc_hd__decap_3
XFILLER_53_332 VPWR VGND VPWR VGND sky130_fd_sc_hd__decap_3
XFILLER_53_343 VPWR VGND VPWR VGND sky130_fd_sc_hd__decap_3
XFILLER_53_376 VPWR VGND VPWR VGND sky130_fd_sc_hd__decap_3
XFILLER_21_262 VPWR VGND VPWR VGND sky130_fd_sc_hd__decap_3
XFILLER_21_284 VPWR VGND VPWR VGND sky130_fd_sc_hd__decap_3
XFILLER_0_100 VPWR VGND VPWR VGND sky130_fd_sc_hd__decap_3
XFILLER_0_144 VPWR VGND VPWR VGND sky130_fd_sc_hd__decap_3
XFILLER_0_122 VPWR VGND VPWR VGND sky130_fd_sc_hd__decap_3
XFILLER_48_126 VPWR VGND VPWR VGND sky130_fd_sc_hd__decap_3
XPHY_EDGE_ROW_26_Right_47 VPWR VGND VPWR VGND sky130_fd_sc_hd__decap_3
XFILLER_48_159 VPWR VGND VPWR VGND sky130_fd_sc_hd__decap_3
XFILLER_28_51 VPWR VGND VPWR VGND sky130_fd_sc_hd__decap_3
XFILLER_29_340 VPWR VGND VPWR VGND sky130_fd_sc_hd__decap_3
XFILLER_29_373 VPWR VGND VPWR VGND sky130_fd_sc_hd__decap_3
XFILLER_44_321 VPWR VGND VPWR VGND sky130_fd_sc_hd__decap_3
XFILLER_56_192 VPWR VGND VPWR VGND sky130_fd_sc_hd__decap_3
XFILLER_44_365 VPWR VGND VPWR VGND sky130_fd_sc_hd__decap_3
XFILLER_44_354 VPWR VGND VPWR VGND sky130_fd_sc_hd__decap_3
XFILLER_44_398 VPWR VGND VPWR VGND sky130_fd_sc_hd__decap_3
XFILLER_44_50 VPWR VGND VPWR VGND sky130_fd_sc_hd__decap_3
XPHY_EDGE_ROW_35_Right_56 VPWR VGND VPWR VGND sky130_fd_sc_hd__decap_3
XFILLER_60_71 VPWR VGND VPWR VGND sky130_fd_sc_hd__decap_3
XFILLER_5_33 VPWR VGND VPWR VGND sky130_fd_sc_hd__decap_3
XFILLER_5_88 VPWR VGND VPWR VGND sky130_fd_sc_hd__decap_3
XPHY_EDGE_ROW_44_Right_65 VPWR VGND VPWR VGND sky130_fd_sc_hd__decap_3
XFILLER_39_137 VPWR VGND VPWR VGND sky130_fd_sc_hd__decap_3
XFILLER_54_118 VPWR VGND VPWR VGND sky130_fd_sc_hd__decap_3
XFILLER_35_332 VPWR VGND VPWR VGND sky130_fd_sc_hd__decap_3
XFILLER_47_181 VPWR VGND VPWR VGND sky130_fd_sc_hd__decap_3
XFILLER_35_343 VPWR VGND VPWR VGND sky130_fd_sc_hd__decap_3
XFILLER_62_162 VPWR VGND VPWR VGND sky130_fd_sc_hd__decap_3
XFILLER_50_324 VPWR VGND VPWR VGND sky130_fd_sc_hd__decap_3
XFILLER_35_376 VPWR VGND VPWR VGND sky130_fd_sc_hd__decap_3
XPHY_EDGE_ROW_53_Right_74 VPWR VGND VPWR VGND sky130_fd_sc_hd__decap_3
XFILLER_50_357 VPWR VGND VPWR VGND sky130_fd_sc_hd__decap_3
XFILLER_50_368 VPWR VGND VPWR VGND sky130_fd_sc_hd__decap_3
XPHY_EDGE_ROW_62_Right_83 VPWR VGND VPWR VGND sky130_fd_sc_hd__decap_3
XFILLER_26_321 VPWR VGND VPWR VGND sky130_fd_sc_hd__decap_3
XFILLER_26_354 VPWR VGND VPWR VGND sky130_fd_sc_hd__decap_3
XFILLER_26_365 VPWR VGND VPWR VGND sky130_fd_sc_hd__decap_3
XFILLER_38_192 VPWR VGND VPWR VGND sky130_fd_sc_hd__decap_3
XFILLER_53_140 VPWR VGND VPWR VGND sky130_fd_sc_hd__decap_3
XFILLER_41_302 VPWR VGND VPWR VGND sky130_fd_sc_hd__decap_3
XFILLER_26_398 VPWR VGND VPWR VGND sky130_fd_sc_hd__decap_3
XFILLER_53_184 VPWR VGND VPWR VGND sky130_fd_sc_hd__decap_3
XFILLER_41_346 VPWR VGND VPWR VGND sky130_fd_sc_hd__decap_3
X_280_ VGND VPWR VPWR VGND clknet_2_1__leaf_clk_regs net15 _025_ genblk1\[8\].fa_inst.a
+ _280_/a_1462_47# _280_/a_543_47# _280_/a_651_413# _280_/a_193_47# _280_/a_805_47#
+ _280_/a_448_47# _280_/a_639_47# _280_/a_1283_21# _280_/a_761_289# _280_/a_1108_47#
+ _280_/a_1217_47# _280_/a_1270_413# _280_/a_27_47# sky130_fd_sc_hd__dfrtp_1
XFILLER_41_379 VPWR VGND VPWR VGND sky130_fd_sc_hd__decap_3
XFILLER_14_97 VPWR VGND VPWR VGND sky130_fd_sc_hd__decap_3
XFILLER_30_41 VPWR VGND VPWR VGND sky130_fd_sc_hd__decap_3
XFILLER_30_85 VPWR VGND VPWR VGND sky130_fd_sc_hd__decap_3
XFILLER_39_50 VPWR VGND VPWR VGND sky130_fd_sc_hd__decap_3
XFILLER_29_181 VPWR VGND VPWR VGND sky130_fd_sc_hd__decap_3
XFILLER_36_118 VPWR VGND VPWR VGND sky130_fd_sc_hd__decap_3
XFILLER_17_343 VPWR VGND VPWR VGND sky130_fd_sc_hd__decap_3
XFILLER_17_376 VPWR VGND VPWR VGND sky130_fd_sc_hd__decap_3
XFILLER_55_93 VPWR VGND VPWR VGND sky130_fd_sc_hd__decap_3
XFILLER_44_162 VPWR VGND VPWR VGND sky130_fd_sc_hd__decap_3
XFILLER_32_324 VPWR VGND VPWR VGND sky130_fd_sc_hd__decap_3
XFILLER_32_357 VPWR VGND VPWR VGND sky130_fd_sc_hd__decap_3
XFILLER_32_368 VPWR VGND VPWR VGND sky130_fd_sc_hd__decap_3
XFILLER_35_140 VPWR VGND VPWR VGND sky130_fd_sc_hd__decap_3
XFILLER_23_302 VPWR VGND VPWR VGND sky130_fd_sc_hd__decap_3
XFILLER_35_184 VPWR VGND VPWR VGND sky130_fd_sc_hd__decap_3
XFILLER_23_346 VPWR VGND VPWR VGND sky130_fd_sc_hd__decap_3
XFILLER_50_121 VPWR VGND VPWR VGND sky130_fd_sc_hd__decap_3
XFILLER_23_379 VPWR VGND VPWR VGND sky130_fd_sc_hd__decap_3
XFILLER_50_165 VPWR VGND VPWR VGND sky130_fd_sc_hd__decap_3
Xclkbuf_0_clk_regs VGND VPWR VGND VPWR clk_regs clknet_0_clk_regs clkbuf_0_clk_regs/a_110_47#
+ sky130_fd_sc_hd__clkbuf_16
XFILLER_58_221 VPWR VGND VPWR VGND sky130_fd_sc_hd__decap_3
XFILLER_58_265 VPWR VGND VPWR VGND sky130_fd_sc_hd__decap_3
XFILLER_58_298 VPWR VGND VPWR VGND sky130_fd_sc_hd__decap_3
XFILLER_18_118 VPWR VGND VPWR VGND sky130_fd_sc_hd__decap_3
XFILLER_26_162 VPWR VGND VPWR VGND sky130_fd_sc_hd__decap_3
XFILLER_14_346 VPWR VGND VPWR VGND sky130_fd_sc_hd__decap_3
XFILLER_14_357 VPWR VGND VPWR VGND sky130_fd_sc_hd__decap_3
XFILLER_25_85 VPWR VGND VPWR VGND sky130_fd_sc_hd__decap_3
XFILLER_41_143 VPWR VGND VPWR VGND sky130_fd_sc_hd__decap_3
X_263_ VGND VPWR VPWR VGND clknet_2_2__leaf_clk_regs genblk1\[8\].fa_inst.s _008_
+ net53 _263_/a_1462_47# _263_/a_543_47# _263_/a_651_413# _263_/a_193_47# _263_/a_805_47#
+ _263_/a_448_47# _263_/a_639_47# _263_/a_1283_21# _263_/a_761_289# _263_/a_1108_47#
+ _263_/a_1217_47# _263_/a_1270_413# _263_/a_27_47# sky130_fd_sc_hd__dfrtp_1
XFILLER_41_187 VPWR VGND VPWR VGND sky130_fd_sc_hd__decap_3
XFILLER_41_84 VPWR VGND VPWR VGND sky130_fd_sc_hd__decap_3
X_194_ VGND VPWR _104_ genblk1\[13\].fa_inst.s _103_ VPWR VGND _194_/a_129_47# _194_/a_47_47#
+ _194_/a_285_47# _194_/a_377_297# sky130_fd_sc_hd__xnor2_1
XFILLER_44_9 VPWR VGND VPWR VGND sky130_fd_sc_hd__decap_3
XFILLER_2_12 VPWR VGND VPWR VGND sky130_fd_sc_hd__decap_3
XFILLER_2_56 VPWR VGND VPWR VGND sky130_fd_sc_hd__decap_3
XFILLER_49_243 VPWR VGND VPWR VGND sky130_fd_sc_hd__decap_3
XFILLER_49_276 VPWR VGND VPWR VGND sky130_fd_sc_hd__decap_3
XFILLER_49_287 VPWR VGND VPWR VGND sky130_fd_sc_hd__decap_3
XFILLER_64_268 VPWR VGND VPWR VGND sky130_fd_sc_hd__decap_3
XFILLER_64_246 VPWR VGND VPWR VGND sky130_fd_sc_hd__decap_3
XFILLER_17_140 VPWR VGND VPWR VGND sky130_fd_sc_hd__decap_3
XFILLER_32_132 VPWR VGND VPWR VGND sky130_fd_sc_hd__decap_3
XFILLER_32_187 VPWR VGND VPWR VGND sky130_fd_sc_hd__decap_3
XFILLER_9_361 VPWR VGND VPWR VGND sky130_fd_sc_hd__decap_3
XFILLER_20_349 VPWR VGND VPWR VGND sky130_fd_sc_hd__decap_3
XFILLER_9_394 VPWR VGND VPWR VGND sky130_fd_sc_hd__decap_3
XFILLER_46_18 VPWR VGND VPWR VGND sky130_fd_sc_hd__decap_3
XFILLER_46_29 VPWR VGND VPWR VGND sky130_fd_sc_hd__decap_3
XFILLER_55_202 VPWR VGND VPWR VGND sky130_fd_sc_hd__decap_3
XFILLER_55_246 VPWR VGND VPWR VGND sky130_fd_sc_hd__decap_3
XFILLER_63_290 VPWR VGND VPWR VGND sky130_fd_sc_hd__decap_3
XFILLER_23_143 VPWR VGND VPWR VGND sky130_fd_sc_hd__decap_3
XFILLER_23_187 VPWR VGND VPWR VGND sky130_fd_sc_hd__decap_3
XFILLER_11_349 VPWR VGND VPWR VGND sky130_fd_sc_hd__decap_3
XFILLER_11_21 VPWR VGND VPWR VGND sky130_fd_sc_hd__decap_3
XFILLER_11_98 VPWR VGND VPWR VGND sky130_fd_sc_hd__decap_3
XFILLER_46_224 VPWR VGND VPWR VGND sky130_fd_sc_hd__decap_3
XFILLER_61_205 VPWR VGND VPWR VGND sky130_fd_sc_hd__decap_3
XFILLER_36_51 VPWR VGND VPWR VGND sky130_fd_sc_hd__decap_3
XFILLER_46_268 VPWR VGND VPWR VGND sky130_fd_sc_hd__decap_3
XFILLER_61_249 VPWR VGND VPWR VGND sky130_fd_sc_hd__decap_3
XFILLER_14_121 VPWR VGND VPWR VGND sky130_fd_sc_hd__decap_3
XFILLER_14_165 VPWR VGND VPWR VGND sky130_fd_sc_hd__decap_3
Xinput37 VGND VPWR net37 rst VPWR VGND input37/a_75_212# sky130_fd_sc_hd__clkbuf_1
XFILLER_10_360 VPWR VGND VPWR VGND sky130_fd_sc_hd__decap_3
Xinput15 VGND VPWR net15 a[8] VPWR VGND input15/a_75_212# sky130_fd_sc_hd__clkbuf_1
Xinput26 VGND VPWR net26 b[3] VPWR VGND input26/a_75_212# sky130_fd_sc_hd__clkbuf_1
X_246_ net59 _041_ VPWR VGND VPWR VGND sky130_fd_sc_hd__inv_2
XFILLER_10_393 VPWR VGND VPWR VGND sky130_fd_sc_hd__decap_3
XFILLER_6_331 VPWR VGND VPWR VGND sky130_fd_sc_hd__decap_3
X_177_ VPWR VGND VGND VPWR _089_ _091_ _090_ _177_/a_113_47# sky130_fd_sc_hd__nand2_1
XFILLER_6_375 VPWR VGND VPWR VGND sky130_fd_sc_hd__decap_3
XFILLER_42_6 VPWR VGND VPWR VGND sky130_fd_sc_hd__decap_3
XPHY_EDGE_ROW_16_2_Left_37 VPWR VGND VPWR VGND sky130_fd_sc_hd__decap_3
XFILLER_37_202 VPWR VGND VPWR VGND sky130_fd_sc_hd__decap_3
XFILLER_37_246 VPWR VGND VPWR VGND sky130_fd_sc_hd__decap_3
XFILLER_45_290 VPWR VGND VPWR VGND sky130_fd_sc_hd__decap_3
XFILLER_52_227 VPWR VGND VPWR VGND sky130_fd_sc_hd__decap_3
XFILLER_60_271 VPWR VGND VPWR VGND sky130_fd_sc_hd__decap_3
XFILLER_20_135 VPWR VGND VPWR VGND sky130_fd_sc_hd__decap_3
XFILLER_20_168 VPWR VGND VPWR VGND sky130_fd_sc_hd__decap_3
XPHY_EDGE_ROW_19_1_Left_125 VPWR VGND VPWR VGND sky130_fd_sc_hd__decap_3
XFILLER_28_224 VPWR VGND VPWR VGND sky130_fd_sc_hd__decap_3
XFILLER_28_268 VPWR VGND VPWR VGND sky130_fd_sc_hd__decap_3
XFILLER_43_205 VPWR VGND VPWR VGND sky130_fd_sc_hd__decap_3
XFILLER_43_249 VPWR VGND VPWR VGND sky130_fd_sc_hd__decap_3
XFILLER_11_113 VPWR VGND VPWR VGND sky130_fd_sc_hd__decap_3
XFILLER_51_293 VPWR VGND VPWR VGND sky130_fd_sc_hd__decap_3
XFILLER_11_146 VPWR VGND VPWR VGND sky130_fd_sc_hd__decap_3
XFILLER_7_128 VPWR VGND VPWR VGND sky130_fd_sc_hd__decap_3
XFILLER_7_106 VPWR VGND VPWR VGND sky130_fd_sc_hd__decap_3
XFILLER_22_53 VPWR VGND VPWR VGND sky130_fd_sc_hd__decap_3
XFILLER_22_75 VPWR VGND VPWR VGND sky130_fd_sc_hd__decap_3
XFILLER_22_97 VPWR VGND VPWR VGND sky130_fd_sc_hd__decap_3
XFILLER_3_334 VPWR VGND VPWR VGND sky130_fd_sc_hd__decap_3
XFILLER_3_367 VPWR VGND VPWR VGND sky130_fd_sc_hd__decap_3
XFILLER_59_382 VPWR VGND VPWR VGND sky130_fd_sc_hd__decap_3
XFILLER_59_393 VPWR VGND VPWR VGND sky130_fd_sc_hd__decap_3
XFILLER_47_72 VPWR VGND VPWR VGND sky130_fd_sc_hd__decap_3
Xpmu_inst clknet_1_0__leaf_clk net36 cout_next net63 net64 net65 net66 net67 net68
+ net69 net70 net72 net74 net55 pmu_inst/dc_inst.x9/a_247_21# pmu_inst/dc_inst.x2.x5/a_27_47#
+ pmu_inst/dc_inst.x6.net4 pmu_inst/_23_/a_193_47# pmu_inst/clkbuf_1_0__f_clk/a_110_47#
+ pmu_inst/clkbuf_0_clk/a_110_47# pmu_inst/dc_inst.x7.x8/a_27_47# pmu_inst/_14_/a_218_374#
+ pmu_inst/dc_inst.x2.net15 pmu_inst/dc_inst.x3.x5/a_27_47# pmu_inst/dc_inst.x7.net9
+ pmu_inst/dc_inst.x2.net10 pmu_inst/_17_/a_574_297# pmu_inst/dc_inst.x5.net10 pmu_inst/clkload0/X
+ pmu_inst/dc_inst.x2.net6 pmu_inst/dc_inst.x9/a_668_97# pmu_inst/_23_/a_1108_47#
+ pmu_inst/dc_inst.x4.x5/a_27_47# pmu_inst/dc_inst.x3.net15 pmu_inst/dc_inst.x7.x18/a_27_47#
+ pmu_inst/dc_inst.x5.net8 pmu_inst/dc_inst.x3.net11 pmu_inst/dc_inst.x6.x14/a_27_47#
+ pmu_inst/_24_/a_1108_47# pmu_inst/dc_inst.x4.x16/a_27_47# pmu_inst/dc_inst.x1.net17
+ pmu_inst/dc_inst.x6.net13 pmu_inst/dc_inst.x5.x10/a_27_47# pmu_inst/dc_inst.x8/a_27_413#
+ pmu_inst/dc_inst.x5.x5/a_27_47# pmu_inst/dc_inst.x8/a_750_97# pmu_inst/dc_inst.x2.x18/a_27_47#
+ pmu_inst/dc_inst.x3.x12/a_27_47# pmu_inst/dc_inst.x6.net10 pmu_inst/dc_inst.x10/a_218_47#
+ pmu_inst/dc_inst.x3.net4 pmu_inst/dc_inst.x1.x14/a_27_47# pmu_inst/_23_/a_1217_47#
+ pmu_inst/shadow_q pmu_inst/dc_inst.x1.x2/a_27_47# pmu_inst/dc_inst.x4.net15 pmu_inst/_25_/a_1108_47#
+ pmu_inst/_19_/a_109_297# pmu_inst/dc_inst.x6.x5/a_27_47# pmu_inst/dc_inst.x6.net2
+ pmu_inst/_24_/a_193_47# pmu_inst/dc_inst.x2.net17 pmu_inst/dc_inst.x7.net13 pmu_inst/_18_/a_218_374#
+ pmu_inst/dc_inst.x2.x2/a_27_47# pmu_inst/_23_/a_448_47# pmu_inst/dc_inst.x6.x20/a_27_47#
+ pmu_inst/dc_inst.x4.net5 pmu_inst/dc_inst.x7.x5/a_27_47# pmu_inst/dc_inst.net7 pmu_inst/_15_/a_872_316#
+ pmu_inst/dc_inst.x1.x20/a_27_47# pmu_inst/_25_/a_1217_47# pmu_inst/dc_inst.x3.x2/a_27_47#
+ pmu_inst/dc_inst.x3.net17 pmu_inst/dc_inst.x3.net13 pmu_inst/dc_inst.x4.x2/a_27_47#
+ pmu_inst/dc_inst.x7.x15/a_27_47# pmu_inst/dc_inst.x1.net19 pmu_inst/dc_inst.x6.net15
+ pmu_inst/dc_inst.x10/a_76_199# pmu_inst/dc_inst.x1.net15 pmu_inst/dc_inst.x5.x17/a_27_47#
+ pmu_inst/dc_inst.x6.x11/a_27_47# pmu_inst/_18_/a_505_21# pmu_inst/dc_inst.x3.x19/a_27_47#
+ pmu_inst/_15_/a_193_47# pmu_inst/dc_inst.x4.x13/a_27_47# pmu_inst/dc_inst.x3.net2
+ pmu_inst/_14_/a_439_47# pmu_inst/dc_inst.x2.x15/a_27_47# pmu_inst/dc_inst.x5.x2/a_27_47#
+ pmu_inst/dc_inst.x1.x9/a_27_47# pmu_inst/_14_/a_218_47# pmu_inst/dc_inst.x4.net13
+ pmu_inst/dc_inst.x9/a_277_47# pmu_inst/dc_inst.x1.x11/a_27_47# pmu_inst/dc_inst.x6.net8
+ pmu_inst/_24_/a_1462_47# pmu_inst/_24_/a_805_47# pmu_inst/_15_/a_788_316# pmu_inst/dc_inst.x1.net5
+ pmu_inst/_25_/a_193_47# pmu_inst/dc_inst.x2.net19 pmu_inst/dc_inst.x7.net15 pmu_inst/dc_inst.x6.x2/a_27_47#
+ pmu_inst/dc_inst.x7.net11 pmu_inst/dc_inst.x8/a_923_363# pmu_inst/_24_/a_448_47#
+ pmu_inst/_03_ pmu_inst/dc_inst.x4.net7 pmu_inst/dc_inst.x2.x9/a_27_47# pmu_inst/_25_/a_1462_47#
+ pmu_inst/_13_/a_112_47# pmu_inst/dc_inst.x5.net17 pmu_inst/dc_inst.x5.net13 pmu_inst/_15_/a_600_345#
+ pmu_inst/dc_inst.x7.x2/a_27_47# pmu_inst/dc_inst.x3.x9/a_27_47# pmu_inst/dc_inst.x7.net2
+ pmu_inst/_08_ pmu_inst/dc_inst.x2.net3 pmu_inst/dc_inst.x10/a_218_374# pmu_inst/_04_
+ pmu_inst/dc_inst.x6.net17 pmu_inst/dc_inst.net4 pmu_inst/dc_inst.x4.x9/a_27_47#
+ pmu_inst/dc_inst.x3.net8 pmu_inst/dc_inst.x6.x18/a_27_47# pmu_inst/dc_inst.x1.net1
+ pmu_inst/dc_inst.x7.x12/a_27_47# pmu_inst/_14_/a_76_199# pmu_inst/_06_ pmu_inst/dc_inst.x8/a_1290_413#
+ pmu_inst/dc_inst.x4.net19 pmu_inst/dc_inst.x5.x14/a_27_47# pmu_inst/_24_/a_639_47#
+ pmu_inst/dc_inst.x5.x9/a_27_47# pmu_inst/dc_inst.x3.x16/a_27_47# pmu_inst/dc_inst.x4.x10/a_27_47#
+ pmu_inst/dc_inst.x1.x18/a_27_47# pmu_inst/dc_inst.x6.net6 pmu_inst/_25_/a_805_47#
+ pmu_inst/dc_inst.x1.net7 pmu_inst/dc_inst.x2.x12/a_27_47# pmu_inst/_25_/a_1270_413#
+ pmu_inst/dc_inst.x7.net17 pmu_inst/dc_inst.x1.x6/a_27_47# pmu_inst/dc_inst.x9/a_1290_413#
+ pmu_inst/_25_/a_448_47# pmu_inst/dc_inst.x9/a_923_363# pmu_inst/dc_inst.x4.net9
+ pmu_inst/dc_inst.x6.x9/a_27_47# pmu_inst/dc_inst.x8/a_193_47# pmu_inst/dc_inst.x2.net1
+ pmu_inst/dc_inst.x5.net19 pmu_inst/dc_inst.x2.x6/a_27_47# pmu_inst/dc_inst.x5.net15
+ pmu_inst/dc_inst.x8/a_1478_413# pmu_inst/dc_inst.x5.x20/a_27_47# pmu_inst/dc_inst.x9/a_27_413#
+ pmu_inst/dc_inst.x7.x9/a_27_47# pmu_inst/dc_inst.x2.net5 pmu_inst/dc_inst.x9/a_750_97#
+ pmu_inst/dc_inst.x9/a_1478_413# pmu_inst/dc_inst.x3.x6/a_27_47# pmu_inst/_19_/a_465_47#
+ pmu_inst/dc_inst.x3.net1 pmu_inst/dc_inst.x5.net3 pmu_inst/clkload0/a_27_47# pmu_inst/dc_inst.x1.net12
+ pmu_inst/dc_inst.x4.x6/a_27_47# pmu_inst/dc_inst.x3.net6 pmu_inst/dc_inst.x7.x19/a_27_47#
+ pmu_inst/dc_inst.x4.net17 pmu_inst/_25_/a_639_47# pmu_inst/dc_inst.x6.x15/a_27_47#
+ pmu_inst/dc_inst.x1.net9 pmu_inst/dc_inst.x4.x17/a_27_47# pmu_inst/dc_inst.x5.x11/a_27_47#
+ pmu_inst/dc_inst.x7.net19 pmu_inst/dc_inst.x2.x19/a_27_47# pmu_inst/dc_inst.x5.x6/a_27_47#
+ pmu_inst/dc_inst.x3.x13/a_27_47# pmu_inst/_17_/a_478_47# pmu_inst/dc_inst.x1.x15/a_27_47#
+ net73 pmu_inst/dc_inst.x1.x3/a_27_47# pmu_inst/dc_inst.x2.net12 pmu_inst/dc_inst.x4.net4
+ pmu_inst/dc_inst.x6.x6/a_27_47# pmu_inst/dc_inst.net8 pmu_inst/dc_inst.x5.net1 pmu_inst/_19_/a_205_47#
+ pmu_inst/dc_inst.x2.x3/a_27_47# pmu_inst/dc_inst.x7.x6/a_27_47# pmu_inst/dc_inst.x3.net12
+ pmu_inst/dc_inst.x5.net9 pmu_inst/dc_inst.x5.net5 pmu_inst/_23_/a_651_413# pmu_inst/dc_inst.x3.x3/a_27_47#
+ pmu_inst/_15_/a_288_47# pmu_inst/dc_inst.x1.net14 pmu_inst/dc_inst.x6.net1 pmu_inst/_24_/a_651_413#
+ pmu_inst/dc_inst.x4.x3/a_27_47# pmu_inst/dc_inst.x7.x16/a_27_47# pmu_inst/_15_/a_1060_369#
+ pmu_inst/dc_inst.x6.net3 pmu_inst/dc_inst.x5.x18/a_27_47# pmu_inst/dc_inst.x6.x12/a_27_47#
+ pmu_inst/_15_/a_397_47# pmu_inst/dc_inst.x4.x14/a_27_47# pmu_inst/dc_inst.x2.net14
+ pmu_inst/_25_/a_651_413# pmu_inst/dc_inst.x5.x3/a_27_47# pmu_inst/dc_inst.x3.x10/a_27_47#
+ pmu_inst/dc_inst.x2.x16/a_27_47# pmu_inst/dc_inst.x4.net6 pmu_inst/dc_inst.x4.net2
+ pmu_inst/dc_inst.x1.x12/a_27_47# pmu_inst/_24_/a_1270_413# pmu_inst/_23_/a_27_47#
+ pmu_inst/dc_inst.net2 pmu_inst/dc_inst.x7.net8 pmu_inst/dc_inst.x2.net9 pmu_inst/dc_inst.x6.x3/a_27_47#
+ pmu_inst/dc_inst.x7.net4 pmu_inst/dc_inst.x3.net14 pmu_inst/dc_inst.x5.net7 pmu_inst/dc_inst.net1
+ pmu_inst/dc_inst.x4.x20/a_27_47# pmu_inst/dc_inst.x7.x3/a_27_47# pmu_inst/dc_inst.x6.net12
+ pmu_inst/dc_inst.x3.net3 pmu_inst/_07_ pmu_inst/dc_inst.x9/a_193_47# pmu_inst/_18_/a_439_47#
+ pmu_inst/_02_ pmu_inst/_18_/a_218_47# pmu_inst/clknet_1_1__leaf_clk pmu_inst/_10_
+ pmu_inst/dc_inst.x4.net1 pmu_inst/dc_inst.x6.net5 pmu_inst/dc_inst.x1.net6 pmu_inst/_15_/a_193_369#
+ pmu_inst/dc_inst.net5 pmu_inst/dc_inst.x1.net2 pmu_inst/_13_/a_470_47# pmu_inst/dc_inst.x6.x19/a_27_47#
+ pmu_inst/dc_inst.x7.x13/a_27_47# pmu_inst/dc_inst.x2.net16 net62 pmu_inst/_19_/a_193_297#
+ pmu_inst/dc_inst.x4.net8 pmu_inst/dc_inst.x5.x15/a_27_47# pmu_inst/dc_inst.x3.x17/a_27_47#
+ pmu_inst/dc_inst.x4.x11/a_27_47# pmu_inst/dc_inst.x1.x19/a_27_47# pmu_inst/dc_inst.x2.x13/a_27_47#
+ pmu_inst/dc_inst.x7.net10 pmu_inst/dc_inst.x5.net14 pmu_inst/dc_inst.x1.x7/a_27_47#
+ pmu_inst/_05_ pmu_inst/dc_inst.x7.net6 pmu_inst/dc_inst.x2.net7 pmu_inst/_15_/a_372_413#
+ pmu_inst/dc_inst.x2.x7/a_27_47# pmu_inst/clknet_0_clk pmu_inst/_23_/a_543_47# pmu_inst/clkbuf_1_1__f_clk/a_110_47#
+ pmu_inst/dc_inst.x6.net14 pmu_inst/dc_inst.x3.net5 pmu_inst/_20_/a_470_297# pmu_inst/dc_inst.x3.x7/a_27_47#
+ pmu_inst/_18_/a_76_199# pmu_inst/dc_inst.x3.net19 pmu_inst/_14_/a_535_374# pmu_inst/dc_inst.x4.net16
+ pmu_inst/dc_inst.x4.net12 pmu_inst/dc_inst.x6.net7 pmu_inst/dc_inst.x1.net8 pmu_inst/dc_inst.x1.net4
+ pmu_inst/dc_inst.x4.x7/a_27_47# pmu_inst/dc_inst.x7.net14 pmu_inst/_15_/a_1281_47#
+ pmu_inst/dc_inst.x2.net18 pmu_inst/dc_inst.x4.net10 pmu_inst/dc_inst.x7.net1 pmu_inst/_20_/a_79_21#
+ pmu_inst/dc_inst.x6.x16/a_27_47# pmu_inst/dc_inst.x7.x10/a_27_47# pmu_inst/dc_inst.x5.x12/a_27_47#
+ pmu_inst/dc_inst.x5.net16 pmu_inst/dc_inst.x4.x18/a_27_47# pmu_inst/dc_inst.x5.x7/a_27_47#
+ net35 pmu_inst/dc_inst.x3.x14/a_27_47# pmu_inst/dc_inst.x1.x16/a_27_47# pmu_inst/dc_inst.x2.x10/a_27_47#
+ pmu_inst/dc_inst.x1.x4/a_27_47# pmu_inst/dc_inst.x3.net18 pmu_inst/_23_/a_1270_413#
+ pmu_inst/dc_inst.x8/a_27_47# pmu_inst/_15_/a_1279_413# pmu_inst/dc_inst.x6.x7/a_27_47#
+ pmu_inst/dc_inst.x5.net4 pmu_inst/_24_/a_543_47# net34 pmu_inst/dc_inst.x10/a_505_21#
+ pmu_inst/dc_inst.x6.net16 pmu_inst/dc_inst.x1.net16 pmu_inst/dc_inst.x2.x4/a_27_47#
+ pmu_inst/dc_inst.x3.net7 pmu_inst/dc_inst.x7.x7/a_27_47# pmu_inst/_18_/a_535_374#
+ pmu_inst/dc_inst.x8/a_834_97# pmu_inst/dc_inst.x3.x20/a_27_47# pmu_inst/dc_inst.x4.net14
+ pmu_inst/dc_inst.x3.x4/a_27_47# pmu_inst/dc_inst.x6.net9 pmu_inst/_24_/a_27_47#
+ pmu_inst/dc_inst.x6.net19 pmu_inst/_16_/a_27_93# pmu_inst/dc_inst.x7.net16 pmu_inst/dc_inst.x7.net12
+ pmu_inst/capture_q pmu_inst/dc_inst.x4.x4/a_27_47# pmu_inst/dc_inst.x5.net18 pmu_inst/dc_inst.x7.x17/a_27_47#
+ pmu_inst/_23_/a_1283_21# pmu_inst/dc_inst.x8/a_247_21# pmu_inst/dc_inst.x6.x13/a_27_47#
+ pmu_inst/dc_inst.x5.x19/a_27_47# pmu_inst/_00_ pmu_inst/dc_inst.x4.x15/a_27_47#
+ pmu_inst/dc_inst.x7.net3 pmu_inst/dc_inst.x2.net4 pmu_inst/dc_inst.x5.x4/a_27_47#
+ pmu_inst/dc_inst.x3.x11/a_27_47# pmu_inst/dc_inst.x2.x17/a_27_47# pmu_inst/dc_inst.x3.net16
+ pmu_inst/dc_inst.x1.x13/a_27_47# pmu_inst/_24_/a_1283_21# pmu_inst/dc_inst.x1.x1/a_27_47#
+ pmu_inst/_17_/a_174_21# pmu_inst/dc_inst.x6.net18 pmu_inst/dc_inst.x5.net2 pmu_inst/_25_/a_543_47#
+ pmu_inst/dc_inst.x5.net12 pmu_inst/dc_inst.x1.net18 pmu_inst/dc_inst.x6.x4/a_27_47#
+ pmu_inst/dc_inst.x8/a_668_97# pmu_inst/_14_/a_505_21# pmu_inst/dc_inst.x1.net11
+ pmu_inst/_25_/a_1283_21# pmu_inst/_20_/a_384_47# pmu_inst/dc_inst.x2.x1/a_27_47#
+ pmu_inst/dc_inst.x8/a_193_413# pmu_inst/dc_inst.x7.x4/a_27_47# pmu_inst/dc_inst.x7.net18
+ pmu_inst/dc_inst.x3.x1/a_27_47# pmu_inst/dc_inst.x2.net11 pmu_inst/dc_inst.x10/a_535_374#
+ pmu_inst/dc_inst.x4.net3 pmu_inst/dc_inst.x4.x1/a_27_47# pmu_inst/_19_/a_27_47#
+ pmu_inst/capture_d pmu_inst/dc_inst.x7.x14/a_27_47# pmu_inst/dc_inst.x7.net5 pmu_inst/dc_inst.net6
+ pmu_inst/dc_inst.x2.net2 pmu_inst/dc_inst.x5.x16/a_27_47# pmu_inst/dc_inst.x6.x10/a_27_47#
+ pmu_inst/dc_inst.x3.x18/a_27_47# pmu_inst/dc_inst.x4.x12/a_27_47# pmu_inst/dc_inst.x2.x14/a_27_47#
+ pmu_inst/dc_inst.x5.x1/a_27_47# pmu_inst/dc_inst.x1.x8/a_27_47# pmu_inst/_15_/a_1064_47#
+ pmu_inst/_15_/a_27_47# pmu_inst/dc_inst.x1.x10/a_27_47# pmu_inst/_09_ pmu_inst/dc_inst.x1.net13
+ pmu_inst/_13_/a_470_297# pmu_inst/_01_ pmu_inst/dc_inst.x8/a_757_363# pmu_inst/dc_inst.x6.x1/a_27_47#
+ pmu_inst/dc_inst.x1.net10 pmu_inst/dc_inst.x2.x8/a_27_47# pmu_inst/dc_inst.x4.net18
+ pmu_inst/dc_inst.x7.x20/a_27_47# pmu_inst/dc_inst.x9/a_193_413# pmu_inst/_13_/a_27_297#
+ pmu_inst/dc_inst.in pmu_inst/dc_inst.x4.net11 pmu_inst/dc_inst.x1.net3 pmu_inst/dc_inst.x7.x1/a_27_47#
+ pmu_inst/dc_inst.x2.x20/a_27_47# pmu_inst/dc_inst.x3.x8/a_27_47# pmu_inst/dc_inst.x2.net13
+ pmu_inst/dc_inst.net3 pmu_inst/_23_/a_761_289# pmu_inst/dc_inst.x8/a_277_47# pmu_inst/dc_inst.net9
+ pmu_inst/dc_inst.x7.net7 pmu_inst/dc_inst.x5.net11 pmu_inst/dc_inst.x4.x8/a_27_47#
+ pmu_inst/dc_inst.x2.net8 pmu_inst/dc_inst.x6.x17/a_27_47# VPWR pmu_inst/_24_/a_761_289#
+ pmu_inst/dc_inst.x7.x11/a_27_47# pmu_inst/dc_inst.x9/a_834_97# pmu_inst/dc_inst.x4.x19/a_27_47#
+ pmu_inst/dc_inst.x5.x13/a_27_47# pmu_inst/dc_inst.x3.net10 pmu_inst/dc_inst.x5.net6
+ pmu_inst/clknet_1_0__leaf_clk pmu_inst/dc_inst.x5.x8/a_27_47# pmu_inst/_25_/a_27_47#
+ pmu_inst/dc_inst.x3.x15/a_27_47# net71 pmu_inst/dc_inst.x1.x17/a_27_47# pmu_inst/_17_/a_27_93#
+ pmu_inst/_16_/a_229_47# pmu_inst/dc_inst.x2.x11/a_27_47# VGND pmu_inst/dc_inst.x1.x5/a_27_47#
+ pmu_inst/dc_inst.x6.net11 pmu_inst/dc_inst.x3.net9 pmu_inst/_25_/a_761_289# pmu_inst/dc_inst.x9/a_27_47#
+ pmu_inst/dc_inst.x9/a_757_363# pmu_inst/dc_inst.x6.x8/a_27_47# pmu
XFILLER_34_227 VPWR VGND VPWR VGND sky130_fd_sc_hd__decap_3
XFILLER_63_60 VPWR VGND VPWR VGND sky130_fd_sc_hd__decap_3
XFILLER_27_290 VPWR VGND VPWR VGND sky130_fd_sc_hd__decap_3
XFILLER_63_93 VPWR VGND VPWR VGND sky130_fd_sc_hd__decap_3
XFILLER_42_271 VPWR VGND VPWR VGND sky130_fd_sc_hd__decap_3
XFILLER_8_77 VPWR VGND VPWR VGND sky130_fd_sc_hd__decap_3
XFILLER_8_88 VPWR VGND VPWR VGND sky130_fd_sc_hd__decap_3
X_229_ net58 _024_ VPWR VGND VPWR VGND sky130_fd_sc_hd__inv_2
XFILLER_6_150 VPWR VGND VPWR VGND sky130_fd_sc_hd__decap_3
XFILLER_25_205 VPWR VGND VPWR VGND sky130_fd_sc_hd__decap_3
XFILLER_25_249 VPWR VGND VPWR VGND sky130_fd_sc_hd__decap_3
XFILLER_33_293 VPWR VGND VPWR VGND sky130_fd_sc_hd__decap_3
XFILLER_0_337 VPWR VGND VPWR VGND sky130_fd_sc_hd__decap_3
XFILLER_56_330 VPWR VGND VPWR VGND sky130_fd_sc_hd__decap_3
XFILLER_56_374 VPWR VGND VPWR VGND sky130_fd_sc_hd__decap_3
XFILLER_17_53 VPWR VGND VPWR VGND sky130_fd_sc_hd__decap_3
XFILLER_17_97 VPWR VGND VPWR VGND sky130_fd_sc_hd__decap_3
XFILLER_31_208 VPWR VGND VPWR VGND sky130_fd_sc_hd__decap_3
XFILLER_24_271 VPWR VGND VPWR VGND sky130_fd_sc_hd__decap_3
XFILLER_33_74 VPWR VGND VPWR VGND sky130_fd_sc_hd__decap_3
XFILLER_3_131 VPWR VGND VPWR VGND sky130_fd_sc_hd__decap_3
XFILLER_3_164 VPWR VGND VPWR VGND sky130_fd_sc_hd__decap_3
XFILLER_3_175 VPWR VGND VPWR VGND sky130_fd_sc_hd__decap_3
XFILLER_39_308 VPWR VGND VPWR VGND sky130_fd_sc_hd__decap_3
XFILLER_58_60 VPWR VGND VPWR VGND sky130_fd_sc_hd__decap_3
XFILLER_59_190 VPWR VGND VPWR VGND sky130_fd_sc_hd__decap_3
XFILLER_47_352 VPWR VGND VPWR VGND sky130_fd_sc_hd__decap_3
XFILLER_62_333 VPWR VGND VPWR VGND sky130_fd_sc_hd__decap_3
XFILLER_47_396 VPWR VGND VPWR VGND sky130_fd_sc_hd__decap_3
XFILLER_47_385 VPWR VGND VPWR VGND sky130_fd_sc_hd__decap_3
XFILLER_62_377 VPWR VGND VPWR VGND sky130_fd_sc_hd__decap_3
XFILLER_30_230 VPWR VGND VPWR VGND sky130_fd_sc_hd__decap_3
XFILLER_30_274 VPWR VGND VPWR VGND sky130_fd_sc_hd__decap_3
XFILLER_57_116 VPWR VGND VPWR VGND sky130_fd_sc_hd__decap_3
XFILLER_38_330 VPWR VGND VPWR VGND sky130_fd_sc_hd__decap_3
XFILLER_57_149 VPWR VGND VPWR VGND sky130_fd_sc_hd__decap_3
XFILLER_53_311 VPWR VGND VPWR VGND sky130_fd_sc_hd__decap_3
XFILLER_38_374 VPWR VGND VPWR VGND sky130_fd_sc_hd__decap_3
XFILLER_54_18 VPWR VGND VPWR VGND sky130_fd_sc_hd__decap_3
XFILLER_53_355 VPWR VGND VPWR VGND sky130_fd_sc_hd__decap_3
XFILLER_53_399 VPWR VGND VPWR VGND sky130_fd_sc_hd__decap_3
XFILLER_53_388 VPWR VGND VPWR VGND sky130_fd_sc_hd__decap_3
XFILLER_21_296 VPWR VGND VPWR VGND sky130_fd_sc_hd__decap_3
XFILLER_0_134 VPWR VGND VPWR VGND sky130_fd_sc_hd__decap_3
XFILLER_0_156 VPWR VGND VPWR VGND sky130_fd_sc_hd__decap_3
XFILLER_63_119 VPWR VGND VPWR VGND sky130_fd_sc_hd__decap_3
XFILLER_63_108 VPWR VGND VPWR VGND sky130_fd_sc_hd__decap_3
XFILLER_28_74 VPWR VGND VPWR VGND sky130_fd_sc_hd__decap_3
XFILLER_28_63 VPWR VGND VPWR VGND sky130_fd_sc_hd__decap_3
XFILLER_29_352 VPWR VGND VPWR VGND sky130_fd_sc_hd__decap_3
XFILLER_28_85 VPWR VGND VPWR VGND sky130_fd_sc_hd__decap_3
XFILLER_29_385 VPWR VGND VPWR VGND sky130_fd_sc_hd__decap_3
XFILLER_29_396 VPWR VGND VPWR VGND sky130_fd_sc_hd__decap_3
XFILLER_56_171 VPWR VGND VPWR VGND sky130_fd_sc_hd__decap_3
XFILLER_44_333 VPWR VGND VPWR VGND sky130_fd_sc_hd__decap_3
XFILLER_44_377 VPWR VGND VPWR VGND sky130_fd_sc_hd__decap_3
XFILLER_44_62 VPWR VGND VPWR VGND sky130_fd_sc_hd__decap_3
XFILLER_60_50 VPWR VGND VPWR VGND sky130_fd_sc_hd__decap_3
XFILLER_60_94 VPWR VGND VPWR VGND sky130_fd_sc_hd__decap_3
XFILLER_39_116 VPWR VGND VPWR VGND sky130_fd_sc_hd__decap_3
XFILLER_39_105 VPWR VGND VPWR VGND sky130_fd_sc_hd__decap_3
XFILLER_39_149 VPWR VGND VPWR VGND sky130_fd_sc_hd__decap_3
XFILLER_35_311 VPWR VGND VPWR VGND sky130_fd_sc_hd__decap_3
XFILLER_62_141 VPWR VGND VPWR VGND sky130_fd_sc_hd__decap_3
XFILLER_62_130 VPWR VGND VPWR VGND sky130_fd_sc_hd__decap_3
XFILLER_35_355 VPWR VGND VPWR VGND sky130_fd_sc_hd__decap_3
XFILLER_47_193 VPWR VGND VPWR VGND sky130_fd_sc_hd__decap_3
XFILLER_62_174 VPWR VGND VPWR VGND sky130_fd_sc_hd__decap_3
XFILLER_35_388 VPWR VGND VPWR VGND sky130_fd_sc_hd__decap_3
XFILLER_35_399 VPWR VGND VPWR VGND sky130_fd_sc_hd__decap_3
XFILLER_50_336 VPWR VGND VPWR VGND sky130_fd_sc_hd__decap_3
XFILLER_38_171 VPWR VGND VPWR VGND sky130_fd_sc_hd__decap_3
XFILLER_45_119 VPWR VGND VPWR VGND sky130_fd_sc_hd__decap_3
XFILLER_26_333 VPWR VGND VPWR VGND sky130_fd_sc_hd__decap_3
XFILLER_41_314 VPWR VGND VPWR VGND sky130_fd_sc_hd__decap_3
XFILLER_26_377 VPWR VGND VPWR VGND sky130_fd_sc_hd__decap_3
XFILLER_53_152 VPWR VGND VPWR VGND sky130_fd_sc_hd__decap_3
XFILLER_41_358 VPWR VGND VPWR VGND sky130_fd_sc_hd__decap_3
XFILLER_53_196 VPWR VGND VPWR VGND sky130_fd_sc_hd__decap_3
XFILLER_14_54 VPWR VGND VPWR VGND sky130_fd_sc_hd__decap_3
XFILLER_14_32 VPWR VGND VPWR VGND sky130_fd_sc_hd__decap_3
XPHY_EDGE_ROW_11_1_Right_10 VPWR VGND VPWR VGND sky130_fd_sc_hd__decap_3
XFILLER_30_53 VPWR VGND VPWR VGND sky130_fd_sc_hd__decap_3
XFILLER_30_97 VPWR VGND VPWR VGND sky130_fd_sc_hd__decap_3
XPHY_EDGE_ROW_24_Left_130 VPWR VGND VPWR VGND sky130_fd_sc_hd__decap_3
XFILLER_29_193 VPWR VGND VPWR VGND sky130_fd_sc_hd__decap_3
XFILLER_17_355 VPWR VGND VPWR VGND sky130_fd_sc_hd__decap_3
XFILLER_44_130 VPWR VGND VPWR VGND sky130_fd_sc_hd__decap_3
XFILLER_44_141 VPWR VGND VPWR VGND sky130_fd_sc_hd__decap_3
XFILLER_17_388 VPWR VGND VPWR VGND sky130_fd_sc_hd__decap_3
XFILLER_44_174 VPWR VGND VPWR VGND sky130_fd_sc_hd__decap_3
XFILLER_32_336 VPWR VGND VPWR VGND sky130_fd_sc_hd__decap_3
XFILLER_40_380 VPWR VGND VPWR VGND sky130_fd_sc_hd__decap_3
XFILLER_27_108 VPWR VGND VPWR VGND sky130_fd_sc_hd__decap_3
XFILLER_27_119 VPWR VGND VPWR VGND sky130_fd_sc_hd__decap_3
XFILLER_35_152 VPWR VGND VPWR VGND sky130_fd_sc_hd__decap_3
XFILLER_23_314 VPWR VGND VPWR VGND sky130_fd_sc_hd__decap_3
XFILLER_35_196 VPWR VGND VPWR VGND sky130_fd_sc_hd__decap_3
XFILLER_50_100 VPWR VGND VPWR VGND sky130_fd_sc_hd__decap_3
XFILLER_50_133 VPWR VGND VPWR VGND sky130_fd_sc_hd__decap_3
XFILLER_23_358 VPWR VGND VPWR VGND sky130_fd_sc_hd__decap_3
XFILLER_50_144 VPWR VGND VPWR VGND sky130_fd_sc_hd__decap_3
XFILLER_50_177 VPWR VGND VPWR VGND sky130_fd_sc_hd__decap_3
XFILLER_58_233 VPWR VGND VPWR VGND sky130_fd_sc_hd__decap_3
XFILLER_58_200 VPWR VGND VPWR VGND sky130_fd_sc_hd__decap_3
XFILLER_58_277 VPWR VGND VPWR VGND sky130_fd_sc_hd__decap_3
XFILLER_26_130 VPWR VGND VPWR VGND sky130_fd_sc_hd__decap_3
XFILLER_26_141 VPWR VGND VPWR VGND sky130_fd_sc_hd__decap_3
XFILLER_25_42 VPWR VGND VPWR VGND sky130_fd_sc_hd__decap_3
XFILLER_26_174 VPWR VGND VPWR VGND sky130_fd_sc_hd__decap_3
XFILLER_41_122 VPWR VGND VPWR VGND sky130_fd_sc_hd__decap_3
XFILLER_14_369 VPWR VGND VPWR VGND sky130_fd_sc_hd__decap_3
XFILLER_25_97 VPWR VGND VPWR VGND sky130_fd_sc_hd__decap_3
XFILLER_41_155 VPWR VGND VPWR VGND sky130_fd_sc_hd__decap_3
X_262_ VGND VPWR VPWR VGND clknet_2_1__leaf_clk_regs genblk1\[7\].fa_inst.s _007_
+ net52 _262_/a_1462_47# _262_/a_543_47# _262_/a_651_413# _262_/a_193_47# _262_/a_805_47#
+ _262_/a_448_47# _262_/a_639_47# _262_/a_1283_21# _262_/a_761_289# _262_/a_1108_47#
+ _262_/a_1217_47# _262_/a_1270_413# _262_/a_27_47# sky130_fd_sc_hd__dfrtp_1
XFILLER_22_380 VPWR VGND VPWR VGND sky130_fd_sc_hd__decap_3
XFILLER_41_199 VPWR VGND VPWR VGND sky130_fd_sc_hd__decap_3
XFILLER_41_41 VPWR VGND VPWR VGND sky130_fd_sc_hd__decap_3
X_193_ VGND VPWR VGND VPWR _104_ _100_ _097_ _098_ _193_/a_215_297# _193_/a_27_413#
+ _193_/a_298_297# _193_/a_382_47# sky130_fd_sc_hd__a21bo_1
XFILLER_41_96 VPWR VGND VPWR VGND sky130_fd_sc_hd__decap_3
XFILLER_37_9 VPWR VGND VPWR VGND sky130_fd_sc_hd__decap_3
XFILLER_2_24 VPWR VGND VPWR VGND sky130_fd_sc_hd__decap_3
XFILLER_2_35 VPWR VGND VPWR VGND sky130_fd_sc_hd__decap_3
XFILLER_49_211 VPWR VGND VPWR VGND sky130_fd_sc_hd__decap_3
XFILLER_2_68 VPWR VGND VPWR VGND sky130_fd_sc_hd__decap_3
XFILLER_49_255 VPWR VGND VPWR VGND sky130_fd_sc_hd__decap_3
XFILLER_64_225 VPWR VGND VPWR VGND sky130_fd_sc_hd__decap_3
XFILLER_64_203 VPWR VGND VPWR VGND sky130_fd_sc_hd__decap_3
XFILLER_49_299 VPWR VGND VPWR VGND sky130_fd_sc_hd__decap_3
XFILLER_17_152 VPWR VGND VPWR VGND sky130_fd_sc_hd__decap_3
XFILLER_32_166 VPWR VGND VPWR VGND sky130_fd_sc_hd__decap_3
XFILLER_20_328 VPWR VGND VPWR VGND sky130_fd_sc_hd__decap_3
XFILLER_13_391 VPWR VGND VPWR VGND sky130_fd_sc_hd__decap_3
XFILLER_9_340 VPWR VGND VPWR VGND sky130_fd_sc_hd__decap_3
XPHY_EDGE_ROW_4_1_Right_3 VPWR VGND VPWR VGND sky130_fd_sc_hd__decap_3
XFILLER_9_373 VPWR VGND VPWR VGND sky130_fd_sc_hd__decap_3
XFILLER_55_214 VPWR VGND VPWR VGND sky130_fd_sc_hd__decap_3
XFILLER_55_225 VPWR VGND VPWR VGND sky130_fd_sc_hd__decap_3
XFILLER_55_258 VPWR VGND VPWR VGND sky130_fd_sc_hd__decap_3
XFILLER_62_18 VPWR VGND VPWR VGND sky130_fd_sc_hd__decap_3
XFILLER_23_122 VPWR VGND VPWR VGND sky130_fd_sc_hd__decap_3
XFILLER_62_29 VPWR VGND VPWR VGND sky130_fd_sc_hd__decap_3
XFILLER_23_155 VPWR VGND VPWR VGND sky130_fd_sc_hd__decap_3
XFILLER_11_328 VPWR VGND VPWR VGND sky130_fd_sc_hd__decap_3
XFILLER_23_199 VPWR VGND VPWR VGND sky130_fd_sc_hd__decap_3
XFILLER_11_33 VPWR VGND VPWR VGND sky130_fd_sc_hd__decap_3
XFILLER_2_6 VPWR VGND VPWR VGND sky130_fd_sc_hd__decap_3
XFILLER_11_77 VPWR VGND VPWR VGND sky130_fd_sc_hd__decap_3
XFILLER_46_203 VPWR VGND VPWR VGND sky130_fd_sc_hd__decap_3
XFILLER_46_236 VPWR VGND VPWR VGND sky130_fd_sc_hd__decap_3
XFILLER_61_217 VPWR VGND VPWR VGND sky130_fd_sc_hd__decap_3
XFILLER_36_63 VPWR VGND VPWR VGND sky130_fd_sc_hd__decap_3
XFILLER_61_228 VPWR VGND VPWR VGND sky130_fd_sc_hd__decap_3
XFILLER_14_100 VPWR VGND VPWR VGND sky130_fd_sc_hd__decap_3
XFILLER_36_85 VPWR VGND VPWR VGND sky130_fd_sc_hd__decap_3
XFILLER_54_280 VPWR VGND VPWR VGND sky130_fd_sc_hd__decap_3
XFILLER_14_144 VPWR VGND VPWR VGND sky130_fd_sc_hd__decap_3
XFILLER_14_133 VPWR VGND VPWR VGND sky130_fd_sc_hd__decap_3
XFILLER_14_177 VPWR VGND VPWR VGND sky130_fd_sc_hd__decap_3
X_245_ net59 _040_ VPWR VGND VPWR VGND sky130_fd_sc_hd__inv_2
Xinput16 VGND VPWR net16 a[9] VPWR VGND input16/a_75_212# sky130_fd_sc_hd__clkbuf_1
Xinput27 VGND VPWR net27 b[4] VPWR VGND input27/a_75_212# sky130_fd_sc_hd__clkbuf_1
XFILLER_10_372 VPWR VGND VPWR VGND sky130_fd_sc_hd__decap_3
XFILLER_6_343 VPWR VGND VPWR VGND sky130_fd_sc_hd__decap_3
X_176_ VPWR VGND VGND VPWR genblk1\[10\].fa_inst.b _090_ genblk1\[10\].fa_inst.a _176_/a_113_47#
+ sky130_fd_sc_hd__nand2_1
XFILLER_6_387 VPWR VGND VPWR VGND sky130_fd_sc_hd__decap_3
XFILLER_6_354 VPWR VGND VPWR VGND sky130_fd_sc_hd__decap_3
XFILLER_35_6 VPWR VGND VPWR VGND sky130_fd_sc_hd__decap_3
XFILLER_37_214 VPWR VGND VPWR VGND sky130_fd_sc_hd__decap_3
XFILLER_37_225 VPWR VGND VPWR VGND sky130_fd_sc_hd__decap_3
XFILLER_37_258 VPWR VGND VPWR VGND sky130_fd_sc_hd__decap_3
XFILLER_52_206 VPWR VGND VPWR VGND sky130_fd_sc_hd__decap_3
XFILLER_52_239 VPWR VGND VPWR VGND sky130_fd_sc_hd__decap_3
XFILLER_60_283 VPWR VGND VPWR VGND sky130_fd_sc_hd__decap_3
XFILLER_20_147 VPWR VGND VPWR VGND sky130_fd_sc_hd__decap_3
XFILLER_28_203 VPWR VGND VPWR VGND sky130_fd_sc_hd__decap_3
XFILLER_28_236 VPWR VGND VPWR VGND sky130_fd_sc_hd__decap_3
XFILLER_36_280 VPWR VGND VPWR VGND sky130_fd_sc_hd__decap_3
XFILLER_43_217 VPWR VGND VPWR VGND sky130_fd_sc_hd__decap_3
XFILLER_43_228 VPWR VGND VPWR VGND sky130_fd_sc_hd__decap_3
XFILLER_51_261 VPWR VGND VPWR VGND sky130_fd_sc_hd__decap_3
XFILLER_11_125 VPWR VGND VPWR VGND sky130_fd_sc_hd__decap_3
XFILLER_11_169 VPWR VGND VPWR VGND sky130_fd_sc_hd__decap_3
XFILLER_11_158 VPWR VGND VPWR VGND sky130_fd_sc_hd__decap_3
XFILLER_22_21 VPWR VGND VPWR VGND sky130_fd_sc_hd__decap_3
XFILLER_22_32 VPWR VGND VPWR VGND sky130_fd_sc_hd__decap_3
XFILLER_3_346 VPWR VGND VPWR VGND sky130_fd_sc_hd__decap_3
XFILLER_59_361 VPWR VGND VPWR VGND sky130_fd_sc_hd__decap_3
XFILLER_47_51 VPWR VGND VPWR VGND sky130_fd_sc_hd__decap_3
XFILLER_34_206 VPWR VGND VPWR VGND sky130_fd_sc_hd__decap_3
XFILLER_47_84 VPWR VGND VPWR VGND sky130_fd_sc_hd__decap_3
XFILLER_34_239 VPWR VGND VPWR VGND sky130_fd_sc_hd__decap_3
XFILLER_63_72 VPWR VGND VPWR VGND sky130_fd_sc_hd__decap_3
XFILLER_30_401 VPWR VGND VPWR VGND sky130_fd_sc_hd__decap_3
XFILLER_8_12 VPWR VGND VPWR VGND sky130_fd_sc_hd__decap_3
XFILLER_42_283 VPWR VGND VPWR VGND sky130_fd_sc_hd__decap_3
X_228_ net58 _023_ VPWR VGND VPWR VGND sky130_fd_sc_hd__inv_2
XFILLER_6_162 VPWR VGND VPWR VGND sky130_fd_sc_hd__decap_3
X_159_ VGND VPWR _076_ genblk1\[6\].fa_inst.s _075_ VPWR VGND _159_/a_129_47# _159_/a_47_47#
+ _159_/a_285_47# _159_/a_377_297# sky130_fd_sc_hd__xnor2_1
XFILLER_33_3 VPWR VGND VPWR VGND sky130_fd_sc_hd__decap_3
XFILLER_2_390 VPWR VGND VPWR VGND sky130_fd_sc_hd__decap_3
XFILLER_25_217 VPWR VGND VPWR VGND sky130_fd_sc_hd__decap_3
XFILLER_25_228 VPWR VGND VPWR VGND sky130_fd_sc_hd__decap_3
XFILLER_33_261 VPWR VGND VPWR VGND sky130_fd_sc_hd__decap_3
XFILLER_40_209 VPWR VGND VPWR VGND sky130_fd_sc_hd__decap_3
XFILLER_0_349 VPWR VGND VPWR VGND sky130_fd_sc_hd__decap_3
XFILLER_48_309 VPWR VGND VPWR VGND sky130_fd_sc_hd__decap_3
XFILLER_56_342 VPWR VGND VPWR VGND sky130_fd_sc_hd__decap_3
XFILLER_56_386 VPWR VGND VPWR VGND sky130_fd_sc_hd__decap_3
XFILLER_17_76 VPWR VGND VPWR VGND sky130_fd_sc_hd__decap_3
XFILLER_33_42 VPWR VGND VPWR VGND sky130_fd_sc_hd__decap_3
XFILLER_24_283 VPWR VGND VPWR VGND sky130_fd_sc_hd__decap_3
XFILLER_33_86 VPWR VGND VPWR VGND sky130_fd_sc_hd__decap_3
XFILLER_3_143 VPWR VGND VPWR VGND sky130_fd_sc_hd__decap_3
XFILLER_58_72 VPWR VGND VPWR VGND sky130_fd_sc_hd__decap_3
XFILLER_58_94 VPWR VGND VPWR VGND sky130_fd_sc_hd__decap_3
XFILLER_47_320 VPWR VGND VPWR VGND sky130_fd_sc_hd__decap_3
XFILLER_47_364 VPWR VGND VPWR VGND sky130_fd_sc_hd__decap_3
XFILLER_62_312 VPWR VGND VPWR VGND sky130_fd_sc_hd__decap_3
XFILLER_62_301 VPWR VGND VPWR VGND sky130_fd_sc_hd__decap_3
XFILLER_62_345 VPWR VGND VPWR VGND sky130_fd_sc_hd__decap_3
XFILLER_62_389 VPWR VGND VPWR VGND sky130_fd_sc_hd__decap_3
XFILLER_22_209 VPWR VGND VPWR VGND sky130_fd_sc_hd__decap_3
XFILLER_30_253 VPWR VGND VPWR VGND sky130_fd_sc_hd__decap_3
XFILLER_30_242 VPWR VGND VPWR VGND sky130_fd_sc_hd__decap_3
XFILLER_30_286 VPWR VGND VPWR VGND sky130_fd_sc_hd__decap_3
XFILLER_57_128 VPWR VGND VPWR VGND sky130_fd_sc_hd__decap_3
XFILLER_38_342 VPWR VGND VPWR VGND sky130_fd_sc_hd__decap_3
XFILLER_53_323 VPWR VGND VPWR VGND sky130_fd_sc_hd__decap_3
XFILLER_38_386 VPWR VGND VPWR VGND sky130_fd_sc_hd__decap_3
XFILLER_53_367 VPWR VGND VPWR VGND sky130_fd_sc_hd__decap_3
XFILLER_21_253 VPWR VGND VPWR VGND sky130_fd_sc_hd__decap_3
XFILLER_21_275 VPWR VGND VPWR VGND sky130_fd_sc_hd__decap_3
XFILLER_0_113 VPWR VGND VPWR VGND sky130_fd_sc_hd__decap_3
XFILLER_48_117 VPWR VGND VPWR VGND sky130_fd_sc_hd__decap_3
XFILLER_29_320 VPWR VGND VPWR VGND sky130_fd_sc_hd__decap_3
XFILLER_28_42 VPWR VGND VPWR VGND sky130_fd_sc_hd__decap_3
XFILLER_29_364 VPWR VGND VPWR VGND sky130_fd_sc_hd__decap_3
XFILLER_44_312 VPWR VGND VPWR VGND sky130_fd_sc_hd__decap_3
XFILLER_44_301 VPWR VGND VPWR VGND sky130_fd_sc_hd__decap_3
XFILLER_56_150 VPWR VGND VPWR VGND sky130_fd_sc_hd__decap_3
XFILLER_56_183 VPWR VGND VPWR VGND sky130_fd_sc_hd__decap_3
XFILLER_44_345 VPWR VGND VPWR VGND sky130_fd_sc_hd__decap_3
XFILLER_44_389 VPWR VGND VPWR VGND sky130_fd_sc_hd__decap_3
XFILLER_44_41 VPWR VGND VPWR VGND sky130_fd_sc_hd__decap_3
XFILLER_44_85 VPWR VGND VPWR VGND sky130_fd_sc_hd__decap_3
XFILLER_60_62 VPWR VGND VPWR VGND sky130_fd_sc_hd__decap_3
XFILLER_5_68 VPWR VGND VPWR VGND sky130_fd_sc_hd__decap_3
XFILLER_39_128 VPWR VGND VPWR VGND sky130_fd_sc_hd__decap_3
XFILLER_35_323 VPWR VGND VPWR VGND sky130_fd_sc_hd__decap_3
XFILLER_47_172 VPWR VGND VPWR VGND sky130_fd_sc_hd__decap_3
XFILLER_47_161 VPWR VGND VPWR VGND sky130_fd_sc_hd__decap_3
XFILLER_62_153 VPWR VGND VPWR VGND sky130_fd_sc_hd__decap_3
XFILLER_50_315 VPWR VGND VPWR VGND sky130_fd_sc_hd__decap_3
XFILLER_50_304 VPWR VGND VPWR VGND sky130_fd_sc_hd__decap_3
XFILLER_35_367 VPWR VGND VPWR VGND sky130_fd_sc_hd__decap_3
XFILLER_62_197 VPWR VGND VPWR VGND sky130_fd_sc_hd__decap_3
XFILLER_62_186 VPWR VGND VPWR VGND sky130_fd_sc_hd__decap_3
XFILLER_50_348 VPWR VGND VPWR VGND sky130_fd_sc_hd__decap_3
XFILLER_58_404 VPWR VGND VPWR VGND sky130_fd_sc_hd__decap_3
XFILLER_26_301 VPWR VGND VPWR VGND sky130_fd_sc_hd__decap_3
XFILLER_26_312 VPWR VGND VPWR VGND sky130_fd_sc_hd__decap_3
XFILLER_38_150 VPWR VGND VPWR VGND sky130_fd_sc_hd__decap_3
XFILLER_45_109 VPWR VGND VPWR VGND sky130_fd_sc_hd__decap_3
XFILLER_26_345 VPWR VGND VPWR VGND sky130_fd_sc_hd__decap_3
XFILLER_38_183 VPWR VGND VPWR VGND sky130_fd_sc_hd__decap_3
XFILLER_53_131 VPWR VGND VPWR VGND sky130_fd_sc_hd__decap_3
XFILLER_26_389 VPWR VGND VPWR VGND sky130_fd_sc_hd__decap_3
XFILLER_53_175 VPWR VGND VPWR VGND sky130_fd_sc_hd__decap_3
XFILLER_53_164 VPWR VGND VPWR VGND sky130_fd_sc_hd__decap_3
XFILLER_41_337 VPWR VGND VPWR VGND sky130_fd_sc_hd__decap_3
XFILLER_41_326 VPWR VGND VPWR VGND sky130_fd_sc_hd__decap_3
XFILLER_14_77 VPWR VGND VPWR VGND sky130_fd_sc_hd__decap_3
XFILLER_14_88 VPWR VGND VPWR VGND sky130_fd_sc_hd__decap_3
XFILLER_30_21 VPWR VGND VPWR VGND sky130_fd_sc_hd__decap_3
XFILLER_30_32 VPWR VGND VPWR VGND sky130_fd_sc_hd__decap_3
XFILLER_1_400 VPWR VGND VPWR VGND sky130_fd_sc_hd__decap_3
XFILLER_30_76 VPWR VGND VPWR VGND sky130_fd_sc_hd__decap_3
XFILLER_39_41 VPWR VGND VPWR VGND sky130_fd_sc_hd__decap_3
XFILLER_39_63 VPWR VGND VPWR VGND sky130_fd_sc_hd__decap_3
XFILLER_39_96 VPWR VGND VPWR VGND sky130_fd_sc_hd__decap_3
XFILLER_29_172 VPWR VGND VPWR VGND sky130_fd_sc_hd__decap_3
XFILLER_29_161 VPWR VGND VPWR VGND sky130_fd_sc_hd__decap_3
XFILLER_17_334 VPWR VGND VPWR VGND sky130_fd_sc_hd__decap_3
XFILLER_55_40 VPWR VGND VPWR VGND sky130_fd_sc_hd__decap_3
XFILLER_17_367 VPWR VGND VPWR VGND sky130_fd_sc_hd__decap_3
XFILLER_32_304 VPWR VGND VPWR VGND sky130_fd_sc_hd__decap_3
XFILLER_55_84 VPWR VGND VPWR VGND sky130_fd_sc_hd__decap_3
XFILLER_44_153 VPWR VGND VPWR VGND sky130_fd_sc_hd__decap_3
XFILLER_32_315 VPWR VGND VPWR VGND sky130_fd_sc_hd__decap_3
XFILLER_32_348 VPWR VGND VPWR VGND sky130_fd_sc_hd__decap_3
XFILLER_44_186 VPWR VGND VPWR VGND sky130_fd_sc_hd__decap_3
XFILLER_44_197 VPWR VGND VPWR VGND sky130_fd_sc_hd__decap_3
XFILLER_40_392 VPWR VGND VPWR VGND sky130_fd_sc_hd__decap_3
XFILLER_35_131 VPWR VGND VPWR VGND sky130_fd_sc_hd__decap_3
XFILLER_35_164 VPWR VGND VPWR VGND sky130_fd_sc_hd__decap_3
XFILLER_35_175 VPWR VGND VPWR VGND sky130_fd_sc_hd__decap_3
XFILLER_23_326 VPWR VGND VPWR VGND sky130_fd_sc_hd__decap_3
XFILLER_23_337 VPWR VGND VPWR VGND sky130_fd_sc_hd__decap_3
XFILLER_50_112 VPWR VGND VPWR VGND sky130_fd_sc_hd__decap_3
XFILLER_50_156 VPWR VGND VPWR VGND sky130_fd_sc_hd__decap_3
XFILLER_31_370 VPWR VGND VPWR VGND sky130_fd_sc_hd__decap_3
XFILLER_50_189 VPWR VGND VPWR VGND sky130_fd_sc_hd__decap_3
Xpmu_inst_70 net70 pmu_inst_70/HI VPWR VGND VGND VPWR sky130_fd_sc_hd__conb_1
XFILLER_58_212 VPWR VGND VPWR VGND sky130_fd_sc_hd__decap_3
XFILLER_58_256 VPWR VGND VPWR VGND sky130_fd_sc_hd__decap_3
XFILLER_58_245 VPWR VGND VPWR VGND sky130_fd_sc_hd__decap_3
XFILLER_58_289 VPWR VGND VPWR VGND sky130_fd_sc_hd__decap_3
XFILLER_18_109 VPWR VGND VPWR VGND sky130_fd_sc_hd__decap_3
XFILLER_26_153 VPWR VGND VPWR VGND sky130_fd_sc_hd__decap_3
XFILLER_14_337 VPWR VGND VPWR VGND sky130_fd_sc_hd__decap_3
XFILLER_26_186 VPWR VGND VPWR VGND sky130_fd_sc_hd__decap_3
XFILLER_26_197 VPWR VGND VPWR VGND sky130_fd_sc_hd__decap_3
XFILLER_25_76 VPWR VGND VPWR VGND sky130_fd_sc_hd__decap_3
XFILLER_41_134 VPWR VGND VPWR VGND sky130_fd_sc_hd__decap_3
X_261_ VGND VPWR VPWR VGND clknet_2_1__leaf_clk_regs genblk1\[6\].fa_inst.s _006_
+ net51 _261_/a_1462_47# _261_/a_543_47# _261_/a_651_413# _261_/a_193_47# _261_/a_805_47#
+ _261_/a_448_47# _261_/a_639_47# _261_/a_1283_21# _261_/a_761_289# _261_/a_1108_47#
+ _261_/a_1217_47# _261_/a_1270_413# _261_/a_27_47# sky130_fd_sc_hd__dfrtp_1
XPHY_EDGE_ROW_19_2_Left_40 VPWR VGND VPWR VGND sky130_fd_sc_hd__decap_3
XFILLER_41_178 VPWR VGND VPWR VGND sky130_fd_sc_hd__decap_3
XFILLER_22_392 VPWR VGND VPWR VGND sky130_fd_sc_hd__decap_3
X_192_ VPWR VGND VGND VPWR _101_ _103_ _102_ _192_/a_113_47# sky130_fd_sc_hd__nand2_1
XFILLER_41_75 VPWR VGND VPWR VGND sky130_fd_sc_hd__decap_3
XFILLER_2_47 VPWR VGND VPWR VGND sky130_fd_sc_hd__decap_3
XFILLER_49_234 VPWR VGND VPWR VGND sky130_fd_sc_hd__decap_3
XFILLER_64_215 VPWR VGND VPWR VGND sky130_fd_sc_hd__decap_3
XFILLER_49_267 VPWR VGND VPWR VGND sky130_fd_sc_hd__decap_3
XFILLER_64_259 VPWR VGND VPWR VGND sky130_fd_sc_hd__decap_3
XFILLER_64_237 VPWR VGND VPWR VGND sky130_fd_sc_hd__decap_3
XFILLER_17_131 VPWR VGND VPWR VGND sky130_fd_sc_hd__decap_3
XFILLER_17_164 VPWR VGND VPWR VGND sky130_fd_sc_hd__decap_3
XFILLER_17_175 VPWR VGND VPWR VGND sky130_fd_sc_hd__decap_3
XFILLER_32_123 VPWR VGND VPWR VGND sky130_fd_sc_hd__decap_3
XFILLER_13_370 VPWR VGND VPWR VGND sky130_fd_sc_hd__decap_3
XFILLER_32_178 VPWR VGND VPWR VGND sky130_fd_sc_hd__decap_3
XFILLER_9_352 VPWR VGND VPWR VGND sky130_fd_sc_hd__decap_3
XFILLER_9_385 VPWR VGND VPWR VGND sky130_fd_sc_hd__decap_3
XFILLER_55_237 VPWR VGND VPWR VGND sky130_fd_sc_hd__decap_3
XFILLER_63_281 VPWR VGND VPWR VGND sky130_fd_sc_hd__decap_3
XFILLER_63_270 VPWR VGND VPWR VGND sky130_fd_sc_hd__decap_3
XFILLER_23_134 VPWR VGND VPWR VGND sky130_fd_sc_hd__decap_3
XPHY_EDGE_ROW_43_Left_149 VPWR VGND VPWR VGND sky130_fd_sc_hd__decap_3
XFILLER_23_178 VPWR VGND VPWR VGND sky130_fd_sc_hd__decap_3
XPHY_EDGE_ROW_59_Right_80 VPWR VGND VPWR VGND sky130_fd_sc_hd__decap_3
XFILLER_11_12 VPWR VGND VPWR VGND sky130_fd_sc_hd__decap_3
XFILLER_11_45 VPWR VGND VPWR VGND sky130_fd_sc_hd__decap_3
XFILLER_11_89 VPWR VGND VPWR VGND sky130_fd_sc_hd__decap_3
XPHY_EDGE_ROW_52_Left_158 VPWR VGND VPWR VGND sky130_fd_sc_hd__decap_3
XFILLER_46_215 VPWR VGND VPWR VGND sky130_fd_sc_hd__decap_3
XFILLER_46_248 VPWR VGND VPWR VGND sky130_fd_sc_hd__decap_3
XFILLER_36_42 VPWR VGND VPWR VGND sky130_fd_sc_hd__decap_3
XFILLER_46_259 VPWR VGND VPWR VGND sky130_fd_sc_hd__decap_3
XPHY_EDGE_ROW_61_Left_167 VPWR VGND VPWR VGND sky130_fd_sc_hd__decap_3
XFILLER_14_112 VPWR VGND VPWR VGND sky130_fd_sc_hd__decap_3
XFILLER_36_75 VPWR VGND VPWR VGND sky130_fd_sc_hd__decap_3
XFILLER_54_292 VPWR VGND VPWR VGND sky130_fd_sc_hd__decap_3
XFILLER_14_156 VPWR VGND VPWR VGND sky130_fd_sc_hd__decap_3
XFILLER_52_41 VPWR VGND VPWR VGND sky130_fd_sc_hd__decap_3
X_244_ net62 _039_ VPWR VGND VPWR VGND sky130_fd_sc_hd__inv_2
XFILLER_52_85 VPWR VGND VPWR VGND sky130_fd_sc_hd__decap_3
XFILLER_10_340 VPWR VGND VPWR VGND sky130_fd_sc_hd__decap_3
Xinput17 VGND VPWR net17 b[0] VPWR VGND input17/a_27_47# sky130_fd_sc_hd__buf_1
Xinput28 VGND VPWR net28 b[5] VPWR VGND input28/a_75_212# sky130_fd_sc_hd__clkbuf_1
XFILLER_10_384 VPWR VGND VPWR VGND sky130_fd_sc_hd__decap_3
X_175_ VPWR VGND VGND VPWR _089_ genblk1\[10\].fa_inst.b genblk1\[10\].fa_inst.a _175_/a_150_297#
+ _175_/a_68_297# sky130_fd_sc_hd__or2_1
XFILLER_6_366 VPWR VGND VPWR VGND sky130_fd_sc_hd__decap_3
XFILLER_6_399 VPWR VGND VPWR VGND sky130_fd_sc_hd__decap_3
XFILLER_28_6 VPWR VGND VPWR VGND sky130_fd_sc_hd__decap_3
XFILLER_37_237 VPWR VGND VPWR VGND sky130_fd_sc_hd__decap_3
XFILLER_45_270 VPWR VGND VPWR VGND sky130_fd_sc_hd__decap_3
XFILLER_45_281 VPWR VGND VPWR VGND sky130_fd_sc_hd__decap_3
XFILLER_52_218 VPWR VGND VPWR VGND sky130_fd_sc_hd__decap_3
XFILLER_60_262 VPWR VGND VPWR VGND sky130_fd_sc_hd__decap_3
XFILLER_60_295 VPWR VGND VPWR VGND sky130_fd_sc_hd__decap_3
XFILLER_20_126 VPWR VGND VPWR VGND sky130_fd_sc_hd__decap_3
XFILLER_20_159 VPWR VGND VPWR VGND sky130_fd_sc_hd__decap_3
XFILLER_28_215 VPWR VGND VPWR VGND sky130_fd_sc_hd__decap_3
XFILLER_28_248 VPWR VGND VPWR VGND sky130_fd_sc_hd__decap_3
XFILLER_28_259 VPWR VGND VPWR VGND sky130_fd_sc_hd__decap_3
XFILLER_36_292 VPWR VGND VPWR VGND sky130_fd_sc_hd__decap_3
XFILLER_51_240 VPWR VGND VPWR VGND sky130_fd_sc_hd__decap_3
XFILLER_11_104 VPWR VGND VPWR VGND sky130_fd_sc_hd__decap_3
XFILLER_51_273 VPWR VGND VPWR VGND sky130_fd_sc_hd__decap_3
XFILLER_11_137 VPWR VGND VPWR VGND sky130_fd_sc_hd__decap_3
XFILLER_51_284 VPWR VGND VPWR VGND sky130_fd_sc_hd__decap_3
XFILLER_7_119 VPWR VGND VPWR VGND sky130_fd_sc_hd__decap_3
XFILLER_22_44 VPWR VGND VPWR VGND sky130_fd_sc_hd__decap_3
XFILLER_22_88 VPWR VGND VPWR VGND sky130_fd_sc_hd__decap_3
XFILLER_3_358 VPWR VGND VPWR VGND sky130_fd_sc_hd__decap_3
XFILLER_59_340 VPWR VGND VPWR VGND sky130_fd_sc_hd__decap_3
XFILLER_59_373 VPWR VGND VPWR VGND sky130_fd_sc_hd__decap_3
XFILLER_47_30 VPWR VGND VPWR VGND sky130_fd_sc_hd__decap_3
XFILLER_47_63 VPWR VGND VPWR VGND sky130_fd_sc_hd__decap_3
XFILLER_47_96 VPWR VGND VPWR VGND sky130_fd_sc_hd__decap_3
XFILLER_27_270 VPWR VGND VPWR VGND sky130_fd_sc_hd__decap_3
XFILLER_34_218 VPWR VGND VPWR VGND sky130_fd_sc_hd__decap_3
XFILLER_63_40 VPWR VGND VPWR VGND sky130_fd_sc_hd__decap_3
XFILLER_27_281 VPWR VGND VPWR VGND sky130_fd_sc_hd__decap_3
XFILLER_63_84 VPWR VGND VPWR VGND sky130_fd_sc_hd__decap_3
XFILLER_42_262 VPWR VGND VPWR VGND sky130_fd_sc_hd__decap_3
XFILLER_42_295 VPWR VGND VPWR VGND sky130_fd_sc_hd__decap_3
XFILLER_8_24 VPWR VGND VPWR VGND sky130_fd_sc_hd__decap_3
XFILLER_8_35 VPWR VGND VPWR VGND sky130_fd_sc_hd__decap_3
XFILLER_8_68 VPWR VGND VPWR VGND sky130_fd_sc_hd__decap_3
X_227_ net58 _022_ VPWR VGND VPWR VGND sky130_fd_sc_hd__inv_2
XFILLER_6_141 VPWR VGND VPWR VGND sky130_fd_sc_hd__decap_3
XFILLER_6_130 VPWR VGND VPWR VGND sky130_fd_sc_hd__decap_3
X_158_ VGND VPWR VGND VPWR _076_ _072_ _069_ _070_ _158_/a_215_297# _158_/a_27_413#
+ _158_/a_298_297# _158_/a_382_47# sky130_fd_sc_hd__a21bo_1
XFILLER_6_174 VPWR VGND VPWR VGND sky130_fd_sc_hd__decap_3
XFILLER_33_240 VPWR VGND VPWR VGND sky130_fd_sc_hd__decap_3
XFILLER_33_273 VPWR VGND VPWR VGND sky130_fd_sc_hd__decap_3
XFILLER_33_284 VPWR VGND VPWR VGND sky130_fd_sc_hd__decap_3
XFILLER_56_321 VPWR VGND VPWR VGND sky130_fd_sc_hd__decap_3
XFILLER_56_365 VPWR VGND VPWR VGND sky130_fd_sc_hd__decap_3
XFILLER_56_354 VPWR VGND VPWR VGND sky130_fd_sc_hd__decap_3
XFILLER_56_398 VPWR VGND VPWR VGND sky130_fd_sc_hd__decap_3
XFILLER_17_44 VPWR VGND VPWR VGND sky130_fd_sc_hd__decap_3
XFILLER_17_88 VPWR VGND VPWR VGND sky130_fd_sc_hd__decap_3
XFILLER_12_402 VPWR VGND VPWR VGND sky130_fd_sc_hd__decap_3
XFILLER_24_262 VPWR VGND VPWR VGND sky130_fd_sc_hd__decap_3
XFILLER_24_295 VPWR VGND VPWR VGND sky130_fd_sc_hd__decap_3
XFILLER_33_98 VPWR VGND VPWR VGND sky130_fd_sc_hd__decap_3
XFILLER_3_122 VPWR VGND VPWR VGND sky130_fd_sc_hd__decap_3
XFILLER_3_155 VPWR VGND VPWR VGND sky130_fd_sc_hd__decap_3
XFILLER_59_181 VPWR VGND VPWR VGND sky130_fd_sc_hd__decap_3
XFILLER_47_343 VPWR VGND VPWR VGND sky130_fd_sc_hd__decap_3
XFILLER_47_332 VPWR VGND VPWR VGND sky130_fd_sc_hd__decap_3
XPHY_EDGE_ROW_18_1_Left_124 VPWR VGND VPWR VGND sky130_fd_sc_hd__decap_3
XFILLER_62_324 VPWR VGND VPWR VGND sky130_fd_sc_hd__decap_3
XFILLER_47_376 VPWR VGND VPWR VGND sky130_fd_sc_hd__decap_3
XFILLER_62_357 VPWR VGND VPWR VGND sky130_fd_sc_hd__decap_3
XFILLER_62_368 VPWR VGND VPWR VGND sky130_fd_sc_hd__decap_3
XFILLER_30_221 VPWR VGND VPWR VGND sky130_fd_sc_hd__decap_3
XFILLER_30_265 VPWR VGND VPWR VGND sky130_fd_sc_hd__decap_3
XFILLER_30_298 VPWR VGND VPWR VGND sky130_fd_sc_hd__decap_3
XFILLER_57_107 VPWR VGND VPWR VGND sky130_fd_sc_hd__decap_3
XFILLER_38_321 VPWR VGND VPWR VGND sky130_fd_sc_hd__decap_3
XFILLER_38_354 VPWR VGND VPWR VGND sky130_fd_sc_hd__decap_3
XFILLER_38_398 VPWR VGND VPWR VGND sky130_fd_sc_hd__decap_3
XFILLER_53_302 VPWR VGND VPWR VGND sky130_fd_sc_hd__decap_3
XFILLER_38_365 VPWR VGND VPWR VGND sky130_fd_sc_hd__decap_3
XFILLER_53_346 VPWR VGND VPWR VGND sky130_fd_sc_hd__decap_3
XFILLER_53_379 VPWR VGND VPWR VGND sky130_fd_sc_hd__decap_3
XFILLER_0_91 VPWR VGND VPWR VGND sky130_fd_sc_hd__decap_3
XFILLER_21_221 VPWR VGND VPWR VGND sky130_fd_sc_hd__decap_3
XFILLER_21_287 VPWR VGND VPWR VGND sky130_fd_sc_hd__decap_3
XFILLER_0_103 VPWR VGND VPWR VGND sky130_fd_sc_hd__decap_3
XFILLER_0_125 VPWR VGND VPWR VGND sky130_fd_sc_hd__decap_3
XFILLER_0_169 VPWR VGND VPWR VGND sky130_fd_sc_hd__decap_3
XFILLER_0_147 VPWR VGND VPWR VGND sky130_fd_sc_hd__decap_3
XFILLER_28_21 VPWR VGND VPWR VGND sky130_fd_sc_hd__decap_3
XFILLER_48_129 VPWR VGND VPWR VGND sky130_fd_sc_hd__decap_3
XFILLER_28_54 VPWR VGND VPWR VGND sky130_fd_sc_hd__decap_3
XFILLER_29_332 VPWR VGND VPWR VGND sky130_fd_sc_hd__decap_3
XFILLER_29_343 VPWR VGND VPWR VGND sky130_fd_sc_hd__decap_3
XFILLER_29_376 VPWR VGND VPWR VGND sky130_fd_sc_hd__decap_3
XFILLER_56_162 VPWR VGND VPWR VGND sky130_fd_sc_hd__decap_3
XFILLER_44_357 VPWR VGND VPWR VGND sky130_fd_sc_hd__decap_3
XFILLER_44_324 VPWR VGND VPWR VGND sky130_fd_sc_hd__decap_3
XFILLER_44_368 VPWR VGND VPWR VGND sky130_fd_sc_hd__decap_3
XFILLER_44_53 VPWR VGND VPWR VGND sky130_fd_sc_hd__decap_3
XFILLER_60_74 VPWR VGND VPWR VGND sky130_fd_sc_hd__decap_3
XFILLER_60_41 VPWR VGND VPWR VGND sky130_fd_sc_hd__decap_3
XFILLER_60_85 VPWR VGND VPWR VGND sky130_fd_sc_hd__decap_3
XFILLER_10_6 VPWR VGND VPWR VGND sky130_fd_sc_hd__decap_3
XFILLER_47_140 VPWR VGND VPWR VGND sky130_fd_sc_hd__decap_3
XFILLER_35_302 VPWR VGND VPWR VGND sky130_fd_sc_hd__decap_3
XFILLER_62_121 VPWR VGND VPWR VGND sky130_fd_sc_hd__decap_3
XFILLER_35_346 VPWR VGND VPWR VGND sky130_fd_sc_hd__decap_3
XFILLER_47_184 VPWR VGND VPWR VGND sky130_fd_sc_hd__decap_3
XFILLER_62_165 VPWR VGND VPWR VGND sky130_fd_sc_hd__decap_3
XFILLER_35_379 VPWR VGND VPWR VGND sky130_fd_sc_hd__decap_3
XFILLER_50_327 VPWR VGND VPWR VGND sky130_fd_sc_hd__decap_3
XPHY_EDGE_ROW_22_Right_43 VPWR VGND VPWR VGND sky130_fd_sc_hd__decap_3
XPHY_EDGE_ROW_31_Right_52 VPWR VGND VPWR VGND sky130_fd_sc_hd__decap_3
XFILLER_38_162 VPWR VGND VPWR VGND sky130_fd_sc_hd__decap_3
XFILLER_26_324 VPWR VGND VPWR VGND sky130_fd_sc_hd__decap_3
XFILLER_41_305 VPWR VGND VPWR VGND sky130_fd_sc_hd__decap_3
XFILLER_26_357 VPWR VGND VPWR VGND sky130_fd_sc_hd__decap_3
XFILLER_26_368 VPWR VGND VPWR VGND sky130_fd_sc_hd__decap_3
XFILLER_53_143 VPWR VGND VPWR VGND sky130_fd_sc_hd__decap_3
XFILLER_41_349 VPWR VGND VPWR VGND sky130_fd_sc_hd__decap_3
XFILLER_53_187 VPWR VGND VPWR VGND sky130_fd_sc_hd__decap_3
XFILLER_14_12 VPWR VGND VPWR VGND sky130_fd_sc_hd__decap_3
XPHY_EDGE_ROW_40_Right_61 VPWR VGND VPWR VGND sky130_fd_sc_hd__decap_3
XFILLER_30_44 VPWR VGND VPWR VGND sky130_fd_sc_hd__decap_3
XFILLER_30_88 VPWR VGND VPWR VGND sky130_fd_sc_hd__decap_3
XFILLER_39_53 VPWR VGND VPWR VGND sky130_fd_sc_hd__decap_3
XFILLER_29_140 VPWR VGND VPWR VGND sky130_fd_sc_hd__decap_3
XFILLER_29_184 VPWR VGND VPWR VGND sky130_fd_sc_hd__decap_3
XFILLER_17_346 VPWR VGND VPWR VGND sky130_fd_sc_hd__decap_3
XFILLER_44_121 VPWR VGND VPWR VGND sky130_fd_sc_hd__decap_3
XFILLER_55_96 VPWR VGND VPWR VGND sky130_fd_sc_hd__decap_3
XFILLER_44_165 VPWR VGND VPWR VGND sky130_fd_sc_hd__decap_3
XFILLER_32_327 VPWR VGND VPWR VGND sky130_fd_sc_hd__decap_3
XFILLER_40_371 VPWR VGND VPWR VGND sky130_fd_sc_hd__decap_3
XFILLER_40_360 VPWR VGND VPWR VGND sky130_fd_sc_hd__decap_3
XFILLER_58_6 VPWR VGND VPWR VGND sky130_fd_sc_hd__decap_3
XFILLER_35_143 VPWR VGND VPWR VGND sky130_fd_sc_hd__decap_3
XFILLER_23_305 VPWR VGND VPWR VGND sky130_fd_sc_hd__decap_3
XFILLER_35_187 VPWR VGND VPWR VGND sky130_fd_sc_hd__decap_3
XFILLER_50_124 VPWR VGND VPWR VGND sky130_fd_sc_hd__decap_3
XFILLER_16_390 VPWR VGND VPWR VGND sky130_fd_sc_hd__decap_3
XFILLER_23_349 VPWR VGND VPWR VGND sky130_fd_sc_hd__decap_3
XFILLER_50_168 VPWR VGND VPWR VGND sky130_fd_sc_hd__decap_3
XFILLER_31_382 VPWR VGND VPWR VGND sky130_fd_sc_hd__decap_3
XFILLER_31_393 VPWR VGND VPWR VGND sky130_fd_sc_hd__decap_3
Xpmu_inst_71 net71 pmu_inst_71/HI VPWR VGND VGND VPWR sky130_fd_sc_hd__conb_1
XFILLER_58_224 VPWR VGND VPWR VGND sky130_fd_sc_hd__decap_3
XFILLER_58_268 VPWR VGND VPWR VGND sky130_fd_sc_hd__decap_3
XPHY_EDGE_ROW_11_2_Left_32 VPWR VGND VPWR VGND sky130_fd_sc_hd__decap_3
XFILLER_26_121 VPWR VGND VPWR VGND sky130_fd_sc_hd__decap_3
XFILLER_26_165 VPWR VGND VPWR VGND sky130_fd_sc_hd__decap_3
XFILLER_41_113 VPWR VGND VPWR VGND sky130_fd_sc_hd__decap_3
XFILLER_41_102 VPWR VGND VPWR VGND sky130_fd_sc_hd__decap_3
XFILLER_14_349 VPWR VGND VPWR VGND sky130_fd_sc_hd__decap_3
XFILLER_25_88 VPWR VGND VPWR VGND sky130_fd_sc_hd__decap_3
XFILLER_41_146 VPWR VGND VPWR VGND sky130_fd_sc_hd__decap_3
X_260_ VGND VPWR VPWR VGND clknet_2_0__leaf_clk_regs genblk1\[5\].fa_inst.s _005_
+ net50 _260_/a_1462_47# _260_/a_543_47# _260_/a_651_413# _260_/a_193_47# _260_/a_805_47#
+ _260_/a_448_47# _260_/a_639_47# _260_/a_1283_21# _260_/a_761_289# _260_/a_1108_47#
+ _260_/a_1217_47# _260_/a_1270_413# _260_/a_27_47# sky130_fd_sc_hd__dfrtp_1
XFILLER_22_360 VPWR VGND VPWR VGND sky130_fd_sc_hd__decap_3
XFILLER_22_371 VPWR VGND VPWR VGND sky130_fd_sc_hd__decap_3
X_191_ VPWR VGND VGND VPWR genblk1\[13\].fa_inst.b _102_ genblk1\[13\].fa_inst.a _191_/a_113_47#
+ sky130_fd_sc_hd__nand2_1
XFILLER_41_87 VPWR VGND VPWR VGND sky130_fd_sc_hd__decap_3
XFILLER_2_15 VPWR VGND VPWR VGND sky130_fd_sc_hd__decap_3
XFILLER_49_202 VPWR VGND VPWR VGND sky130_fd_sc_hd__decap_3
XFILLER_2_59 VPWR VGND VPWR VGND sky130_fd_sc_hd__decap_3
XFILLER_49_246 VPWR VGND VPWR VGND sky130_fd_sc_hd__decap_3
XFILLER_64_249 VPWR VGND VPWR VGND sky130_fd_sc_hd__decap_3
XFILLER_17_143 VPWR VGND VPWR VGND sky130_fd_sc_hd__decap_3
XFILLER_32_135 VPWR VGND VPWR VGND sky130_fd_sc_hd__decap_3
XFILLER_13_382 VPWR VGND VPWR VGND sky130_fd_sc_hd__decap_3
XFILLER_9_331 VPWR VGND VPWR VGND sky130_fd_sc_hd__decap_3
XFILLER_9_364 VPWR VGND VPWR VGND sky130_fd_sc_hd__decap_3
XFILLER_9_397 VPWR VGND VPWR VGND sky130_fd_sc_hd__decap_3
XFILLER_55_205 VPWR VGND VPWR VGND sky130_fd_sc_hd__decap_3
XFILLER_55_249 VPWR VGND VPWR VGND sky130_fd_sc_hd__decap_3
XFILLER_23_113 VPWR VGND VPWR VGND sky130_fd_sc_hd__decap_3
XFILLER_23_102 VPWR VGND VPWR VGND sky130_fd_sc_hd__decap_3
XFILLER_63_293 VPWR VGND VPWR VGND sky130_fd_sc_hd__decap_3
XFILLER_23_146 VPWR VGND VPWR VGND sky130_fd_sc_hd__decap_3
XFILLER_31_190 VPWR VGND VPWR VGND sky130_fd_sc_hd__decap_3
XFILLER_11_24 VPWR VGND VPWR VGND sky130_fd_sc_hd__decap_3
XFILLER_11_57 VPWR VGND VPWR VGND sky130_fd_sc_hd__decap_3
XFILLER_11_68 VPWR VGND VPWR VGND sky130_fd_sc_hd__decap_3
XFILLER_36_21 VPWR VGND VPWR VGND sky130_fd_sc_hd__decap_3
XFILLER_46_227 VPWR VGND VPWR VGND sky130_fd_sc_hd__decap_3
XFILLER_61_208 VPWR VGND VPWR VGND sky130_fd_sc_hd__decap_3
XFILLER_36_54 VPWR VGND VPWR VGND sky130_fd_sc_hd__decap_3
XFILLER_39_290 VPWR VGND VPWR VGND sky130_fd_sc_hd__decap_3
XFILLER_54_271 VPWR VGND VPWR VGND sky130_fd_sc_hd__decap_3
XFILLER_14_124 VPWR VGND VPWR VGND sky130_fd_sc_hd__decap_3
XFILLER_14_168 VPWR VGND VPWR VGND sky130_fd_sc_hd__decap_3
X_243_ net62 _038_ VPWR VGND VPWR VGND sky130_fd_sc_hd__inv_2
XFILLER_52_75 VPWR VGND VPWR VGND sky130_fd_sc_hd__decap_3
Xinput18 VGND VPWR net18 b[10] VPWR VGND input18/a_75_212# sky130_fd_sc_hd__clkbuf_1
XFILLER_10_363 VPWR VGND VPWR VGND sky130_fd_sc_hd__decap_3
XFILLER_6_334 VPWR VGND VPWR VGND sky130_fd_sc_hd__decap_3
X_174_ VGND VPWR _088_ genblk1\[9\].fa_inst.s _087_ VPWR VGND _174_/a_129_47# _174_/a_47_47#
+ _174_/a_285_47# _174_/a_377_297# sky130_fd_sc_hd__xnor2_1
Xinput29 VGND VPWR net29 b[6] VPWR VGND input29/a_75_212# sky130_fd_sc_hd__clkbuf_1
XFILLER_10_396 VPWR VGND VPWR VGND sky130_fd_sc_hd__decap_3
XFILLER_6_378 VPWR VGND VPWR VGND sky130_fd_sc_hd__decap_3
XFILLER_42_9 VPWR VGND VPWR VGND sky130_fd_sc_hd__decap_3
XFILLER_37_205 VPWR VGND VPWR VGND sky130_fd_sc_hd__decap_3
XFILLER_37_249 VPWR VGND VPWR VGND sky130_fd_sc_hd__decap_3
XFILLER_60_230 VPWR VGND VPWR VGND sky130_fd_sc_hd__decap_3
XFILLER_45_293 VPWR VGND VPWR VGND sky130_fd_sc_hd__decap_3
XFILLER_60_274 VPWR VGND VPWR VGND sky130_fd_sc_hd__decap_3
XFILLER_9_161 VPWR VGND VPWR VGND sky130_fd_sc_hd__decap_3
XFILLER_9_172 VPWR VGND VPWR VGND sky130_fd_sc_hd__decap_3
XFILLER_28_227 VPWR VGND VPWR VGND sky130_fd_sc_hd__decap_3
XFILLER_36_271 VPWR VGND VPWR VGND sky130_fd_sc_hd__decap_3
XFILLER_43_208 VPWR VGND VPWR VGND sky130_fd_sc_hd__decap_3
XFILLER_51_252 VPWR VGND VPWR VGND sky130_fd_sc_hd__decap_3
XFILLER_51_296 VPWR VGND VPWR VGND sky130_fd_sc_hd__decap_3
XFILLER_11_116 VPWR VGND VPWR VGND sky130_fd_sc_hd__decap_3
XFILLER_11_149 VPWR VGND VPWR VGND sky130_fd_sc_hd__decap_3
XFILLER_7_109 VPWR VGND VPWR VGND sky130_fd_sc_hd__decap_3
XFILLER_22_12 VPWR VGND VPWR VGND sky130_fd_sc_hd__decap_3
XFILLER_22_56 VPWR VGND VPWR VGND sky130_fd_sc_hd__decap_3
XFILLER_22_78 VPWR VGND VPWR VGND sky130_fd_sc_hd__decap_3
XFILLER_3_337 VPWR VGND VPWR VGND sky130_fd_sc_hd__decap_3
XFILLER_59_352 VPWR VGND VPWR VGND sky130_fd_sc_hd__decap_3
XFILLER_59_396 VPWR VGND VPWR VGND sky130_fd_sc_hd__decap_3
XFILLER_59_385 VPWR VGND VPWR VGND sky130_fd_sc_hd__decap_3
XFILLER_47_42 VPWR VGND VPWR VGND sky130_fd_sc_hd__decap_3
XFILLER_47_75 VPWR VGND VPWR VGND sky130_fd_sc_hd__decap_3
XFILLER_15_400 VPWR VGND VPWR VGND sky130_fd_sc_hd__decap_3
XFILLER_27_293 VPWR VGND VPWR VGND sky130_fd_sc_hd__decap_3
XFILLER_42_230 VPWR VGND VPWR VGND sky130_fd_sc_hd__decap_3
XFILLER_63_63 VPWR VGND VPWR VGND sky130_fd_sc_hd__decap_3
XFILLER_63_52 VPWR VGND VPWR VGND sky130_fd_sc_hd__decap_3
XFILLER_63_96 VPWR VGND VPWR VGND sky130_fd_sc_hd__decap_3
XFILLER_42_274 VPWR VGND VPWR VGND sky130_fd_sc_hd__decap_3
X_226_ net56 _021_ VPWR VGND VPWR VGND sky130_fd_sc_hd__inv_2
XFILLER_10_171 VPWR VGND VPWR VGND sky130_fd_sc_hd__decap_3
XFILLER_6_153 VPWR VGND VPWR VGND sky130_fd_sc_hd__decap_3
X_157_ VPWR VGND VGND VPWR _073_ _075_ _074_ _157_/a_113_47# sky130_fd_sc_hd__nand2_1
XFILLER_40_6 VPWR VGND VPWR VGND sky130_fd_sc_hd__decap_3
XFILLER_2_381 VPWR VGND VPWR VGND sky130_fd_sc_hd__decap_3
XFILLER_19_3 VPWR VGND VPWR VGND sky130_fd_sc_hd__decap_3
XFILLER_25_208 VPWR VGND VPWR VGND sky130_fd_sc_hd__decap_3
XFILLER_33_252 VPWR VGND VPWR VGND sky130_fd_sc_hd__decap_3
XFILLER_33_296 VPWR VGND VPWR VGND sky130_fd_sc_hd__decap_3
XFILLER_56_333 VPWR VGND VPWR VGND sky130_fd_sc_hd__decap_3
XFILLER_17_12 VPWR VGND VPWR VGND sky130_fd_sc_hd__decap_3
XFILLER_56_377 VPWR VGND VPWR VGND sky130_fd_sc_hd__decap_3
XFILLER_24_230 VPWR VGND VPWR VGND sky130_fd_sc_hd__decap_3
XFILLER_24_274 VPWR VGND VPWR VGND sky130_fd_sc_hd__decap_3
XFILLER_33_77 VPWR VGND VPWR VGND sky130_fd_sc_hd__decap_3
XFILLER_3_134 VPWR VGND VPWR VGND sky130_fd_sc_hd__decap_3
XFILLER_58_63 VPWR VGND VPWR VGND sky130_fd_sc_hd__decap_3
XFILLER_58_41 VPWR VGND VPWR VGND sky130_fd_sc_hd__decap_3
XFILLER_58_85 VPWR VGND VPWR VGND sky130_fd_sc_hd__decap_3
XFILLER_47_311 VPWR VGND VPWR VGND sky130_fd_sc_hd__decap_3
XFILLER_59_193 VPWR VGND VPWR VGND sky130_fd_sc_hd__decap_3
XFILLER_47_355 VPWR VGND VPWR VGND sky130_fd_sc_hd__decap_3
XFILLER_47_388 VPWR VGND VPWR VGND sky130_fd_sc_hd__decap_3
XFILLER_62_336 VPWR VGND VPWR VGND sky130_fd_sc_hd__decap_3
XFILLER_47_399 VPWR VGND VPWR VGND sky130_fd_sc_hd__decap_3
XFILLER_30_200 VPWR VGND VPWR VGND sky130_fd_sc_hd__decap_3
XFILLER_30_233 VPWR VGND VPWR VGND sky130_fd_sc_hd__decap_3
XFILLER_30_277 VPWR VGND VPWR VGND sky130_fd_sc_hd__decap_3
X_209_ net57 _004_ VPWR VGND VPWR VGND sky130_fd_sc_hd__inv_2
XFILLER_57_119 VPWR VGND VPWR VGND sky130_fd_sc_hd__decap_3
XFILLER_38_333 VPWR VGND VPWR VGND sky130_fd_sc_hd__decap_3
XFILLER_53_314 VPWR VGND VPWR VGND sky130_fd_sc_hd__decap_3
XFILLER_38_377 VPWR VGND VPWR VGND sky130_fd_sc_hd__decap_3
XFILLER_53_358 VPWR VGND VPWR VGND sky130_fd_sc_hd__decap_3
XFILLER_0_81 VPWR VGND VPWR VGND sky130_fd_sc_hd__decap_3
XFILLER_21_200 VPWR VGND VPWR VGND sky130_fd_sc_hd__decap_3
XFILLER_9_90 VPWR VGND VPWR VGND sky130_fd_sc_hd__decap_3
XFILLER_21_299 VPWR VGND VPWR VGND sky130_fd_sc_hd__decap_3
XFILLER_0_159 VPWR VGND VPWR VGND sky130_fd_sc_hd__decap_3
XFILLER_0_137 VPWR VGND VPWR VGND sky130_fd_sc_hd__decap_3
XFILLER_29_311 VPWR VGND VPWR VGND sky130_fd_sc_hd__decap_3
XFILLER_28_33 VPWR VGND VPWR VGND sky130_fd_sc_hd__decap_3
XFILLER_29_355 VPWR VGND VPWR VGND sky130_fd_sc_hd__decap_3
XFILLER_56_130 VPWR VGND VPWR VGND sky130_fd_sc_hd__decap_3
XFILLER_28_77 VPWR VGND VPWR VGND sky130_fd_sc_hd__decap_3
XFILLER_29_388 VPWR VGND VPWR VGND sky130_fd_sc_hd__decap_3
XFILLER_56_141 VPWR VGND VPWR VGND sky130_fd_sc_hd__decap_3
XFILLER_56_174 VPWR VGND VPWR VGND sky130_fd_sc_hd__decap_3
XFILLER_44_336 VPWR VGND VPWR VGND sky130_fd_sc_hd__decap_3
XFILLER_44_32 VPWR VGND VPWR VGND sky130_fd_sc_hd__decap_3
XFILLER_44_21 VPWR VGND VPWR VGND sky130_fd_sc_hd__decap_3
XFILLER_52_380 VPWR VGND VPWR VGND sky130_fd_sc_hd__decap_3
XFILLER_60_53 VPWR VGND VPWR VGND sky130_fd_sc_hd__decap_3
XFILLER_60_97 VPWR VGND VPWR VGND sky130_fd_sc_hd__decap_3
XFILLER_39_108 VPWR VGND VPWR VGND sky130_fd_sc_hd__decap_3
XFILLER_39_119 VPWR VGND VPWR VGND sky130_fd_sc_hd__decap_3
XFILLER_35_314 VPWR VGND VPWR VGND sky130_fd_sc_hd__decap_3
XFILLER_47_152 VPWR VGND VPWR VGND sky130_fd_sc_hd__decap_3
XFILLER_62_133 VPWR VGND VPWR VGND sky130_fd_sc_hd__decap_3
XFILLER_62_100 VPWR VGND VPWR VGND sky130_fd_sc_hd__decap_3
XFILLER_47_196 VPWR VGND VPWR VGND sky130_fd_sc_hd__decap_3
XFILLER_62_144 VPWR VGND VPWR VGND sky130_fd_sc_hd__decap_3
XFILLER_35_358 VPWR VGND VPWR VGND sky130_fd_sc_hd__decap_3
XFILLER_62_177 VPWR VGND VPWR VGND sky130_fd_sc_hd__decap_3
XFILLER_50_339 VPWR VGND VPWR VGND sky130_fd_sc_hd__decap_3
XFILLER_38_130 VPWR VGND VPWR VGND sky130_fd_sc_hd__decap_3
XFILLER_38_141 VPWR VGND VPWR VGND sky130_fd_sc_hd__decap_3
XFILLER_26_336 VPWR VGND VPWR VGND sky130_fd_sc_hd__decap_3
XFILLER_38_174 VPWR VGND VPWR VGND sky130_fd_sc_hd__decap_3
XFILLER_53_122 VPWR VGND VPWR VGND sky130_fd_sc_hd__decap_3
XFILLER_53_155 VPWR VGND VPWR VGND sky130_fd_sc_hd__decap_3
XFILLER_41_317 VPWR VGND VPWR VGND sky130_fd_sc_hd__decap_3
XFILLER_53_199 VPWR VGND VPWR VGND sky130_fd_sc_hd__decap_3
XFILLER_14_35 VPWR VGND VPWR VGND sky130_fd_sc_hd__decap_3
XFILLER_34_380 VPWR VGND VPWR VGND sky130_fd_sc_hd__decap_3
XFILLER_14_57 VPWR VGND VPWR VGND sky130_fd_sc_hd__decap_3
XFILLER_30_12 VPWR VGND VPWR VGND sky130_fd_sc_hd__decap_3
XFILLER_30_56 VPWR VGND VPWR VGND sky130_fd_sc_hd__decap_3
XFILLER_29_152 VPWR VGND VPWR VGND sky130_fd_sc_hd__decap_3
XFILLER_29_196 VPWR VGND VPWR VGND sky130_fd_sc_hd__decap_3
XFILLER_17_358 VPWR VGND VPWR VGND sky130_fd_sc_hd__decap_3
XFILLER_44_133 VPWR VGND VPWR VGND sky130_fd_sc_hd__decap_3
XFILLER_44_144 VPWR VGND VPWR VGND sky130_fd_sc_hd__decap_3
XFILLER_32_339 VPWR VGND VPWR VGND sky130_fd_sc_hd__decap_3
XFILLER_44_177 VPWR VGND VPWR VGND sky130_fd_sc_hd__decap_3
XFILLER_40_383 VPWR VGND VPWR VGND sky130_fd_sc_hd__decap_3
XPHY_EDGE_ROW_20_2_Right_106 VPWR VGND VPWR VGND sky130_fd_sc_hd__decap_3
XFILLER_35_122 VPWR VGND VPWR VGND sky130_fd_sc_hd__decap_3
XFILLER_35_155 VPWR VGND VPWR VGND sky130_fd_sc_hd__decap_3
XFILLER_23_317 VPWR VGND VPWR VGND sky130_fd_sc_hd__decap_3
XFILLER_50_103 VPWR VGND VPWR VGND sky130_fd_sc_hd__decap_3
XFILLER_35_199 VPWR VGND VPWR VGND sky130_fd_sc_hd__decap_3
XFILLER_50_136 VPWR VGND VPWR VGND sky130_fd_sc_hd__decap_3
XFILLER_50_147 VPWR VGND VPWR VGND sky130_fd_sc_hd__decap_3
XFILLER_31_361 VPWR VGND VPWR VGND sky130_fd_sc_hd__decap_3
Xpmu_inst_72 net72 pmu_inst_72/HI VPWR VGND VGND VPWR sky130_fd_sc_hd__conb_1
XFILLER_6_91 VPWR VGND VPWR VGND sky130_fd_sc_hd__decap_3
XFILLER_58_203 VPWR VGND VPWR VGND sky130_fd_sc_hd__decap_3
XFILLER_58_236 VPWR VGND VPWR VGND sky130_fd_sc_hd__decap_3
XFILLER_26_100 VPWR VGND VPWR VGND sky130_fd_sc_hd__decap_3
XFILLER_25_12 VPWR VGND VPWR VGND sky130_fd_sc_hd__decap_3
XFILLER_26_133 VPWR VGND VPWR VGND sky130_fd_sc_hd__decap_3
XFILLER_26_144 VPWR VGND VPWR VGND sky130_fd_sc_hd__decap_3
XFILLER_14_328 VPWR VGND VPWR VGND sky130_fd_sc_hd__decap_3
XFILLER_25_45 VPWR VGND VPWR VGND sky130_fd_sc_hd__decap_3
XFILLER_26_177 VPWR VGND VPWR VGND sky130_fd_sc_hd__decap_3
XFILLER_41_125 VPWR VGND VPWR VGND sky130_fd_sc_hd__decap_3
XFILLER_41_158 VPWR VGND VPWR VGND sky130_fd_sc_hd__decap_3
XFILLER_41_169 VPWR VGND VPWR VGND sky130_fd_sc_hd__decap_3
XFILLER_22_383 VPWR VGND VPWR VGND sky130_fd_sc_hd__decap_3
X_190_ VPWR VGND VGND VPWR _101_ genblk1\[13\].fa_inst.b genblk1\[13\].fa_inst.a _190_/a_150_297#
+ _190_/a_68_297# sky130_fd_sc_hd__or2_1
XFILLER_41_44 VPWR VGND VPWR VGND sky130_fd_sc_hd__decap_3
XFILLER_41_99 VPWR VGND VPWR VGND sky130_fd_sc_hd__decap_3
XFILLER_49_214 VPWR VGND VPWR VGND sky130_fd_sc_hd__decap_3
XFILLER_2_38 VPWR VGND VPWR VGND sky130_fd_sc_hd__decap_3
XFILLER_49_225 VPWR VGND VPWR VGND sky130_fd_sc_hd__decap_3
XFILLER_64_206 VPWR VGND VPWR VGND sky130_fd_sc_hd__decap_3
XFILLER_49_258 VPWR VGND VPWR VGND sky130_fd_sc_hd__decap_3
XFILLER_64_228 VPWR VGND VPWR VGND sky130_fd_sc_hd__decap_3
XFILLER_17_122 VPWR VGND VPWR VGND sky130_fd_sc_hd__decap_3
XFILLER_17_155 VPWR VGND VPWR VGND sky130_fd_sc_hd__decap_3
XFILLER_60_401 VPWR VGND VPWR VGND sky130_fd_sc_hd__decap_3
XFILLER_32_114 VPWR VGND VPWR VGND sky130_fd_sc_hd__decap_3
XFILLER_13_361 VPWR VGND VPWR VGND sky130_fd_sc_hd__decap_3
XFILLER_32_169 VPWR VGND VPWR VGND sky130_fd_sc_hd__decap_3
XFILLER_13_394 VPWR VGND VPWR VGND sky130_fd_sc_hd__decap_3
XFILLER_9_343 VPWR VGND VPWR VGND sky130_fd_sc_hd__decap_3
XFILLER_40_180 VPWR VGND VPWR VGND sky130_fd_sc_hd__decap_3
XFILLER_9_376 VPWR VGND VPWR VGND sky130_fd_sc_hd__decap_3
XFILLER_49_3 VPWR VGND VPWR VGND sky130_fd_sc_hd__decap_3
XFILLER_48_280 VPWR VGND VPWR VGND sky130_fd_sc_hd__decap_3
XFILLER_55_217 VPWR VGND VPWR VGND sky130_fd_sc_hd__decap_3
XFILLER_55_228 VPWR VGND VPWR VGND sky130_fd_sc_hd__decap_3
XFILLER_63_261 VPWR VGND VPWR VGND sky130_fd_sc_hd__decap_3
XFILLER_23_125 VPWR VGND VPWR VGND sky130_fd_sc_hd__decap_3
XFILLER_23_158 VPWR VGND VPWR VGND sky130_fd_sc_hd__decap_3
XFILLER_23_169 VPWR VGND VPWR VGND sky130_fd_sc_hd__decap_3
XFILLER_11_36 VPWR VGND VPWR VGND sky130_fd_sc_hd__decap_3
XFILLER_2_9 VPWR VGND VPWR VGND sky130_fd_sc_hd__decap_3
XFILLER_46_206 VPWR VGND VPWR VGND sky130_fd_sc_hd__decap_3
XFILLER_46_239 VPWR VGND VPWR VGND sky130_fd_sc_hd__decap_3
XFILLER_36_33 VPWR VGND VPWR VGND sky130_fd_sc_hd__decap_3
XFILLER_42_401 VPWR VGND VPWR VGND sky130_fd_sc_hd__decap_3
XFILLER_14_103 VPWR VGND VPWR VGND sky130_fd_sc_hd__decap_3
XFILLER_36_88 VPWR VGND VPWR VGND sky130_fd_sc_hd__decap_3
XFILLER_14_136 VPWR VGND VPWR VGND sky130_fd_sc_hd__decap_3
XFILLER_54_283 VPWR VGND VPWR VGND sky130_fd_sc_hd__decap_3
XFILLER_14_147 VPWR VGND VPWR VGND sky130_fd_sc_hd__decap_3
XFILLER_52_32 VPWR VGND VPWR VGND sky130_fd_sc_hd__decap_3
X_242_ net58 _037_ VPWR VGND VPWR VGND sky130_fd_sc_hd__inv_2
XFILLER_10_331 VPWR VGND VPWR VGND sky130_fd_sc_hd__decap_3
X_173_ VGND VPWR VGND VPWR _088_ _084_ _081_ _082_ _173_/a_215_297# _173_/a_27_413#
+ _173_/a_298_297# _173_/a_382_47# sky130_fd_sc_hd__a21bo_1
XFILLER_22_180 VPWR VGND VPWR VGND sky130_fd_sc_hd__decap_3
Xinput19 VGND VPWR net19 b[11] VPWR VGND input19/a_75_212# sky130_fd_sc_hd__clkbuf_1
XFILLER_10_375 VPWR VGND VPWR VGND sky130_fd_sc_hd__decap_3
XFILLER_6_357 VPWR VGND VPWR VGND sky130_fd_sc_hd__decap_3
XFILLER_6_346 VPWR VGND VPWR VGND sky130_fd_sc_hd__decap_3
XFILLER_35_9 VPWR VGND VPWR VGND sky130_fd_sc_hd__decap_3
XFILLER_37_228 VPWR VGND VPWR VGND sky130_fd_sc_hd__decap_3
XFILLER_37_217 VPWR VGND VPWR VGND sky130_fd_sc_hd__decap_3
XPHY_EDGE_ROW_5_2_Left_26 VPWR VGND VPWR VGND sky130_fd_sc_hd__decap_3
XFILLER_45_261 VPWR VGND VPWR VGND sky130_fd_sc_hd__decap_3
XFILLER_52_209 VPWR VGND VPWR VGND sky130_fd_sc_hd__decap_3
XFILLER_60_253 VPWR VGND VPWR VGND sky130_fd_sc_hd__decap_3
XFILLER_60_242 VPWR VGND VPWR VGND sky130_fd_sc_hd__decap_3
XFILLER_60_286 VPWR VGND VPWR VGND sky130_fd_sc_hd__decap_3
XFILLER_9_140 VPWR VGND VPWR VGND sky130_fd_sc_hd__decap_3
XFILLER_3_81 VPWR VGND VPWR VGND sky130_fd_sc_hd__decap_3
XFILLER_28_206 VPWR VGND VPWR VGND sky130_fd_sc_hd__decap_3
XFILLER_28_239 VPWR VGND VPWR VGND sky130_fd_sc_hd__decap_3
XFILLER_24_401 VPWR VGND VPWR VGND sky130_fd_sc_hd__decap_3
XFILLER_36_283 VPWR VGND VPWR VGND sky130_fd_sc_hd__decap_3
XFILLER_51_231 VPWR VGND VPWR VGND sky130_fd_sc_hd__decap_3
XFILLER_51_220 VPWR VGND VPWR VGND sky130_fd_sc_hd__decap_3
XFILLER_51_264 VPWR VGND VPWR VGND sky130_fd_sc_hd__decap_3
XFILLER_11_128 VPWR VGND VPWR VGND sky130_fd_sc_hd__decap_3
XFILLER_22_24 VPWR VGND VPWR VGND sky130_fd_sc_hd__decap_3
XFILLER_22_35 VPWR VGND VPWR VGND sky130_fd_sc_hd__decap_3
XFILLER_3_349 VPWR VGND VPWR VGND sky130_fd_sc_hd__decap_3
XFILLER_59_320 VPWR VGND VPWR VGND sky130_fd_sc_hd__decap_3
XFILLER_59_364 VPWR VGND VPWR VGND sky130_fd_sc_hd__decap_3
XFILLER_47_21 VPWR VGND VPWR VGND sky130_fd_sc_hd__decap_3
XFILLER_47_87 VPWR VGND VPWR VGND sky130_fd_sc_hd__decap_3
XFILLER_27_261 VPWR VGND VPWR VGND sky130_fd_sc_hd__decap_3
XFILLER_34_209 VPWR VGND VPWR VGND sky130_fd_sc_hd__decap_3
XFILLER_63_31 VPWR VGND VPWR VGND sky130_fd_sc_hd__decap_3
XFILLER_63_75 VPWR VGND VPWR VGND sky130_fd_sc_hd__decap_3
XFILLER_30_404 VPWR VGND VPWR VGND sky130_fd_sc_hd__decap_3
XFILLER_42_242 VPWR VGND VPWR VGND sky130_fd_sc_hd__decap_3
XFILLER_42_253 VPWR VGND VPWR VGND sky130_fd_sc_hd__decap_3
XFILLER_8_15 VPWR VGND VPWR VGND sky130_fd_sc_hd__decap_3
XFILLER_42_286 VPWR VGND VPWR VGND sky130_fd_sc_hd__decap_3
XFILLER_10_150 VPWR VGND VPWR VGND sky130_fd_sc_hd__decap_3
X_225_ net56 _020_ VPWR VGND VPWR VGND sky130_fd_sc_hd__inv_2
XFILLER_6_121 VPWR VGND VPWR VGND sky130_fd_sc_hd__decap_3
X_156_ VPWR VGND VGND VPWR genblk1\[6\].fa_inst.b _074_ genblk1\[6\].fa_inst.a _156_/a_113_47#
+ sky130_fd_sc_hd__nand2_1
XFILLER_6_165 VPWR VGND VPWR VGND sky130_fd_sc_hd__decap_3
XFILLER_2_393 VPWR VGND VPWR VGND sky130_fd_sc_hd__decap_3
XFILLER_2_360 VPWR VGND VPWR VGND sky130_fd_sc_hd__decap_3
XFILLER_33_6 VPWR VGND VPWR VGND sky130_fd_sc_hd__decap_3
XFILLER_33_220 VPWR VGND VPWR VGND sky130_fd_sc_hd__decap_3
XFILLER_33_231 VPWR VGND VPWR VGND sky130_fd_sc_hd__decap_3
XFILLER_33_264 VPWR VGND VPWR VGND sky130_fd_sc_hd__decap_3
XFILLER_56_312 VPWR VGND VPWR VGND sky130_fd_sc_hd__decap_3
XFILLER_56_301 VPWR VGND VPWR VGND sky130_fd_sc_hd__decap_3
XFILLER_56_345 VPWR VGND VPWR VGND sky130_fd_sc_hd__decap_3
XFILLER_56_389 VPWR VGND VPWR VGND sky130_fd_sc_hd__decap_3
XFILLER_17_35 VPWR VGND VPWR VGND sky130_fd_sc_hd__decap_3
XFILLER_17_57 VPWR VGND VPWR VGND sky130_fd_sc_hd__decap_3
XFILLER_17_79 VPWR VGND VPWR VGND sky130_fd_sc_hd__decap_3
XFILLER_24_242 VPWR VGND VPWR VGND sky130_fd_sc_hd__decap_3
XFILLER_24_253 VPWR VGND VPWR VGND sky130_fd_sc_hd__decap_3
XFILLER_33_12 VPWR VGND VPWR VGND sky130_fd_sc_hd__decap_3
XFILLER_24_286 VPWR VGND VPWR VGND sky130_fd_sc_hd__decap_3
XFILLER_33_45 VPWR VGND VPWR VGND sky130_fd_sc_hd__decap_3
XFILLER_33_89 VPWR VGND VPWR VGND sky130_fd_sc_hd__decap_3
XPHY_EDGE_ROW_49_Left_155 VPWR VGND VPWR VGND sky130_fd_sc_hd__decap_3
XFILLER_3_146 VPWR VGND VPWR VGND sky130_fd_sc_hd__decap_3
XPHY_EDGE_ROW_58_Left_164 VPWR VGND VPWR VGND sky130_fd_sc_hd__decap_3
XFILLER_59_172 VPWR VGND VPWR VGND sky130_fd_sc_hd__decap_3
XFILLER_59_150 VPWR VGND VPWR VGND sky130_fd_sc_hd__decap_3
XFILLER_58_75 VPWR VGND VPWR VGND sky130_fd_sc_hd__decap_3
XFILLER_47_323 VPWR VGND VPWR VGND sky130_fd_sc_hd__decap_3
XFILLER_62_315 VPWR VGND VPWR VGND sky130_fd_sc_hd__decap_3
XFILLER_62_304 VPWR VGND VPWR VGND sky130_fd_sc_hd__decap_3
XFILLER_47_367 VPWR VGND VPWR VGND sky130_fd_sc_hd__decap_3
XFILLER_62_348 VPWR VGND VPWR VGND sky130_fd_sc_hd__decap_3
XPHY_EDGE_ROW_0_1_Left_171 VPWR VGND VPWR VGND sky130_fd_sc_hd__decap_3
XFILLER_30_212 VPWR VGND VPWR VGND sky130_fd_sc_hd__decap_3
XFILLER_30_245 VPWR VGND VPWR VGND sky130_fd_sc_hd__decap_3
XFILLER_30_256 VPWR VGND VPWR VGND sky130_fd_sc_hd__decap_3
XFILLER_30_289 VPWR VGND VPWR VGND sky130_fd_sc_hd__decap_3
X_208_ net57 _003_ VPWR VGND VPWR VGND sky130_fd_sc_hd__inv_2
X_139_ VGND VPWR _060_ genblk1\[2\].fa_inst.s _057_ VPWR VGND _139_/a_129_47# _139_/a_47_47#
+ _139_/a_285_47# _139_/a_377_297# sky130_fd_sc_hd__xnor2_1
XFILLER_31_3 VPWR VGND VPWR VGND sky130_fd_sc_hd__decap_3
XFILLER_38_312 VPWR VGND VPWR VGND sky130_fd_sc_hd__decap_3
XFILLER_38_301 VPWR VGND VPWR VGND sky130_fd_sc_hd__decap_3
XFILLER_38_345 VPWR VGND VPWR VGND sky130_fd_sc_hd__decap_3
XFILLER_38_389 VPWR VGND VPWR VGND sky130_fd_sc_hd__decap_3
XFILLER_53_337 VPWR VGND VPWR VGND sky130_fd_sc_hd__decap_3
XFILLER_53_326 VPWR VGND VPWR VGND sky130_fd_sc_hd__decap_3
XFILLER_0_60 VPWR VGND VPWR VGND sky130_fd_sc_hd__decap_3
XFILLER_61_370 VPWR VGND VPWR VGND sky130_fd_sc_hd__decap_3
XFILLER_21_212 VPWR VGND VPWR VGND sky130_fd_sc_hd__decap_3
XFILLER_21_245 VPWR VGND VPWR VGND sky130_fd_sc_hd__decap_3
XFILLER_21_256 VPWR VGND VPWR VGND sky130_fd_sc_hd__decap_3
XFILLER_0_116 VPWR VGND VPWR VGND sky130_fd_sc_hd__decap_3
XFILLER_28_12 VPWR VGND VPWR VGND sky130_fd_sc_hd__decap_3
XFILLER_28_45 VPWR VGND VPWR VGND sky130_fd_sc_hd__decap_3
XFILLER_29_323 VPWR VGND VPWR VGND sky130_fd_sc_hd__decap_3
XFILLER_44_304 VPWR VGND VPWR VGND sky130_fd_sc_hd__decap_3
XFILLER_29_367 VPWR VGND VPWR VGND sky130_fd_sc_hd__decap_3
XFILLER_56_153 VPWR VGND VPWR VGND sky130_fd_sc_hd__decap_3
XFILLER_44_348 VPWR VGND VPWR VGND sky130_fd_sc_hd__decap_3
XFILLER_44_315 VPWR VGND VPWR VGND sky130_fd_sc_hd__decap_3
XFILLER_56_186 VPWR VGND VPWR VGND sky130_fd_sc_hd__decap_3
XFILLER_56_197 VPWR VGND VPWR VGND sky130_fd_sc_hd__decap_3
XFILLER_44_44 VPWR VGND VPWR VGND sky130_fd_sc_hd__decap_3
XFILLER_44_77 VPWR VGND VPWR VGND sky130_fd_sc_hd__decap_3
XFILLER_52_392 VPWR VGND VPWR VGND sky130_fd_sc_hd__decap_3
XFILLER_44_88 VPWR VGND VPWR VGND sky130_fd_sc_hd__decap_3
XFILLER_60_65 VPWR VGND VPWR VGND sky130_fd_sc_hd__decap_3
XFILLER_60_32 VPWR VGND VPWR VGND sky130_fd_sc_hd__decap_3
XFILLER_47_131 VPWR VGND VPWR VGND sky130_fd_sc_hd__decap_3
XFILLER_47_164 VPWR VGND VPWR VGND sky130_fd_sc_hd__decap_3
XFILLER_62_112 VPWR VGND VPWR VGND sky130_fd_sc_hd__decap_3
XFILLER_35_326 VPWR VGND VPWR VGND sky130_fd_sc_hd__decap_3
XFILLER_35_337 VPWR VGND VPWR VGND sky130_fd_sc_hd__decap_3
XFILLER_47_175 VPWR VGND VPWR VGND sky130_fd_sc_hd__decap_3
XFILLER_62_156 VPWR VGND VPWR VGND sky130_fd_sc_hd__decap_3
XFILLER_62_189 VPWR VGND VPWR VGND sky130_fd_sc_hd__decap_3
XFILLER_50_318 VPWR VGND VPWR VGND sky130_fd_sc_hd__decap_3
XFILLER_43_370 VPWR VGND VPWR VGND sky130_fd_sc_hd__decap_3
XFILLER_26_304 VPWR VGND VPWR VGND sky130_fd_sc_hd__decap_3
XFILLER_38_153 VPWR VGND VPWR VGND sky130_fd_sc_hd__decap_3
XFILLER_26_315 VPWR VGND VPWR VGND sky130_fd_sc_hd__decap_3
XFILLER_38_186 VPWR VGND VPWR VGND sky130_fd_sc_hd__decap_3
XFILLER_38_197 VPWR VGND VPWR VGND sky130_fd_sc_hd__decap_3
XFILLER_26_348 VPWR VGND VPWR VGND sky130_fd_sc_hd__decap_3
XFILLER_53_134 VPWR VGND VPWR VGND sky130_fd_sc_hd__decap_3
XFILLER_41_329 VPWR VGND VPWR VGND sky130_fd_sc_hd__decap_3
XFILLER_53_178 VPWR VGND VPWR VGND sky130_fd_sc_hd__decap_3
XFILLER_14_25 VPWR VGND VPWR VGND sky130_fd_sc_hd__decap_3
XFILLER_34_392 VPWR VGND VPWR VGND sky130_fd_sc_hd__decap_3
XPHY_EDGE_ROW_17_1_Left_123 VPWR VGND VPWR VGND sky130_fd_sc_hd__decap_3
XFILLER_30_24 VPWR VGND VPWR VGND sky130_fd_sc_hd__decap_3
XFILLER_30_35 VPWR VGND VPWR VGND sky130_fd_sc_hd__decap_3
XFILLER_30_79 VPWR VGND VPWR VGND sky130_fd_sc_hd__decap_3
XFILLER_39_44 VPWR VGND VPWR VGND sky130_fd_sc_hd__decap_3
XFILLER_39_66 VPWR VGND VPWR VGND sky130_fd_sc_hd__decap_3
XFILLER_39_99 VPWR VGND VPWR VGND sky130_fd_sc_hd__decap_3
XFILLER_29_131 VPWR VGND VPWR VGND sky130_fd_sc_hd__decap_3
XFILLER_29_175 VPWR VGND VPWR VGND sky130_fd_sc_hd__decap_3
XFILLER_29_164 VPWR VGND VPWR VGND sky130_fd_sc_hd__decap_3
XFILLER_17_337 VPWR VGND VPWR VGND sky130_fd_sc_hd__decap_3
XFILLER_55_43 VPWR VGND VPWR VGND sky130_fd_sc_hd__decap_3
XFILLER_55_87 VPWR VGND VPWR VGND sky130_fd_sc_hd__decap_3
XFILLER_44_156 VPWR VGND VPWR VGND sky130_fd_sc_hd__decap_3
XFILLER_25_370 VPWR VGND VPWR VGND sky130_fd_sc_hd__decap_3
XFILLER_32_318 VPWR VGND VPWR VGND sky130_fd_sc_hd__decap_3
XFILLER_44_189 VPWR VGND VPWR VGND sky130_fd_sc_hd__decap_3
XFILLER_40_351 VPWR VGND VPWR VGND sky130_fd_sc_hd__decap_3
XFILLER_40_395 VPWR VGND VPWR VGND sky130_fd_sc_hd__decap_3
XFILLER_35_134 VPWR VGND VPWR VGND sky130_fd_sc_hd__decap_3
XFILLER_35_178 VPWR VGND VPWR VGND sky130_fd_sc_hd__decap_3
XFILLER_23_329 VPWR VGND VPWR VGND sky130_fd_sc_hd__decap_3
XFILLER_50_115 VPWR VGND VPWR VGND sky130_fd_sc_hd__decap_3
XFILLER_16_381 VPWR VGND VPWR VGND sky130_fd_sc_hd__decap_3
XFILLER_31_340 VPWR VGND VPWR VGND sky130_fd_sc_hd__decap_3
XFILLER_50_159 VPWR VGND VPWR VGND sky130_fd_sc_hd__decap_3
XFILLER_31_373 VPWR VGND VPWR VGND sky130_fd_sc_hd__decap_3
Xpmu_inst_73 net73 pmu_inst_73/HI VPWR VGND VGND VPWR sky130_fd_sc_hd__conb_1
XFILLER_58_215 VPWR VGND VPWR VGND sky130_fd_sc_hd__decap_3
XFILLER_58_248 VPWR VGND VPWR VGND sky130_fd_sc_hd__decap_3
XFILLER_58_259 VPWR VGND VPWR VGND sky130_fd_sc_hd__decap_3
XFILLER_26_112 VPWR VGND VPWR VGND sky130_fd_sc_hd__decap_3
XFILLER_26_156 VPWR VGND VPWR VGND sky130_fd_sc_hd__decap_3
XFILLER_26_189 VPWR VGND VPWR VGND sky130_fd_sc_hd__decap_3
XFILLER_25_57 VPWR VGND VPWR VGND sky130_fd_sc_hd__decap_3
XFILLER_25_79 VPWR VGND VPWR VGND sky130_fd_sc_hd__decap_3
XFILLER_41_137 VPWR VGND VPWR VGND sky130_fd_sc_hd__decap_3
XFILLER_22_351 VPWR VGND VPWR VGND sky130_fd_sc_hd__decap_3
XFILLER_22_395 VPWR VGND VPWR VGND sky130_fd_sc_hd__decap_3
XFILLER_41_12 VPWR VGND VPWR VGND sky130_fd_sc_hd__decap_3
XFILLER_41_78 VPWR VGND VPWR VGND sky130_fd_sc_hd__decap_3
XFILLER_9_3 VPWR VGND VPWR VGND sky130_fd_sc_hd__decap_3
XFILLER_49_237 VPWR VGND VPWR VGND sky130_fd_sc_hd__decap_3
XFILLER_64_218 VPWR VGND VPWR VGND sky130_fd_sc_hd__decap_3
XFILLER_57_270 VPWR VGND VPWR VGND sky130_fd_sc_hd__decap_3
XFILLER_17_134 VPWR VGND VPWR VGND sky130_fd_sc_hd__decap_3
XFILLER_32_126 VPWR VGND VPWR VGND sky130_fd_sc_hd__decap_3
XFILLER_13_340 VPWR VGND VPWR VGND sky130_fd_sc_hd__decap_3
XFILLER_13_373 VPWR VGND VPWR VGND sky130_fd_sc_hd__decap_3
XFILLER_15_90 VPWR VGND VPWR VGND sky130_fd_sc_hd__decap_3
XFILLER_9_355 VPWR VGND VPWR VGND sky130_fd_sc_hd__decap_3
XFILLER_40_192 VPWR VGND VPWR VGND sky130_fd_sc_hd__decap_3
XFILLER_9_388 VPWR VGND VPWR VGND sky130_fd_sc_hd__decap_3
XFILLER_48_292 VPWR VGND VPWR VGND sky130_fd_sc_hd__decap_3
XFILLER_63_273 VPWR VGND VPWR VGND sky130_fd_sc_hd__decap_3
XFILLER_63_240 VPWR VGND VPWR VGND sky130_fd_sc_hd__decap_3
XFILLER_51_402 VPWR VGND VPWR VGND sky130_fd_sc_hd__decap_3
XFILLER_63_284 VPWR VGND VPWR VGND sky130_fd_sc_hd__decap_3
XFILLER_23_137 VPWR VGND VPWR VGND sky130_fd_sc_hd__decap_3
XFILLER_31_181 VPWR VGND VPWR VGND sky130_fd_sc_hd__decap_3
XFILLER_11_15 VPWR VGND VPWR VGND sky130_fd_sc_hd__decap_3
XFILLER_11_48 VPWR VGND VPWR VGND sky130_fd_sc_hd__decap_3
XPHY_EDGE_ROW_21_Left_127 VPWR VGND VPWR VGND sky130_fd_sc_hd__decap_3
XFILLER_36_12 VPWR VGND VPWR VGND sky130_fd_sc_hd__decap_3
XFILLER_39_270 VPWR VGND VPWR VGND sky130_fd_sc_hd__decap_3
XFILLER_46_218 VPWR VGND VPWR VGND sky130_fd_sc_hd__decap_3
XFILLER_36_45 VPWR VGND VPWR VGND sky130_fd_sc_hd__decap_3
XFILLER_39_281 VPWR VGND VPWR VGND sky130_fd_sc_hd__decap_3
XFILLER_36_78 VPWR VGND VPWR VGND sky130_fd_sc_hd__decap_3
XFILLER_54_262 VPWR VGND VPWR VGND sky130_fd_sc_hd__decap_3
XFILLER_54_295 VPWR VGND VPWR VGND sky130_fd_sc_hd__decap_3
XFILLER_14_115 VPWR VGND VPWR VGND sky130_fd_sc_hd__decap_3
XFILLER_14_159 VPWR VGND VPWR VGND sky130_fd_sc_hd__decap_3
X_241_ net56 _036_ VPWR VGND VPWR VGND sky130_fd_sc_hd__inv_2
XPHY_EDGE_ROW_30_Left_136 VPWR VGND VPWR VGND sky130_fd_sc_hd__decap_3
XFILLER_52_44 VPWR VGND VPWR VGND sky130_fd_sc_hd__decap_3
XFILLER_10_343 VPWR VGND VPWR VGND sky130_fd_sc_hd__decap_3
X_172_ VPWR VGND VGND VPWR _085_ _087_ _086_ _172_/a_113_47# sky130_fd_sc_hd__nand2_1
XFILLER_22_192 VPWR VGND VPWR VGND sky130_fd_sc_hd__decap_3
XFILLER_52_88 VPWR VGND VPWR VGND sky130_fd_sc_hd__decap_3
XFILLER_10_354 VPWR VGND VPWR VGND sky130_fd_sc_hd__decap_3
XFILLER_10_387 VPWR VGND VPWR VGND sky130_fd_sc_hd__decap_3
XFILLER_6_369 VPWR VGND VPWR VGND sky130_fd_sc_hd__decap_3
XFILLER_28_9 VPWR VGND VPWR VGND sky130_fd_sc_hd__decap_3
XFILLER_45_240 VPWR VGND VPWR VGND sky130_fd_sc_hd__decap_3
XFILLER_60_221 VPWR VGND VPWR VGND sky130_fd_sc_hd__decap_3
XFILLER_45_273 VPWR VGND VPWR VGND sky130_fd_sc_hd__decap_3
XFILLER_45_284 VPWR VGND VPWR VGND sky130_fd_sc_hd__decap_3
XFILLER_60_265 VPWR VGND VPWR VGND sky130_fd_sc_hd__decap_3
XFILLER_60_298 VPWR VGND VPWR VGND sky130_fd_sc_hd__decap_3
XFILLER_20_129 VPWR VGND VPWR VGND sky130_fd_sc_hd__decap_3
XFILLER_9_152 VPWR VGND VPWR VGND sky130_fd_sc_hd__decap_3
XFILLER_61_3 VPWR VGND VPWR VGND sky130_fd_sc_hd__decap_3
XFILLER_5_391 VPWR VGND VPWR VGND sky130_fd_sc_hd__decap_3
XFILLER_3_60 VPWR VGND VPWR VGND sky130_fd_sc_hd__decap_3
XFILLER_28_218 VPWR VGND VPWR VGND sky130_fd_sc_hd__decap_3
XFILLER_36_262 VPWR VGND VPWR VGND sky130_fd_sc_hd__decap_3
XFILLER_36_295 VPWR VGND VPWR VGND sky130_fd_sc_hd__decap_3
XFILLER_51_243 VPWR VGND VPWR VGND sky130_fd_sc_hd__decap_3
XFILLER_11_107 VPWR VGND VPWR VGND sky130_fd_sc_hd__decap_3
XFILLER_51_276 VPWR VGND VPWR VGND sky130_fd_sc_hd__decap_3
XFILLER_51_287 VPWR VGND VPWR VGND sky130_fd_sc_hd__decap_3
XPHY_EDGE_ROW_3_2_Right_89 VPWR VGND VPWR VGND sky130_fd_sc_hd__decap_3
XFILLER_22_47 VPWR VGND VPWR VGND sky130_fd_sc_hd__decap_3
XFILLER_22_69 VPWR VGND VPWR VGND sky130_fd_sc_hd__decap_3
XFILLER_3_328 VPWR VGND VPWR VGND sky130_fd_sc_hd__decap_3
XFILLER_59_343 VPWR VGND VPWR VGND sky130_fd_sc_hd__decap_3
XFILLER_59_332 VPWR VGND VPWR VGND sky130_fd_sc_hd__decap_3
XFILLER_59_376 VPWR VGND VPWR VGND sky130_fd_sc_hd__decap_3
XFILLER_47_66 VPWR VGND VPWR VGND sky130_fd_sc_hd__decap_3
XFILLER_27_240 VPWR VGND VPWR VGND sky130_fd_sc_hd__decap_3
XFILLER_47_99 VPWR VGND VPWR VGND sky130_fd_sc_hd__decap_3
XFILLER_63_10 VPWR VGND VPWR VGND sky130_fd_sc_hd__decap_3
XFILLER_27_273 VPWR VGND VPWR VGND sky130_fd_sc_hd__decap_3
XFILLER_27_284 VPWR VGND VPWR VGND sky130_fd_sc_hd__decap_3
XFILLER_42_221 VPWR VGND VPWR VGND sky130_fd_sc_hd__decap_3
XFILLER_63_43 VPWR VGND VPWR VGND sky130_fd_sc_hd__decap_3
XFILLER_63_87 VPWR VGND VPWR VGND sky130_fd_sc_hd__decap_3
XFILLER_42_265 VPWR VGND VPWR VGND sky130_fd_sc_hd__decap_3
XFILLER_42_298 VPWR VGND VPWR VGND sky130_fd_sc_hd__decap_3
X_224_ net56 _019_ VPWR VGND VPWR VGND sky130_fd_sc_hd__inv_2
XFILLER_8_38 VPWR VGND VPWR VGND sky130_fd_sc_hd__decap_3
XFILLER_6_100 VPWR VGND VPWR VGND sky130_fd_sc_hd__decap_3
XFILLER_10_162 VPWR VGND VPWR VGND sky130_fd_sc_hd__decap_3
XFILLER_6_144 VPWR VGND VPWR VGND sky130_fd_sc_hd__decap_3
XFILLER_6_133 VPWR VGND VPWR VGND sky130_fd_sc_hd__decap_3
X_155_ VPWR VGND VGND VPWR _073_ genblk1\[6\].fa_inst.b genblk1\[6\].fa_inst.a _155_/a_150_297#
+ _155_/a_68_297# sky130_fd_sc_hd__or2_1
XFILLER_6_177 VPWR VGND VPWR VGND sky130_fd_sc_hd__decap_3
XFILLER_12_80 VPWR VGND VPWR VGND sky130_fd_sc_hd__decap_3
XFILLER_12_91 VPWR VGND VPWR VGND sky130_fd_sc_hd__decap_3
XFILLER_2_372 VPWR VGND VPWR VGND sky130_fd_sc_hd__decap_3
XFILLER_26_6 VPWR VGND VPWR VGND sky130_fd_sc_hd__decap_3
XFILLER_33_243 VPWR VGND VPWR VGND sky130_fd_sc_hd__decap_3
XFILLER_33_276 VPWR VGND VPWR VGND sky130_fd_sc_hd__decap_3
XFILLER_33_287 VPWR VGND VPWR VGND sky130_fd_sc_hd__decap_3
XFILLER_56_324 VPWR VGND VPWR VGND sky130_fd_sc_hd__decap_3
XFILLER_56_368 VPWR VGND VPWR VGND sky130_fd_sc_hd__decap_3
XFILLER_56_357 VPWR VGND VPWR VGND sky130_fd_sc_hd__decap_3
XFILLER_17_47 VPWR VGND VPWR VGND sky130_fd_sc_hd__decap_3
XFILLER_24_221 VPWR VGND VPWR VGND sky130_fd_sc_hd__decap_3
XFILLER_24_265 VPWR VGND VPWR VGND sky130_fd_sc_hd__decap_3
XFILLER_24_298 VPWR VGND VPWR VGND sky130_fd_sc_hd__decap_3
XFILLER_3_125 VPWR VGND VPWR VGND sky130_fd_sc_hd__decap_3
XFILLER_3_169 VPWR VGND VPWR VGND sky130_fd_sc_hd__decap_3
XFILLER_3_158 VPWR VGND VPWR VGND sky130_fd_sc_hd__decap_3
XFILLER_58_21 VPWR VGND VPWR VGND sky130_fd_sc_hd__decap_3
XFILLER_58_32 VPWR VGND VPWR VGND sky130_fd_sc_hd__decap_3
XFILLER_59_162 VPWR VGND VPWR VGND sky130_fd_sc_hd__decap_3
XFILLER_47_302 VPWR VGND VPWR VGND sky130_fd_sc_hd__decap_3
XFILLER_59_184 VPWR VGND VPWR VGND sky130_fd_sc_hd__decap_3
XFILLER_47_346 VPWR VGND VPWR VGND sky130_fd_sc_hd__decap_3
XFILLER_47_379 VPWR VGND VPWR VGND sky130_fd_sc_hd__decap_3
XFILLER_62_327 VPWR VGND VPWR VGND sky130_fd_sc_hd__decap_3
XFILLER_30_224 VPWR VGND VPWR VGND sky130_fd_sc_hd__decap_3
XFILLER_30_268 VPWR VGND VPWR VGND sky130_fd_sc_hd__decap_3
X_207_ net57 _002_ VPWR VGND VPWR VGND sky130_fd_sc_hd__inv_2
X_138_ VPWR VGND VGND VPWR _058_ _060_ _059_ _138_/a_113_47# sky130_fd_sc_hd__nand2_1
XFILLER_38_324 VPWR VGND VPWR VGND sky130_fd_sc_hd__decap_3
XFILLER_53_305 VPWR VGND VPWR VGND sky130_fd_sc_hd__decap_3
XFILLER_38_368 VPWR VGND VPWR VGND sky130_fd_sc_hd__decap_3
XFILLER_38_357 VPWR VGND VPWR VGND sky130_fd_sc_hd__decap_3
XFILLER_0_50 VPWR VGND VPWR VGND sky130_fd_sc_hd__decap_3
XFILLER_53_349 VPWR VGND VPWR VGND sky130_fd_sc_hd__decap_3
XFILLER_0_94 VPWR VGND VPWR VGND sky130_fd_sc_hd__decap_3
XFILLER_0_72 VPWR VGND VPWR VGND sky130_fd_sc_hd__decap_3
XFILLER_61_393 VPWR VGND VPWR VGND sky130_fd_sc_hd__decap_3
XFILLER_61_382 VPWR VGND VPWR VGND sky130_fd_sc_hd__decap_3
XFILLER_9_81 VPWR VGND VPWR VGND sky130_fd_sc_hd__decap_3
XFILLER_0_106 VPWR VGND VPWR VGND sky130_fd_sc_hd__decap_3
XFILLER_0_128 VPWR VGND VPWR VGND sky130_fd_sc_hd__decap_3
XFILLER_29_302 VPWR VGND VPWR VGND sky130_fd_sc_hd__decap_3
XFILLER_28_24 VPWR VGND VPWR VGND sky130_fd_sc_hd__decap_3
XFILLER_28_57 VPWR VGND VPWR VGND sky130_fd_sc_hd__decap_3
XFILLER_29_346 VPWR VGND VPWR VGND sky130_fd_sc_hd__decap_3
XFILLER_56_121 VPWR VGND VPWR VGND sky130_fd_sc_hd__decap_3
XFILLER_29_379 VPWR VGND VPWR VGND sky130_fd_sc_hd__decap_3
XFILLER_56_165 VPWR VGND VPWR VGND sky130_fd_sc_hd__decap_3
XFILLER_44_327 VPWR VGND VPWR VGND sky130_fd_sc_hd__decap_3
XFILLER_44_12 VPWR VGND VPWR VGND sky130_fd_sc_hd__decap_3
XFILLER_52_371 VPWR VGND VPWR VGND sky130_fd_sc_hd__decap_3
XFILLER_52_360 VPWR VGND VPWR VGND sky130_fd_sc_hd__decap_3
XFILLER_44_56 VPWR VGND VPWR VGND sky130_fd_sc_hd__decap_3
XFILLER_60_44 VPWR VGND VPWR VGND sky130_fd_sc_hd__decap_3
XFILLER_60_88 VPWR VGND VPWR VGND sky130_fd_sc_hd__decap_3
XFILLER_60_77 VPWR VGND VPWR VGND sky130_fd_sc_hd__decap_3
XFILLER_10_9 VPWR VGND VPWR VGND sky130_fd_sc_hd__decap_3
XFILLER_35_305 VPWR VGND VPWR VGND sky130_fd_sc_hd__decap_3
XFILLER_47_143 VPWR VGND VPWR VGND sky130_fd_sc_hd__decap_3
XFILLER_47_187 VPWR VGND VPWR VGND sky130_fd_sc_hd__decap_3
XFILLER_62_124 VPWR VGND VPWR VGND sky130_fd_sc_hd__decap_3
XFILLER_35_349 VPWR VGND VPWR VGND sky130_fd_sc_hd__decap_3
XFILLER_62_168 VPWR VGND VPWR VGND sky130_fd_sc_hd__decap_3
XFILLER_43_393 VPWR VGND VPWR VGND sky130_fd_sc_hd__decap_3
XFILLER_43_382 VPWR VGND VPWR VGND sky130_fd_sc_hd__decap_3
XFILLER_38_121 VPWR VGND VPWR VGND sky130_fd_sc_hd__decap_3
XFILLER_26_327 VPWR VGND VPWR VGND sky130_fd_sc_hd__decap_3
XFILLER_38_165 VPWR VGND VPWR VGND sky130_fd_sc_hd__decap_3
XFILLER_53_113 VPWR VGND VPWR VGND sky130_fd_sc_hd__decap_3
XFILLER_53_102 VPWR VGND VPWR VGND sky130_fd_sc_hd__decap_3
XFILLER_53_146 VPWR VGND VPWR VGND sky130_fd_sc_hd__decap_3
XFILLER_41_308 VPWR VGND VPWR VGND sky130_fd_sc_hd__decap_3
XFILLER_34_360 VPWR VGND VPWR VGND sky130_fd_sc_hd__decap_3
XFILLER_14_15 VPWR VGND VPWR VGND sky130_fd_sc_hd__decap_3
XFILLER_34_371 VPWR VGND VPWR VGND sky130_fd_sc_hd__decap_3
XFILLER_61_190 VPWR VGND VPWR VGND sky130_fd_sc_hd__decap_3
XFILLER_30_47 VPWR VGND VPWR VGND sky130_fd_sc_hd__decap_3
XFILLER_39_12 VPWR VGND VPWR VGND sky130_fd_sc_hd__decap_3
XFILLER_29_143 VPWR VGND VPWR VGND sky130_fd_sc_hd__decap_3
XFILLER_29_187 VPWR VGND VPWR VGND sky130_fd_sc_hd__decap_3
XFILLER_17_349 VPWR VGND VPWR VGND sky130_fd_sc_hd__decap_3
XFILLER_44_124 VPWR VGND VPWR VGND sky130_fd_sc_hd__decap_3
XFILLER_44_168 VPWR VGND VPWR VGND sky130_fd_sc_hd__decap_3
XFILLER_55_99 VPWR VGND VPWR VGND sky130_fd_sc_hd__decap_3
XFILLER_25_382 VPWR VGND VPWR VGND sky130_fd_sc_hd__decap_3
XFILLER_25_393 VPWR VGND VPWR VGND sky130_fd_sc_hd__decap_3
XFILLER_40_330 VPWR VGND VPWR VGND sky130_fd_sc_hd__decap_3
XFILLER_40_374 VPWR VGND VPWR VGND sky130_fd_sc_hd__decap_3
XFILLER_58_9 VPWR VGND VPWR VGND sky130_fd_sc_hd__decap_3
XFILLER_20_91 VPWR VGND VPWR VGND sky130_fd_sc_hd__decap_3
XFILLER_35_113 VPWR VGND VPWR VGND sky130_fd_sc_hd__decap_3
XFILLER_35_146 VPWR VGND VPWR VGND sky130_fd_sc_hd__decap_3
XFILLER_16_360 VPWR VGND VPWR VGND sky130_fd_sc_hd__decap_3
XFILLER_23_308 VPWR VGND VPWR VGND sky130_fd_sc_hd__decap_3
XFILLER_16_393 VPWR VGND VPWR VGND sky130_fd_sc_hd__decap_3
XFILLER_50_127 VPWR VGND VPWR VGND sky130_fd_sc_hd__decap_3
XFILLER_31_352 VPWR VGND VPWR VGND sky130_fd_sc_hd__decap_3
XFILLER_43_190 VPWR VGND VPWR VGND sky130_fd_sc_hd__decap_3
XFILLER_31_385 VPWR VGND VPWR VGND sky130_fd_sc_hd__decap_3
XFILLER_31_396 VPWR VGND VPWR VGND sky130_fd_sc_hd__decap_3
Xpmu_inst_63 net63 pmu_inst_63/HI VPWR VGND VGND VPWR sky130_fd_sc_hd__conb_1
Xpmu_inst_74 net74 pmu_inst_74/HI VPWR VGND VGND VPWR sky130_fd_sc_hd__conb_1
XFILLER_58_227 VPWR VGND VPWR VGND sky130_fd_sc_hd__decap_3
XFILLER_26_124 VPWR VGND VPWR VGND sky130_fd_sc_hd__decap_3
XFILLER_25_36 VPWR VGND VPWR VGND sky130_fd_sc_hd__decap_3
XFILLER_26_168 VPWR VGND VPWR VGND sky130_fd_sc_hd__decap_3
XFILLER_41_105 VPWR VGND VPWR VGND sky130_fd_sc_hd__decap_3
XFILLER_41_116 VPWR VGND VPWR VGND sky130_fd_sc_hd__decap_3
XFILLER_22_330 VPWR VGND VPWR VGND sky130_fd_sc_hd__decap_3
XFILLER_41_149 VPWR VGND VPWR VGND sky130_fd_sc_hd__decap_3
XFILLER_22_374 VPWR VGND VPWR VGND sky130_fd_sc_hd__decap_3
XFILLER_49_205 VPWR VGND VPWR VGND sky130_fd_sc_hd__decap_3
XFILLER_2_29 VPWR VGND VPWR VGND sky130_fd_sc_hd__decap_3
XFILLER_2_18 VPWR VGND VPWR VGND sky130_fd_sc_hd__decap_3
XFILLER_49_249 VPWR VGND VPWR VGND sky130_fd_sc_hd__decap_3
XFILLER_17_113 VPWR VGND VPWR VGND sky130_fd_sc_hd__decap_3
XFILLER_17_146 VPWR VGND VPWR VGND sky130_fd_sc_hd__decap_3
XFILLER_13_352 VPWR VGND VPWR VGND sky130_fd_sc_hd__decap_3
XFILLER_25_190 VPWR VGND VPWR VGND sky130_fd_sc_hd__decap_3
XFILLER_13_385 VPWR VGND VPWR VGND sky130_fd_sc_hd__decap_3
XFILLER_9_334 VPWR VGND VPWR VGND sky130_fd_sc_hd__decap_3
XFILLER_40_171 VPWR VGND VPWR VGND sky130_fd_sc_hd__decap_3
XFILLER_9_367 VPWR VGND VPWR VGND sky130_fd_sc_hd__decap_3
XFILLER_63_7 VPWR VGND VPWR VGND sky130_fd_sc_hd__decap_3
XPHY_EDGE_ROW_8_1_Right_7 VPWR VGND VPWR VGND sky130_fd_sc_hd__decap_3
XFILLER_31_90 VPWR VGND VPWR VGND sky130_fd_sc_hd__decap_3
XFILLER_56_6 VPWR VGND VPWR VGND sky130_fd_sc_hd__decap_3
XFILLER_48_271 VPWR VGND VPWR VGND sky130_fd_sc_hd__decap_3
XFILLER_55_208 VPWR VGND VPWR VGND sky130_fd_sc_hd__decap_3
XFILLER_63_252 VPWR VGND VPWR VGND sky130_fd_sc_hd__decap_3
XFILLER_63_296 VPWR VGND VPWR VGND sky130_fd_sc_hd__decap_3
XFILLER_23_116 VPWR VGND VPWR VGND sky130_fd_sc_hd__decap_3
XFILLER_23_105 VPWR VGND VPWR VGND sky130_fd_sc_hd__decap_3
XFILLER_23_149 VPWR VGND VPWR VGND sky130_fd_sc_hd__decap_3
XFILLER_31_193 VPWR VGND VPWR VGND sky130_fd_sc_hd__decap_3
XFILLER_11_27 VPWR VGND VPWR VGND sky130_fd_sc_hd__decap_3
XFILLER_39_293 VPWR VGND VPWR VGND sky130_fd_sc_hd__decap_3
XFILLER_36_24 VPWR VGND VPWR VGND sky130_fd_sc_hd__decap_3
XFILLER_54_230 VPWR VGND VPWR VGND sky130_fd_sc_hd__decap_3
XFILLER_36_57 VPWR VGND VPWR VGND sky130_fd_sc_hd__decap_3
XFILLER_14_127 VPWR VGND VPWR VGND sky130_fd_sc_hd__decap_3
XFILLER_54_274 VPWR VGND VPWR VGND sky130_fd_sc_hd__decap_3
X_240_ net56 _035_ VPWR VGND VPWR VGND sky130_fd_sc_hd__inv_2
X_171_ VPWR VGND VGND VPWR genblk1\[9\].fa_inst.b _086_ genblk1\[9\].fa_inst.a _171_/a_113_47#
+ sky130_fd_sc_hd__nand2_1
XFILLER_22_171 VPWR VGND VPWR VGND sky130_fd_sc_hd__decap_3
XFILLER_52_78 VPWR VGND VPWR VGND sky130_fd_sc_hd__decap_3
XFILLER_10_366 VPWR VGND VPWR VGND sky130_fd_sc_hd__decap_3
XFILLER_10_399 VPWR VGND VPWR VGND sky130_fd_sc_hd__decap_3
XFILLER_6_337 VPWR VGND VPWR VGND sky130_fd_sc_hd__decap_3
XFILLER_37_208 VPWR VGND VPWR VGND sky130_fd_sc_hd__decap_3
XFILLER_45_252 VPWR VGND VPWR VGND sky130_fd_sc_hd__decap_3
XFILLER_60_200 VPWR VGND VPWR VGND sky130_fd_sc_hd__decap_3
XFILLER_45_296 VPWR VGND VPWR VGND sky130_fd_sc_hd__decap_3
XFILLER_60_233 VPWR VGND VPWR VGND sky130_fd_sc_hd__decap_3
XFILLER_60_277 VPWR VGND VPWR VGND sky130_fd_sc_hd__decap_3
XFILLER_9_131 VPWR VGND VPWR VGND sky130_fd_sc_hd__decap_3
XFILLER_9_164 VPWR VGND VPWR VGND sky130_fd_sc_hd__decap_3
XFILLER_9_175 VPWR VGND VPWR VGND sky130_fd_sc_hd__decap_3
XFILLER_5_370 VPWR VGND VPWR VGND sky130_fd_sc_hd__decap_3
XFILLER_3_72 VPWR VGND VPWR VGND sky130_fd_sc_hd__decap_3
XFILLER_36_230 VPWR VGND VPWR VGND sky130_fd_sc_hd__decap_3
XFILLER_36_274 VPWR VGND VPWR VGND sky130_fd_sc_hd__decap_3
XFILLER_51_211 VPWR VGND VPWR VGND sky130_fd_sc_hd__decap_3
XFILLER_51_255 VPWR VGND VPWR VGND sky130_fd_sc_hd__decap_3
XFILLER_11_119 VPWR VGND VPWR VGND sky130_fd_sc_hd__decap_3
XFILLER_51_299 VPWR VGND VPWR VGND sky130_fd_sc_hd__decap_3
XFILLER_22_15 VPWR VGND VPWR VGND sky130_fd_sc_hd__decap_3
XFILLER_59_311 VPWR VGND VPWR VGND sky130_fd_sc_hd__decap_3
XFILLER_59_355 VPWR VGND VPWR VGND sky130_fd_sc_hd__decap_3
XFILLER_47_12 VPWR VGND VPWR VGND sky130_fd_sc_hd__decap_3
XFILLER_59_388 VPWR VGND VPWR VGND sky130_fd_sc_hd__decap_3
XFILLER_47_45 VPWR VGND VPWR VGND sky130_fd_sc_hd__decap_3
XFILLER_59_399 VPWR VGND VPWR VGND sky130_fd_sc_hd__decap_3
XFILLER_47_78 VPWR VGND VPWR VGND sky130_fd_sc_hd__decap_3
XFILLER_27_252 VPWR VGND VPWR VGND sky130_fd_sc_hd__decap_3
XFILLER_63_22 VPWR VGND VPWR VGND sky130_fd_sc_hd__decap_3
XFILLER_15_403 VPWR VGND VPWR VGND sky130_fd_sc_hd__decap_3
XFILLER_27_296 VPWR VGND VPWR VGND sky130_fd_sc_hd__decap_3
XFILLER_42_200 VPWR VGND VPWR VGND sky130_fd_sc_hd__decap_3
XFILLER_63_66 VPWR VGND VPWR VGND sky130_fd_sc_hd__decap_3
XFILLER_42_233 VPWR VGND VPWR VGND sky130_fd_sc_hd__decap_3
XFILLER_63_99 VPWR VGND VPWR VGND sky130_fd_sc_hd__decap_3
XFILLER_42_277 VPWR VGND VPWR VGND sky130_fd_sc_hd__decap_3
X_223_ net56 _018_ VPWR VGND VPWR VGND sky130_fd_sc_hd__inv_2
XFILLER_10_141 VPWR VGND VPWR VGND sky130_fd_sc_hd__decap_3
XFILLER_10_130 VPWR VGND VPWR VGND sky130_fd_sc_hd__decap_3
XPHY_EDGE_ROW_38_Right_59 VPWR VGND VPWR VGND sky130_fd_sc_hd__decap_3
XFILLER_10_174 VPWR VGND VPWR VGND sky130_fd_sc_hd__decap_3
XFILLER_6_112 VPWR VGND VPWR VGND sky130_fd_sc_hd__decap_3
X_154_ VGND VPWR _072_ genblk1\[5\].fa_inst.s _071_ VPWR VGND _154_/a_129_47# _154_/a_47_47#
+ _154_/a_285_47# _154_/a_377_297# sky130_fd_sc_hd__xnor2_1
XFILLER_6_156 VPWR VGND VPWR VGND sky130_fd_sc_hd__decap_3
XFILLER_2_340 VPWR VGND VPWR VGND sky130_fd_sc_hd__decap_3
XFILLER_40_9 VPWR VGND VPWR VGND sky130_fd_sc_hd__decap_3
XFILLER_2_384 VPWR VGND VPWR VGND sky130_fd_sc_hd__decap_3
XPHY_EDGE_ROW_47_Right_68 VPWR VGND VPWR VGND sky130_fd_sc_hd__decap_3
XFILLER_19_6 VPWR VGND VPWR VGND sky130_fd_sc_hd__decap_3
XFILLER_33_211 VPWR VGND VPWR VGND sky130_fd_sc_hd__decap_3
XFILLER_33_255 VPWR VGND VPWR VGND sky130_fd_sc_hd__decap_3
XPHY_EDGE_ROW_56_Right_77 VPWR VGND VPWR VGND sky130_fd_sc_hd__decap_3
XFILLER_33_299 VPWR VGND VPWR VGND sky130_fd_sc_hd__decap_3
XPHY_EDGE_ROW_20_2_Left_41 VPWR VGND VPWR VGND sky130_fd_sc_hd__decap_3
XFILLER_56_336 VPWR VGND VPWR VGND sky130_fd_sc_hd__decap_3
XFILLER_64_380 VPWR VGND VPWR VGND sky130_fd_sc_hd__decap_3
XFILLER_24_200 VPWR VGND VPWR VGND sky130_fd_sc_hd__decap_3
XFILLER_24_233 VPWR VGND VPWR VGND sky130_fd_sc_hd__decap_3
XFILLER_24_277 VPWR VGND VPWR VGND sky130_fd_sc_hd__decap_3
XFILLER_33_36 VPWR VGND VPWR VGND sky130_fd_sc_hd__decap_3
XFILLER_3_137 VPWR VGND VPWR VGND sky130_fd_sc_hd__decap_3
XFILLER_58_44 VPWR VGND VPWR VGND sky130_fd_sc_hd__decap_3
XFILLER_59_141 VPWR VGND VPWR VGND sky130_fd_sc_hd__decap_3
XFILLER_58_88 VPWR VGND VPWR VGND sky130_fd_sc_hd__decap_3
XFILLER_58_66 VPWR VGND VPWR VGND sky130_fd_sc_hd__decap_3
XFILLER_59_196 VPWR VGND VPWR VGND sky130_fd_sc_hd__decap_3
XFILLER_47_314 VPWR VGND VPWR VGND sky130_fd_sc_hd__decap_3
XFILLER_47_358 VPWR VGND VPWR VGND sky130_fd_sc_hd__decap_3
XFILLER_62_339 VPWR VGND VPWR VGND sky130_fd_sc_hd__decap_3
XFILLER_30_203 VPWR VGND VPWR VGND sky130_fd_sc_hd__decap_3
XFILLER_30_236 VPWR VGND VPWR VGND sky130_fd_sc_hd__decap_3
X_206_ net57 _001_ VPWR VGND VPWR VGND sky130_fd_sc_hd__inv_2
X_137_ VPWR VGND VGND VPWR genblk1\[2\].fa_inst.b _059_ genblk1\[2\].fa_inst.a _137_/a_113_47#
+ sky130_fd_sc_hd__nand2_1
XFILLER_38_336 VPWR VGND VPWR VGND sky130_fd_sc_hd__decap_3
XFILLER_17_3 VPWR VGND VPWR VGND sky130_fd_sc_hd__decap_3
XFILLER_53_317 VPWR VGND VPWR VGND sky130_fd_sc_hd__decap_3
XFILLER_46_380 VPWR VGND VPWR VGND sky130_fd_sc_hd__decap_3
XFILLER_61_361 VPWR VGND VPWR VGND sky130_fd_sc_hd__decap_3
XFILLER_21_203 VPWR VGND VPWR VGND sky130_fd_sc_hd__decap_3
XFILLER_9_60 VPWR VGND VPWR VGND sky130_fd_sc_hd__decap_3
XFILLER_21_269 VPWR VGND VPWR VGND sky130_fd_sc_hd__decap_3
XFILLER_9_93 VPWR VGND VPWR VGND sky130_fd_sc_hd__decap_3
XFILLER_28_36 VPWR VGND VPWR VGND sky130_fd_sc_hd__decap_3
XFILLER_29_314 VPWR VGND VPWR VGND sky130_fd_sc_hd__decap_3
XFILLER_56_100 VPWR VGND VPWR VGND sky130_fd_sc_hd__decap_3
XFILLER_29_358 VPWR VGND VPWR VGND sky130_fd_sc_hd__decap_3
XFILLER_56_133 VPWR VGND VPWR VGND sky130_fd_sc_hd__decap_3
XFILLER_56_144 VPWR VGND VPWR VGND sky130_fd_sc_hd__decap_3
XFILLER_44_339 VPWR VGND VPWR VGND sky130_fd_sc_hd__decap_3
XFILLER_56_177 VPWR VGND VPWR VGND sky130_fd_sc_hd__decap_3
XFILLER_44_35 VPWR VGND VPWR VGND sky130_fd_sc_hd__decap_3
XFILLER_44_24 VPWR VGND VPWR VGND sky130_fd_sc_hd__decap_3
XFILLER_52_383 VPWR VGND VPWR VGND sky130_fd_sc_hd__decap_3
XFILLER_60_56 VPWR VGND VPWR VGND sky130_fd_sc_hd__decap_3
XFILLER_4_402 VPWR VGND VPWR VGND sky130_fd_sc_hd__decap_3
XFILLER_47_122 VPWR VGND VPWR VGND sky130_fd_sc_hd__decap_3
XFILLER_47_155 VPWR VGND VPWR VGND sky130_fd_sc_hd__decap_3
XFILLER_62_103 VPWR VGND VPWR VGND sky130_fd_sc_hd__decap_3
XFILLER_18_80 VPWR VGND VPWR VGND sky130_fd_sc_hd__decap_3
XFILLER_35_317 VPWR VGND VPWR VGND sky130_fd_sc_hd__decap_3
XFILLER_62_147 VPWR VGND VPWR VGND sky130_fd_sc_hd__decap_3
XFILLER_62_136 VPWR VGND VPWR VGND sky130_fd_sc_hd__decap_3
XFILLER_18_91 VPWR VGND VPWR VGND sky130_fd_sc_hd__decap_3
XFILLER_28_380 VPWR VGND VPWR VGND sky130_fd_sc_hd__decap_3
XFILLER_47_199 VPWR VGND VPWR VGND sky130_fd_sc_hd__decap_3
XFILLER_50_309 VPWR VGND VPWR VGND sky130_fd_sc_hd__decap_3
XFILLER_43_361 VPWR VGND VPWR VGND sky130_fd_sc_hd__decap_3
XFILLER_38_100 VPWR VGND VPWR VGND sky130_fd_sc_hd__decap_3
XFILLER_38_133 VPWR VGND VPWR VGND sky130_fd_sc_hd__decap_3
XFILLER_38_144 VPWR VGND VPWR VGND sky130_fd_sc_hd__decap_3
XFILLER_38_177 VPWR VGND VPWR VGND sky130_fd_sc_hd__decap_3
XFILLER_26_339 VPWR VGND VPWR VGND sky130_fd_sc_hd__decap_3
XFILLER_19_391 VPWR VGND VPWR VGND sky130_fd_sc_hd__decap_3
XFILLER_53_125 VPWR VGND VPWR VGND sky130_fd_sc_hd__decap_3
XFILLER_53_158 VPWR VGND VPWR VGND sky130_fd_sc_hd__decap_3
XFILLER_53_169 VPWR VGND VPWR VGND sky130_fd_sc_hd__decap_3
XFILLER_34_383 VPWR VGND VPWR VGND sky130_fd_sc_hd__decap_3
XFILLER_14_38 VPWR VGND VPWR VGND sky130_fd_sc_hd__decap_3
XFILLER_30_15 VPWR VGND VPWR VGND sky130_fd_sc_hd__decap_3
XFILLER_30_59 VPWR VGND VPWR VGND sky130_fd_sc_hd__decap_3
XFILLER_39_57 VPWR VGND VPWR VGND sky130_fd_sc_hd__decap_3
XFILLER_29_122 VPWR VGND VPWR VGND sky130_fd_sc_hd__decap_3
XFILLER_29_155 VPWR VGND VPWR VGND sky130_fd_sc_hd__decap_3
XFILLER_17_328 VPWR VGND VPWR VGND sky130_fd_sc_hd__decap_3
XFILLER_55_34 VPWR VGND VPWR VGND sky130_fd_sc_hd__decap_3
XFILLER_29_199 VPWR VGND VPWR VGND sky130_fd_sc_hd__decap_3
XFILLER_44_136 VPWR VGND VPWR VGND sky130_fd_sc_hd__decap_3
XFILLER_44_147 VPWR VGND VPWR VGND sky130_fd_sc_hd__decap_3
XFILLER_25_361 VPWR VGND VPWR VGND sky130_fd_sc_hd__decap_3
XFILLER_32_309 VPWR VGND VPWR VGND sky130_fd_sc_hd__decap_3
XFILLER_52_180 VPWR VGND VPWR VGND sky130_fd_sc_hd__decap_3
XFILLER_40_342 VPWR VGND VPWR VGND sky130_fd_sc_hd__decap_3
XFILLER_40_386 VPWR VGND VPWR VGND sky130_fd_sc_hd__decap_3
XFILLER_29_90 VPWR VGND VPWR VGND sky130_fd_sc_hd__decap_3
XFILLER_35_125 VPWR VGND VPWR VGND sky130_fd_sc_hd__decap_3
XFILLER_35_158 VPWR VGND VPWR VGND sky130_fd_sc_hd__decap_3
XFILLER_35_169 VPWR VGND VPWR VGND sky130_fd_sc_hd__decap_3
XFILLER_50_106 VPWR VGND VPWR VGND sky130_fd_sc_hd__decap_3
XFILLER_16_372 VPWR VGND VPWR VGND sky130_fd_sc_hd__decap_3
XFILLER_31_320 VPWR VGND VPWR VGND sky130_fd_sc_hd__decap_3
XFILLER_31_364 VPWR VGND VPWR VGND sky130_fd_sc_hd__decap_3
XFILLER_6_50 VPWR VGND VPWR VGND sky130_fd_sc_hd__decap_3
Xpmu_inst_64 net64 pmu_inst_64/HI VPWR VGND VGND VPWR sky130_fd_sc_hd__conb_1
XFILLER_6_94 VPWR VGND VPWR VGND sky130_fd_sc_hd__decap_3
XFILLER_58_206 VPWR VGND VPWR VGND sky130_fd_sc_hd__decap_3
XFILLER_58_239 VPWR VGND VPWR VGND sky130_fd_sc_hd__decap_3
XFILLER_54_401 VPWR VGND VPWR VGND sky130_fd_sc_hd__decap_3
XFILLER_26_103 VPWR VGND VPWR VGND sky130_fd_sc_hd__decap_3
XPHY_EDGE_ROW_0_2_Left_21 VPWR VGND VPWR VGND sky130_fd_sc_hd__decap_3
XFILLER_26_136 VPWR VGND VPWR VGND sky130_fd_sc_hd__decap_3
XFILLER_26_147 VPWR VGND VPWR VGND sky130_fd_sc_hd__decap_3
XFILLER_25_48 VPWR VGND VPWR VGND sky130_fd_sc_hd__decap_3
XFILLER_41_128 VPWR VGND VPWR VGND sky130_fd_sc_hd__decap_3
XFILLER_34_180 VPWR VGND VPWR VGND sky130_fd_sc_hd__decap_3
XFILLER_22_342 VPWR VGND VPWR VGND sky130_fd_sc_hd__decap_3
XFILLER_22_386 VPWR VGND VPWR VGND sky130_fd_sc_hd__decap_3
XFILLER_41_47 VPWR VGND VPWR VGND sky130_fd_sc_hd__decap_3
XFILLER_49_217 VPWR VGND VPWR VGND sky130_fd_sc_hd__decap_3
XFILLER_49_228 VPWR VGND VPWR VGND sky130_fd_sc_hd__decap_3
XFILLER_64_209 VPWR VGND VPWR VGND sky130_fd_sc_hd__decap_3
XFILLER_57_261 VPWR VGND VPWR VGND sky130_fd_sc_hd__decap_3
XFILLER_17_125 VPWR VGND VPWR VGND sky130_fd_sc_hd__decap_3
XFILLER_60_404 VPWR VGND VPWR VGND sky130_fd_sc_hd__decap_3
XFILLER_17_158 VPWR VGND VPWR VGND sky130_fd_sc_hd__decap_3
XFILLER_17_169 VPWR VGND VPWR VGND sky130_fd_sc_hd__decap_3
XFILLER_32_117 VPWR VGND VPWR VGND sky130_fd_sc_hd__decap_3
XFILLER_13_331 VPWR VGND VPWR VGND sky130_fd_sc_hd__decap_3
XFILLER_13_364 VPWR VGND VPWR VGND sky130_fd_sc_hd__decap_3
XFILLER_15_81 VPWR VGND VPWR VGND sky130_fd_sc_hd__decap_3
XFILLER_40_150 VPWR VGND VPWR VGND sky130_fd_sc_hd__decap_3
XFILLER_13_397 VPWR VGND VPWR VGND sky130_fd_sc_hd__decap_3
XFILLER_9_346 VPWR VGND VPWR VGND sky130_fd_sc_hd__decap_3
XFILLER_40_183 VPWR VGND VPWR VGND sky130_fd_sc_hd__decap_3
XFILLER_49_6 VPWR VGND VPWR VGND sky130_fd_sc_hd__decap_3
XPHY_EDGE_ROW_16_1_Left_122 VPWR VGND VPWR VGND sky130_fd_sc_hd__decap_3
XFILLER_36_401 VPWR VGND VPWR VGND sky130_fd_sc_hd__decap_3
XFILLER_63_220 VPWR VGND VPWR VGND sky130_fd_sc_hd__decap_3
XFILLER_48_283 VPWR VGND VPWR VGND sky130_fd_sc_hd__decap_3
XFILLER_63_264 VPWR VGND VPWR VGND sky130_fd_sc_hd__decap_3
XFILLER_63_231 VPWR VGND VPWR VGND sky130_fd_sc_hd__decap_3
XFILLER_23_128 VPWR VGND VPWR VGND sky130_fd_sc_hd__decap_3
XFILLER_31_161 VPWR VGND VPWR VGND sky130_fd_sc_hd__decap_3
XFILLER_31_172 VPWR VGND VPWR VGND sky130_fd_sc_hd__decap_3
XFILLER_8_390 VPWR VGND VPWR VGND sky130_fd_sc_hd__decap_3
XFILLER_11_39 VPWR VGND VPWR VGND sky130_fd_sc_hd__decap_3
XFILLER_39_261 VPWR VGND VPWR VGND sky130_fd_sc_hd__decap_3
XFILLER_46_209 VPWR VGND VPWR VGND sky130_fd_sc_hd__decap_3
XFILLER_36_36 VPWR VGND VPWR VGND sky130_fd_sc_hd__decap_3
XFILLER_42_404 VPWR VGND VPWR VGND sky130_fd_sc_hd__decap_3
XFILLER_54_253 VPWR VGND VPWR VGND sky130_fd_sc_hd__decap_3
XFILLER_54_242 VPWR VGND VPWR VGND sky130_fd_sc_hd__decap_3
XFILLER_14_106 VPWR VGND VPWR VGND sky130_fd_sc_hd__decap_3
XFILLER_54_286 VPWR VGND VPWR VGND sky130_fd_sc_hd__decap_3
XFILLER_22_150 VPWR VGND VPWR VGND sky130_fd_sc_hd__decap_3
XFILLER_52_35 VPWR VGND VPWR VGND sky130_fd_sc_hd__decap_3
XFILLER_10_334 VPWR VGND VPWR VGND sky130_fd_sc_hd__decap_3
X_170_ VPWR VGND VGND VPWR _085_ genblk1\[9\].fa_inst.b genblk1\[9\].fa_inst.a _170_/a_150_297#
+ _170_/a_68_297# sky130_fd_sc_hd__or2_1
XFILLER_22_183 VPWR VGND VPWR VGND sky130_fd_sc_hd__decap_3
XFILLER_10_378 VPWR VGND VPWR VGND sky130_fd_sc_hd__decap_3
XFILLER_6_349 VPWR VGND VPWR VGND sky130_fd_sc_hd__decap_3
XFILLER_45_220 VPWR VGND VPWR VGND sky130_fd_sc_hd__decap_3
XFILLER_45_231 VPWR VGND VPWR VGND sky130_fd_sc_hd__decap_3
XFILLER_60_212 VPWR VGND VPWR VGND sky130_fd_sc_hd__decap_3
XFILLER_45_264 VPWR VGND VPWR VGND sky130_fd_sc_hd__decap_3
XFILLER_60_256 VPWR VGND VPWR VGND sky130_fd_sc_hd__decap_3
XFILLER_60_245 VPWR VGND VPWR VGND sky130_fd_sc_hd__decap_3
XFILLER_26_91 VPWR VGND VPWR VGND sky130_fd_sc_hd__decap_3
XFILLER_60_289 VPWR VGND VPWR VGND sky130_fd_sc_hd__decap_3
XFILLER_13_172 VPWR VGND VPWR VGND sky130_fd_sc_hd__decap_3
XFILLER_13_161 VPWR VGND VPWR VGND sky130_fd_sc_hd__decap_3
XFILLER_9_143 VPWR VGND VPWR VGND sky130_fd_sc_hd__decap_3
X_299_ VGND VPWR VPWR VGND clknet_2_3__leaf_clk_regs net19 _044_ genblk1\[11\].fa_inst.b
+ _299_/a_1462_47# _299_/a_543_47# _299_/a_651_413# _299_/a_193_47# _299_/a_805_47#
+ _299_/a_448_47# _299_/a_639_47# _299_/a_1283_21# _299_/a_761_289# _299_/a_1108_47#
+ _299_/a_1217_47# _299_/a_1270_413# _299_/a_27_47# sky130_fd_sc_hd__dfrtp_1
XFILLER_5_382 VPWR VGND VPWR VGND sky130_fd_sc_hd__decap_3
XFILLER_47_3 VPWR VGND VPWR VGND sky130_fd_sc_hd__decap_3
XFILLER_3_84 VPWR VGND VPWR VGND sky130_fd_sc_hd__decap_3
XFILLER_28_209 VPWR VGND VPWR VGND sky130_fd_sc_hd__decap_3
XFILLER_36_253 VPWR VGND VPWR VGND sky130_fd_sc_hd__decap_3
XFILLER_36_242 VPWR VGND VPWR VGND sky130_fd_sc_hd__decap_3
XFILLER_36_286 VPWR VGND VPWR VGND sky130_fd_sc_hd__decap_3
XFILLER_24_404 VPWR VGND VPWR VGND sky130_fd_sc_hd__decap_3
XFILLER_51_234 VPWR VGND VPWR VGND sky130_fd_sc_hd__decap_3
XFILLER_51_267 VPWR VGND VPWR VGND sky130_fd_sc_hd__decap_3
XFILLER_22_38 VPWR VGND VPWR VGND sky130_fd_sc_hd__decap_3
XFILLER_0_9 VPWR VGND VPWR VGND sky130_fd_sc_hd__decap_3
XFILLER_59_323 VPWR VGND VPWR VGND sky130_fd_sc_hd__decap_3
XFILLER_59_367 VPWR VGND VPWR VGND sky130_fd_sc_hd__decap_3
XFILLER_47_24 VPWR VGND VPWR VGND sky130_fd_sc_hd__decap_3
XFILLER_47_57 VPWR VGND VPWR VGND sky130_fd_sc_hd__decap_3
XFILLER_27_231 VPWR VGND VPWR VGND sky130_fd_sc_hd__decap_3
XFILLER_27_220 VPWR VGND VPWR VGND sky130_fd_sc_hd__decap_3
XFILLER_27_264 VPWR VGND VPWR VGND sky130_fd_sc_hd__decap_3
XFILLER_42_212 VPWR VGND VPWR VGND sky130_fd_sc_hd__decap_3
XFILLER_63_34 VPWR VGND VPWR VGND sky130_fd_sc_hd__decap_3
XFILLER_42_245 VPWR VGND VPWR VGND sky130_fd_sc_hd__decap_3
XFILLER_63_78 VPWR VGND VPWR VGND sky130_fd_sc_hd__decap_3
XFILLER_42_256 VPWR VGND VPWR VGND sky130_fd_sc_hd__decap_3
X_222_ net56 _017_ VPWR VGND VPWR VGND sky130_fd_sc_hd__inv_2
XFILLER_8_18 VPWR VGND VPWR VGND sky130_fd_sc_hd__decap_3
XFILLER_8_29 VPWR VGND VPWR VGND sky130_fd_sc_hd__decap_3
XFILLER_42_289 VPWR VGND VPWR VGND sky130_fd_sc_hd__decap_3
XFILLER_10_153 VPWR VGND VPWR VGND sky130_fd_sc_hd__decap_3
XFILLER_6_124 VPWR VGND VPWR VGND sky130_fd_sc_hd__decap_3
X_153_ VGND VPWR VGND VPWR _072_ _068_ _065_ _066_ _153_/a_215_297# _153_/a_27_413#
+ _153_/a_298_297# _153_/a_382_47# sky130_fd_sc_hd__a21bo_1
XFILLER_6_168 VPWR VGND VPWR VGND sky130_fd_sc_hd__decap_3
XFILLER_12_71 VPWR VGND VPWR VGND sky130_fd_sc_hd__decap_3
XFILLER_2_363 VPWR VGND VPWR VGND sky130_fd_sc_hd__decap_3
XFILLER_33_9 VPWR VGND VPWR VGND sky130_fd_sc_hd__decap_3
XFILLER_2_396 VPWR VGND VPWR VGND sky130_fd_sc_hd__decap_3
XFILLER_33_234 VPWR VGND VPWR VGND sky130_fd_sc_hd__decap_3
XFILLER_33_267 VPWR VGND VPWR VGND sky130_fd_sc_hd__decap_3
XFILLER_56_304 VPWR VGND VPWR VGND sky130_fd_sc_hd__decap_3
XFILLER_56_315 VPWR VGND VPWR VGND sky130_fd_sc_hd__decap_3
XFILLER_56_348 VPWR VGND VPWR VGND sky130_fd_sc_hd__decap_3
XFILLER_17_38 VPWR VGND VPWR VGND sky130_fd_sc_hd__decap_3
XFILLER_24_212 VPWR VGND VPWR VGND sky130_fd_sc_hd__decap_3
XFILLER_24_245 VPWR VGND VPWR VGND sky130_fd_sc_hd__decap_3
XFILLER_24_256 VPWR VGND VPWR VGND sky130_fd_sc_hd__decap_3
XFILLER_33_48 VPWR VGND VPWR VGND sky130_fd_sc_hd__decap_3
XFILLER_24_289 VPWR VGND VPWR VGND sky130_fd_sc_hd__decap_3
XFILLER_3_116 VPWR VGND VPWR VGND sky130_fd_sc_hd__decap_3
XFILLER_3_149 VPWR VGND VPWR VGND sky130_fd_sc_hd__decap_3
XFILLER_58_12 VPWR VGND VPWR VGND sky130_fd_sc_hd__decap_3
XFILLER_59_120 VPWR VGND VPWR VGND sky130_fd_sc_hd__decap_3
XFILLER_59_153 VPWR VGND VPWR VGND sky130_fd_sc_hd__decap_3
XFILLER_58_78 VPWR VGND VPWR VGND sky130_fd_sc_hd__decap_3
XFILLER_59_175 VPWR VGND VPWR VGND sky130_fd_sc_hd__decap_3
XFILLER_47_337 VPWR VGND VPWR VGND sky130_fd_sc_hd__decap_3
XFILLER_47_326 VPWR VGND VPWR VGND sky130_fd_sc_hd__decap_3
XFILLER_62_318 VPWR VGND VPWR VGND sky130_fd_sc_hd__decap_3
XFILLER_55_370 VPWR VGND VPWR VGND sky130_fd_sc_hd__decap_3
XPHY_EDGE_ROW_27_Left_133 VPWR VGND VPWR VGND sky130_fd_sc_hd__decap_3
XFILLER_30_215 VPWR VGND VPWR VGND sky130_fd_sc_hd__decap_3
XFILLER_30_248 VPWR VGND VPWR VGND sky130_fd_sc_hd__decap_3
XFILLER_30_259 VPWR VGND VPWR VGND sky130_fd_sc_hd__decap_3
XFILLER_7_400 VPWR VGND VPWR VGND sky130_fd_sc_hd__decap_3
X_205_ VGND VPWR _112_ genblk1\[15\].fa_inst.s _110_ VPWR VGND _205_/a_129_47# _205_/a_47_47#
+ _205_/a_285_47# _205_/a_377_297# sky130_fd_sc_hd__xnor2_1
X_136_ VPWR VGND VGND VPWR _058_ genblk1\[2\].fa_inst.b genblk1\[2\].fa_inst.a _136_/a_150_297#
+ _136_/a_68_297# sky130_fd_sc_hd__or2_1
XPHY_EDGE_ROW_36_Left_142 VPWR VGND VPWR VGND sky130_fd_sc_hd__decap_3
XFILLER_2_171 VPWR VGND VPWR VGND sky130_fd_sc_hd__decap_3
XFILLER_31_6 VPWR VGND VPWR VGND sky130_fd_sc_hd__decap_3
XFILLER_38_304 VPWR VGND VPWR VGND sky130_fd_sc_hd__decap_3
XPHY_EDGE_ROW_2_2_Right_88 VPWR VGND VPWR VGND sky130_fd_sc_hd__decap_3
XFILLER_38_315 VPWR VGND VPWR VGND sky130_fd_sc_hd__decap_3
XFILLER_38_348 VPWR VGND VPWR VGND sky130_fd_sc_hd__decap_3
XPHY_EDGE_ROW_45_Left_151 VPWR VGND VPWR VGND sky130_fd_sc_hd__decap_3
XFILLER_53_329 VPWR VGND VPWR VGND sky130_fd_sc_hd__decap_3
XFILLER_0_41 VPWR VGND VPWR VGND sky130_fd_sc_hd__decap_3
XFILLER_46_392 VPWR VGND VPWR VGND sky130_fd_sc_hd__decap_3
XFILLER_0_85 VPWR VGND VPWR VGND sky130_fd_sc_hd__decap_3
XFILLER_0_63 VPWR VGND VPWR VGND sky130_fd_sc_hd__decap_3
XFILLER_61_340 VPWR VGND VPWR VGND sky130_fd_sc_hd__decap_3
XFILLER_61_373 VPWR VGND VPWR VGND sky130_fd_sc_hd__decap_3
XFILLER_21_215 VPWR VGND VPWR VGND sky130_fd_sc_hd__decap_3
XFILLER_9_72 VPWR VGND VPWR VGND sky130_fd_sc_hd__decap_3
XFILLER_21_248 VPWR VGND VPWR VGND sky130_fd_sc_hd__decap_3
XFILLER_21_259 VPWR VGND VPWR VGND sky130_fd_sc_hd__decap_3
XPHY_EDGE_ROW_54_Left_160 VPWR VGND VPWR VGND sky130_fd_sc_hd__decap_3
XFILLER_0_119 VPWR VGND VPWR VGND sky130_fd_sc_hd__decap_3
XFILLER_28_15 VPWR VGND VPWR VGND sky130_fd_sc_hd__decap_3
XFILLER_28_48 VPWR VGND VPWR VGND sky130_fd_sc_hd__decap_3
XFILLER_29_326 VPWR VGND VPWR VGND sky130_fd_sc_hd__decap_3
XFILLER_29_337 VPWR VGND VPWR VGND sky130_fd_sc_hd__decap_3
XFILLER_56_112 VPWR VGND VPWR VGND sky130_fd_sc_hd__decap_3
XFILLER_56_156 VPWR VGND VPWR VGND sky130_fd_sc_hd__decap_3
XFILLER_44_318 VPWR VGND VPWR VGND sky130_fd_sc_hd__decap_3
XFILLER_56_189 VPWR VGND VPWR VGND sky130_fd_sc_hd__decap_3
XFILLER_37_370 VPWR VGND VPWR VGND sky130_fd_sc_hd__decap_3
XFILLER_52_351 VPWR VGND VPWR VGND sky130_fd_sc_hd__decap_3
XFILLER_44_47 VPWR VGND VPWR VGND sky130_fd_sc_hd__decap_3
XFILLER_52_395 VPWR VGND VPWR VGND sky130_fd_sc_hd__decap_3
XFILLER_60_35 VPWR VGND VPWR VGND sky130_fd_sc_hd__decap_3
XFILLER_60_68 VPWR VGND VPWR VGND sky130_fd_sc_hd__decap_3
XFILLER_47_134 VPWR VGND VPWR VGND sky130_fd_sc_hd__decap_3
XFILLER_35_329 VPWR VGND VPWR VGND sky130_fd_sc_hd__decap_3
XFILLER_47_178 VPWR VGND VPWR VGND sky130_fd_sc_hd__decap_3
XFILLER_62_115 VPWR VGND VPWR VGND sky130_fd_sc_hd__decap_3
XFILLER_28_392 VPWR VGND VPWR VGND sky130_fd_sc_hd__decap_3
XFILLER_62_159 VPWR VGND VPWR VGND sky130_fd_sc_hd__decap_3
XFILLER_43_340 VPWR VGND VPWR VGND sky130_fd_sc_hd__decap_3
XFILLER_43_373 VPWR VGND VPWR VGND sky130_fd_sc_hd__decap_3
XFILLER_34_91 VPWR VGND VPWR VGND sky130_fd_sc_hd__decap_3
XFILLER_34_80 VPWR VGND VPWR VGND sky130_fd_sc_hd__decap_3
XFILLER_38_112 VPWR VGND VPWR VGND sky130_fd_sc_hd__decap_3
XFILLER_26_318 VPWR VGND VPWR VGND sky130_fd_sc_hd__decap_3
XFILLER_38_156 VPWR VGND VPWR VGND sky130_fd_sc_hd__decap_3
XFILLER_19_370 VPWR VGND VPWR VGND sky130_fd_sc_hd__decap_3
XFILLER_38_189 VPWR VGND VPWR VGND sky130_fd_sc_hd__decap_3
XFILLER_53_137 VPWR VGND VPWR VGND sky130_fd_sc_hd__decap_3
XFILLER_34_351 VPWR VGND VPWR VGND sky130_fd_sc_hd__decap_3
XFILLER_34_395 VPWR VGND VPWR VGND sky130_fd_sc_hd__decap_3
XFILLER_61_181 VPWR VGND VPWR VGND sky130_fd_sc_hd__decap_3
XFILLER_30_38 VPWR VGND VPWR VGND sky130_fd_sc_hd__decap_3
XFILLER_39_47 VPWR VGND VPWR VGND sky130_fd_sc_hd__decap_3
XFILLER_29_134 VPWR VGND VPWR VGND sky130_fd_sc_hd__decap_3
XFILLER_29_178 VPWR VGND VPWR VGND sky130_fd_sc_hd__decap_3
XFILLER_55_46 VPWR VGND VPWR VGND sky130_fd_sc_hd__decap_3
XFILLER_44_115 VPWR VGND VPWR VGND sky130_fd_sc_hd__decap_3
XFILLER_25_340 VPWR VGND VPWR VGND sky130_fd_sc_hd__decap_3
XFILLER_44_159 VPWR VGND VPWR VGND sky130_fd_sc_hd__decap_3
XFILLER_25_373 VPWR VGND VPWR VGND sky130_fd_sc_hd__decap_3
XFILLER_40_321 VPWR VGND VPWR VGND sky130_fd_sc_hd__decap_3
XFILLER_52_192 VPWR VGND VPWR VGND sky130_fd_sc_hd__decap_3
XFILLER_40_365 VPWR VGND VPWR VGND sky130_fd_sc_hd__decap_3
XFILLER_40_354 VPWR VGND VPWR VGND sky130_fd_sc_hd__decap_3
XFILLER_40_398 VPWR VGND VPWR VGND sky130_fd_sc_hd__decap_3
XFILLER_63_402 VPWR VGND VPWR VGND sky130_fd_sc_hd__decap_3
XFILLER_35_137 VPWR VGND VPWR VGND sky130_fd_sc_hd__decap_3
XFILLER_16_340 VPWR VGND VPWR VGND sky130_fd_sc_hd__decap_3
XFILLER_16_384 VPWR VGND VPWR VGND sky130_fd_sc_hd__decap_3
XFILLER_50_118 VPWR VGND VPWR VGND sky130_fd_sc_hd__decap_3
XFILLER_31_332 VPWR VGND VPWR VGND sky130_fd_sc_hd__decap_3
XFILLER_31_343 VPWR VGND VPWR VGND sky130_fd_sc_hd__decap_3
XFILLER_43_181 VPWR VGND VPWR VGND sky130_fd_sc_hd__decap_3
XFILLER_31_376 VPWR VGND VPWR VGND sky130_fd_sc_hd__decap_3
Xpmu_inst_65 net65 pmu_inst_65/HI VPWR VGND VGND VPWR sky130_fd_sc_hd__conb_1
XFILLER_6_62 VPWR VGND VPWR VGND sky130_fd_sc_hd__decap_3
XFILLER_58_218 VPWR VGND VPWR VGND sky130_fd_sc_hd__decap_3
XFILLER_26_115 VPWR VGND VPWR VGND sky130_fd_sc_hd__decap_3
XPHY_EDGE_ROW_15_2_Left_36 VPWR VGND VPWR VGND sky130_fd_sc_hd__decap_3
XFILLER_26_159 VPWR VGND VPWR VGND sky130_fd_sc_hd__decap_3
XFILLER_34_192 VPWR VGND VPWR VGND sky130_fd_sc_hd__decap_3
XFILLER_22_321 VPWR VGND VPWR VGND sky130_fd_sc_hd__decap_3
XFILLER_22_354 VPWR VGND VPWR VGND sky130_fd_sc_hd__decap_3
XFILLER_22_365 VPWR VGND VPWR VGND sky130_fd_sc_hd__decap_3
XFILLER_22_398 VPWR VGND VPWR VGND sky130_fd_sc_hd__decap_3
XFILLER_41_15 VPWR VGND VPWR VGND sky130_fd_sc_hd__decap_3
XFILLER_57_240 VPWR VGND VPWR VGND sky130_fd_sc_hd__decap_3
XFILLER_57_273 VPWR VGND VPWR VGND sky130_fd_sc_hd__decap_3
XFILLER_17_137 VPWR VGND VPWR VGND sky130_fd_sc_hd__decap_3
XFILLER_32_129 VPWR VGND VPWR VGND sky130_fd_sc_hd__decap_3
XFILLER_13_343 VPWR VGND VPWR VGND sky130_fd_sc_hd__decap_3
XFILLER_25_181 VPWR VGND VPWR VGND sky130_fd_sc_hd__decap_3
XFILLER_13_376 VPWR VGND VPWR VGND sky130_fd_sc_hd__decap_3
XFILLER_15_93 VPWR VGND VPWR VGND sky130_fd_sc_hd__decap_3
XFILLER_15_60 VPWR VGND VPWR VGND sky130_fd_sc_hd__decap_3
XFILLER_40_162 VPWR VGND VPWR VGND sky130_fd_sc_hd__decap_3
XFILLER_9_358 VPWR VGND VPWR VGND sky130_fd_sc_hd__decap_3
XFILLER_31_81 VPWR VGND VPWR VGND sky130_fd_sc_hd__decap_3
XFILLER_48_262 VPWR VGND VPWR VGND sky130_fd_sc_hd__decap_3
XFILLER_48_295 VPWR VGND VPWR VGND sky130_fd_sc_hd__decap_3
XFILLER_63_243 VPWR VGND VPWR VGND sky130_fd_sc_hd__decap_3
XFILLER_63_287 VPWR VGND VPWR VGND sky130_fd_sc_hd__decap_3
XFILLER_63_276 VPWR VGND VPWR VGND sky130_fd_sc_hd__decap_3
XFILLER_31_140 VPWR VGND VPWR VGND sky130_fd_sc_hd__decap_3
XFILLER_31_184 VPWR VGND VPWR VGND sky130_fd_sc_hd__decap_3
XFILLER_11_18 VPWR VGND VPWR VGND sky130_fd_sc_hd__decap_3
XFILLER_27_402 VPWR VGND VPWR VGND sky130_fd_sc_hd__decap_3
XFILLER_39_240 VPWR VGND VPWR VGND sky130_fd_sc_hd__decap_3
XFILLER_36_15 VPWR VGND VPWR VGND sky130_fd_sc_hd__decap_3
XFILLER_39_273 VPWR VGND VPWR VGND sky130_fd_sc_hd__decap_3
XFILLER_39_284 VPWR VGND VPWR VGND sky130_fd_sc_hd__decap_3
XFILLER_54_221 VPWR VGND VPWR VGND sky130_fd_sc_hd__decap_3
XFILLER_36_48 VPWR VGND VPWR VGND sky130_fd_sc_hd__decap_3
XFILLER_14_118 VPWR VGND VPWR VGND sky130_fd_sc_hd__decap_3
XFILLER_54_265 VPWR VGND VPWR VGND sky130_fd_sc_hd__decap_3
XFILLER_54_298 VPWR VGND VPWR VGND sky130_fd_sc_hd__decap_3
XFILLER_52_47 VPWR VGND VPWR VGND sky130_fd_sc_hd__decap_3
XFILLER_22_162 VPWR VGND VPWR VGND sky130_fd_sc_hd__decap_3
XFILLER_10_357 VPWR VGND VPWR VGND sky130_fd_sc_hd__decap_3
XFILLER_10_346 VPWR VGND VPWR VGND sky130_fd_sc_hd__decap_3
XFILLER_6_328 VPWR VGND VPWR VGND sky130_fd_sc_hd__decap_3
XFILLER_7_3 VPWR VGND VPWR VGND sky130_fd_sc_hd__decap_3
XFILLER_18_402 VPWR VGND VPWR VGND sky130_fd_sc_hd__decap_3
XFILLER_45_243 VPWR VGND VPWR VGND sky130_fd_sc_hd__decap_3
XFILLER_45_276 VPWR VGND VPWR VGND sky130_fd_sc_hd__decap_3
XFILLER_45_287 VPWR VGND VPWR VGND sky130_fd_sc_hd__decap_3
XFILLER_60_224 VPWR VGND VPWR VGND sky130_fd_sc_hd__decap_3
XFILLER_26_81 VPWR VGND VPWR VGND sky130_fd_sc_hd__decap_3
XFILLER_60_268 VPWR VGND VPWR VGND sky130_fd_sc_hd__decap_3
XFILLER_13_140 VPWR VGND VPWR VGND sky130_fd_sc_hd__decap_3
XFILLER_9_122 VPWR VGND VPWR VGND sky130_fd_sc_hd__decap_3
XFILLER_9_155 VPWR VGND VPWR VGND sky130_fd_sc_hd__decap_3
XFILLER_42_80 VPWR VGND VPWR VGND sky130_fd_sc_hd__decap_3
X_298_ VGND VPWR VPWR VGND clknet_2_2__leaf_clk_regs net18 _043_ genblk1\[10\].fa_inst.b
+ _298_/a_1462_47# _298_/a_543_47# _298_/a_651_413# _298_/a_193_47# _298_/a_805_47#
+ _298_/a_448_47# _298_/a_639_47# _298_/a_1283_21# _298_/a_761_289# _298_/a_1108_47#
+ _298_/a_1217_47# _298_/a_1270_413# _298_/a_27_47# sky130_fd_sc_hd__dfrtp_1
XFILLER_42_91 VPWR VGND VPWR VGND sky130_fd_sc_hd__decap_3
XFILLER_61_6 VPWR VGND VPWR VGND sky130_fd_sc_hd__decap_3
XFILLER_5_361 VPWR VGND VPWR VGND sky130_fd_sc_hd__decap_3
XFILLER_5_394 VPWR VGND VPWR VGND sky130_fd_sc_hd__decap_3
XFILLER_3_63 VPWR VGND VPWR VGND sky130_fd_sc_hd__decap_3
XFILLER_36_221 VPWR VGND VPWR VGND sky130_fd_sc_hd__decap_3
XFILLER_36_265 VPWR VGND VPWR VGND sky130_fd_sc_hd__decap_3
XFILLER_51_202 VPWR VGND VPWR VGND sky130_fd_sc_hd__decap_3
XFILLER_36_298 VPWR VGND VPWR VGND sky130_fd_sc_hd__decap_3
XFILLER_51_246 VPWR VGND VPWR VGND sky130_fd_sc_hd__decap_3
XFILLER_59_302 VPWR VGND VPWR VGND sky130_fd_sc_hd__decap_3
XFILLER_59_346 VPWR VGND VPWR VGND sky130_fd_sc_hd__decap_3
XFILLER_59_379 VPWR VGND VPWR VGND sky130_fd_sc_hd__decap_3
XFILLER_47_36 VPWR VGND VPWR VGND sky130_fd_sc_hd__decap_3
XFILLER_47_69 VPWR VGND VPWR VGND sky130_fd_sc_hd__decap_3
XFILLER_27_243 VPWR VGND VPWR VGND sky130_fd_sc_hd__decap_3
XFILLER_63_13 VPWR VGND VPWR VGND sky130_fd_sc_hd__decap_3
XFILLER_27_276 VPWR VGND VPWR VGND sky130_fd_sc_hd__decap_3
XFILLER_63_46 VPWR VGND VPWR VGND sky130_fd_sc_hd__decap_3
XFILLER_63_57 VPWR VGND VPWR VGND sky130_fd_sc_hd__decap_3
XFILLER_27_287 VPWR VGND VPWR VGND sky130_fd_sc_hd__decap_3
XFILLER_42_224 VPWR VGND VPWR VGND sky130_fd_sc_hd__decap_3
XFILLER_42_268 VPWR VGND VPWR VGND sky130_fd_sc_hd__decap_3
X_221_ net62 _016_ VPWR VGND VPWR VGND sky130_fd_sc_hd__inv_2
XFILLER_10_121 VPWR VGND VPWR VGND sky130_fd_sc_hd__decap_3
X_152_ VPWR VGND VGND VPWR _069_ _071_ _070_ _152_/a_113_47# sky130_fd_sc_hd__nand2_1
XFILLER_10_165 VPWR VGND VPWR VGND sky130_fd_sc_hd__decap_3
XFILLER_6_103 VPWR VGND VPWR VGND sky130_fd_sc_hd__decap_3
XFILLER_6_147 VPWR VGND VPWR VGND sky130_fd_sc_hd__decap_3
XFILLER_6_136 VPWR VGND VPWR VGND sky130_fd_sc_hd__decap_3
XFILLER_12_50 VPWR VGND VPWR VGND sky130_fd_sc_hd__decap_3
XFILLER_12_94 VPWR VGND VPWR VGND sky130_fd_sc_hd__decap_3
XFILLER_2_331 VPWR VGND VPWR VGND sky130_fd_sc_hd__decap_3
XFILLER_2_375 VPWR VGND VPWR VGND sky130_fd_sc_hd__decap_3
XFILLER_26_9 VPWR VGND VPWR VGND sky130_fd_sc_hd__decap_3
XFILLER_37_80 VPWR VGND VPWR VGND sky130_fd_sc_hd__decap_3
XFILLER_33_202 VPWR VGND VPWR VGND sky130_fd_sc_hd__decap_3
XFILLER_33_246 VPWR VGND VPWR VGND sky130_fd_sc_hd__decap_3
XFILLER_53_90 VPWR VGND VPWR VGND sky130_fd_sc_hd__decap_3
XFILLER_41_290 VPWR VGND VPWR VGND sky130_fd_sc_hd__decap_3
XFILLER_56_327 VPWR VGND VPWR VGND sky130_fd_sc_hd__decap_3
XFILLER_64_371 VPWR VGND VPWR VGND sky130_fd_sc_hd__decap_3
XFILLER_64_393 VPWR VGND VPWR VGND sky130_fd_sc_hd__decap_3
XFILLER_24_224 VPWR VGND VPWR VGND sky130_fd_sc_hd__decap_3
XFILLER_24_268 VPWR VGND VPWR VGND sky130_fd_sc_hd__decap_3
XFILLER_3_128 VPWR VGND VPWR VGND sky130_fd_sc_hd__decap_3
XFILLER_58_24 VPWR VGND VPWR VGND sky130_fd_sc_hd__decap_3
XFILLER_58_35 VPWR VGND VPWR VGND sky130_fd_sc_hd__decap_3
XFILLER_59_132 VPWR VGND VPWR VGND sky130_fd_sc_hd__decap_3
XFILLER_59_187 VPWR VGND VPWR VGND sky130_fd_sc_hd__decap_3
XFILLER_59_165 VPWR VGND VPWR VGND sky130_fd_sc_hd__decap_3
XFILLER_47_305 VPWR VGND VPWR VGND sky130_fd_sc_hd__decap_3
XFILLER_47_349 VPWR VGND VPWR VGND sky130_fd_sc_hd__decap_3
XFILLER_55_393 VPWR VGND VPWR VGND sky130_fd_sc_hd__decap_3
XFILLER_55_382 VPWR VGND VPWR VGND sky130_fd_sc_hd__decap_3
XFILLER_30_227 VPWR VGND VPWR VGND sky130_fd_sc_hd__decap_3
XFILLER_23_290 VPWR VGND VPWR VGND sky130_fd_sc_hd__decap_3
X_204_ VGND VPWR VGND VPWR _111_ _110_ _109_ cout_next _204_/a_33_297# _204_/a_561_297#
+ _204_/a_225_47# sky130_fd_sc_hd__o21bai_4
XFILLER_23_60 VPWR VGND VPWR VGND sky130_fd_sc_hd__decap_3
X_135_ VGND VPWR VGND VPWR _057_ _054_ _053_ _055_ _135_/a_215_297# _135_/a_27_413#
+ _135_/a_298_297# _135_/a_382_47# sky130_fd_sc_hd__a21bo_1
XFILLER_2_150 VPWR VGND VPWR VGND sky130_fd_sc_hd__decap_3
XFILLER_24_6 VPWR VGND VPWR VGND sky130_fd_sc_hd__decap_3
XFILLER_38_327 VPWR VGND VPWR VGND sky130_fd_sc_hd__decap_3
XFILLER_53_308 VPWR VGND VPWR VGND sky130_fd_sc_hd__decap_3
XFILLER_46_360 VPWR VGND VPWR VGND sky130_fd_sc_hd__decap_3
XFILLER_0_53 VPWR VGND VPWR VGND sky130_fd_sc_hd__decap_3
XFILLER_46_371 VPWR VGND VPWR VGND sky130_fd_sc_hd__decap_3
XFILLER_0_75 VPWR VGND VPWR VGND sky130_fd_sc_hd__decap_3
XFILLER_61_352 VPWR VGND VPWR VGND sky130_fd_sc_hd__decap_3
XFILLER_0_97 VPWR VGND VPWR VGND sky130_fd_sc_hd__decap_3
XFILLER_61_396 VPWR VGND VPWR VGND sky130_fd_sc_hd__decap_3
XFILLER_61_385 VPWR VGND VPWR VGND sky130_fd_sc_hd__decap_3
XFILLER_9_40 VPWR VGND VPWR VGND sky130_fd_sc_hd__decap_3
XFILLER_9_84 VPWR VGND VPWR VGND sky130_fd_sc_hd__decap_3
XFILLER_0_109 VPWR VGND VPWR VGND sky130_fd_sc_hd__decap_3
XFILLER_29_305 VPWR VGND VPWR VGND sky130_fd_sc_hd__decap_3
XFILLER_29_349 VPWR VGND VPWR VGND sky130_fd_sc_hd__decap_3
XFILLER_56_124 VPWR VGND VPWR VGND sky130_fd_sc_hd__decap_3
XFILLER_56_168 VPWR VGND VPWR VGND sky130_fd_sc_hd__decap_3
XFILLER_37_382 VPWR VGND VPWR VGND sky130_fd_sc_hd__decap_3
XFILLER_37_393 VPWR VGND VPWR VGND sky130_fd_sc_hd__decap_3
XFILLER_44_15 VPWR VGND VPWR VGND sky130_fd_sc_hd__decap_3
XFILLER_64_190 VPWR VGND VPWR VGND sky130_fd_sc_hd__decap_3
XFILLER_52_330 VPWR VGND VPWR VGND sky130_fd_sc_hd__decap_3
XFILLER_44_59 VPWR VGND VPWR VGND sky130_fd_sc_hd__decap_3
XFILLER_52_374 VPWR VGND VPWR VGND sky130_fd_sc_hd__decap_3
XFILLER_60_47 VPWR VGND VPWR VGND sky130_fd_sc_hd__decap_3
XFILLER_47_113 VPWR VGND VPWR VGND sky130_fd_sc_hd__decap_3
XFILLER_47_102 VPWR VGND VPWR VGND sky130_fd_sc_hd__decap_3
XFILLER_47_146 VPWR VGND VPWR VGND sky130_fd_sc_hd__decap_3
XFILLER_18_71 VPWR VGND VPWR VGND sky130_fd_sc_hd__decap_3
XFILLER_28_360 VPWR VGND VPWR VGND sky130_fd_sc_hd__decap_3
XFILLER_35_308 VPWR VGND VPWR VGND sky130_fd_sc_hd__decap_3
XFILLER_62_127 VPWR VGND VPWR VGND sky130_fd_sc_hd__decap_3
XFILLER_28_371 VPWR VGND VPWR VGND sky130_fd_sc_hd__decap_3
XFILLER_43_352 VPWR VGND VPWR VGND sky130_fd_sc_hd__decap_3
XFILLER_55_190 VPWR VGND VPWR VGND sky130_fd_sc_hd__decap_3
XFILLER_43_385 VPWR VGND VPWR VGND sky130_fd_sc_hd__decap_3
XFILLER_43_396 VPWR VGND VPWR VGND sky130_fd_sc_hd__decap_3
XFILLER_50_80 VPWR VGND VPWR VGND sky130_fd_sc_hd__decap_3
XFILLER_50_91 VPWR VGND VPWR VGND sky130_fd_sc_hd__decap_3
XFILLER_38_124 VPWR VGND VPWR VGND sky130_fd_sc_hd__decap_3
XFILLER_38_168 VPWR VGND VPWR VGND sky130_fd_sc_hd__decap_3
XFILLER_53_105 VPWR VGND VPWR VGND sky130_fd_sc_hd__decap_3
XFILLER_19_382 VPWR VGND VPWR VGND sky130_fd_sc_hd__decap_3
XFILLER_53_116 VPWR VGND VPWR VGND sky130_fd_sc_hd__decap_3
XFILLER_34_330 VPWR VGND VPWR VGND sky130_fd_sc_hd__decap_3
XFILLER_53_149 VPWR VGND VPWR VGND sky130_fd_sc_hd__decap_3
XFILLER_14_18 VPWR VGND VPWR VGND sky130_fd_sc_hd__decap_3
XFILLER_34_374 VPWR VGND VPWR VGND sky130_fd_sc_hd__decap_3
XFILLER_61_193 VPWR VGND VPWR VGND sky130_fd_sc_hd__decap_3
XFILLER_14_29 VPWR VGND VPWR VGND sky130_fd_sc_hd__decap_3
XPHY_EDGE_ROW_3_1_Right_2 VPWR VGND VPWR VGND sky130_fd_sc_hd__decap_3
XFILLER_39_15 VPWR VGND VPWR VGND sky130_fd_sc_hd__decap_3
XFILLER_29_113 VPWR VGND VPWR VGND sky130_fd_sc_hd__decap_3
XFILLER_29_146 VPWR VGND VPWR VGND sky130_fd_sc_hd__decap_3
XFILLER_44_127 VPWR VGND VPWR VGND sky130_fd_sc_hd__decap_3
XFILLER_37_190 VPWR VGND VPWR VGND sky130_fd_sc_hd__decap_3
XFILLER_25_352 VPWR VGND VPWR VGND sky130_fd_sc_hd__decap_3
XFILLER_25_385 VPWR VGND VPWR VGND sky130_fd_sc_hd__decap_3
XFILLER_52_171 VPWR VGND VPWR VGND sky130_fd_sc_hd__decap_3
XFILLER_40_333 VPWR VGND VPWR VGND sky130_fd_sc_hd__decap_3
XFILLER_25_396 VPWR VGND VPWR VGND sky130_fd_sc_hd__decap_3
XFILLER_40_377 VPWR VGND VPWR VGND sky130_fd_sc_hd__decap_3
XFILLER_20_50 VPWR VGND VPWR VGND sky130_fd_sc_hd__decap_3
XFILLER_29_81 VPWR VGND VPWR VGND sky130_fd_sc_hd__decap_3
XFILLER_35_116 VPWR VGND VPWR VGND sky130_fd_sc_hd__decap_3
XFILLER_35_149 VPWR VGND VPWR VGND sky130_fd_sc_hd__decap_3
XFILLER_16_363 VPWR VGND VPWR VGND sky130_fd_sc_hd__decap_3
XFILLER_45_91 VPWR VGND VPWR VGND sky130_fd_sc_hd__decap_3
XFILLER_16_396 VPWR VGND VPWR VGND sky130_fd_sc_hd__decap_3
XFILLER_31_311 VPWR VGND VPWR VGND sky130_fd_sc_hd__decap_3
XFILLER_43_193 VPWR VGND VPWR VGND sky130_fd_sc_hd__decap_3
XFILLER_31_355 VPWR VGND VPWR VGND sky130_fd_sc_hd__decap_3
XFILLER_31_388 VPWR VGND VPWR VGND sky130_fd_sc_hd__decap_3
XFILLER_31_399 VPWR VGND VPWR VGND sky130_fd_sc_hd__decap_3
XFILLER_61_90 VPWR VGND VPWR VGND sky130_fd_sc_hd__decap_3
XANTENNA_1 net42 VGND VPWR VPWR VGND sky130_fd_sc_hd__diode_2
XFILLER_6_41 VPWR VGND VPWR VGND sky130_fd_sc_hd__decap_3
XFILLER_6_85 VPWR VGND VPWR VGND sky130_fd_sc_hd__decap_3
Xpmu_inst_66 net66 pmu_inst_66/HI VPWR VGND VGND VPWR sky130_fd_sc_hd__conb_1
XFILLER_26_127 VPWR VGND VPWR VGND sky130_fd_sc_hd__decap_3
XFILLER_25_39 VPWR VGND VPWR VGND sky130_fd_sc_hd__decap_3
XFILLER_41_108 VPWR VGND VPWR VGND sky130_fd_sc_hd__decap_3
XFILLER_41_119 VPWR VGND VPWR VGND sky130_fd_sc_hd__decap_3
XFILLER_34_171 VPWR VGND VPWR VGND sky130_fd_sc_hd__decap_3
XFILLER_22_333 VPWR VGND VPWR VGND sky130_fd_sc_hd__decap_3
XFILLER_22_377 VPWR VGND VPWR VGND sky130_fd_sc_hd__decap_3
XFILLER_49_208 VPWR VGND VPWR VGND sky130_fd_sc_hd__decap_3
XFILLER_57_252 VPWR VGND VPWR VGND sky130_fd_sc_hd__decap_3
XFILLER_17_116 VPWR VGND VPWR VGND sky130_fd_sc_hd__decap_3
XFILLER_17_149 VPWR VGND VPWR VGND sky130_fd_sc_hd__decap_3
XFILLER_25_193 VPWR VGND VPWR VGND sky130_fd_sc_hd__decap_3
XFILLER_13_355 VPWR VGND VPWR VGND sky130_fd_sc_hd__decap_3
XFILLER_15_72 VPWR VGND VPWR VGND sky130_fd_sc_hd__decap_3
XFILLER_40_130 VPWR VGND VPWR VGND sky130_fd_sc_hd__decap_3
XFILLER_40_141 VPWR VGND VPWR VGND sky130_fd_sc_hd__decap_3
XFILLER_13_388 VPWR VGND VPWR VGND sky130_fd_sc_hd__decap_3
XFILLER_9_337 VPWR VGND VPWR VGND sky130_fd_sc_hd__decap_3
XFILLER_40_174 VPWR VGND VPWR VGND sky130_fd_sc_hd__decap_3
XFILLER_31_60 VPWR VGND VPWR VGND sky130_fd_sc_hd__decap_3
XFILLER_31_93 VPWR VGND VPWR VGND sky130_fd_sc_hd__decap_3
XFILLER_56_9 VPWR VGND VPWR VGND sky130_fd_sc_hd__decap_3
XFILLER_48_230 VPWR VGND VPWR VGND sky130_fd_sc_hd__decap_3
XFILLER_63_211 VPWR VGND VPWR VGND sky130_fd_sc_hd__decap_3
XFILLER_48_274 VPWR VGND VPWR VGND sky130_fd_sc_hd__decap_3
XFILLER_63_255 VPWR VGND VPWR VGND sky130_fd_sc_hd__decap_3
XFILLER_23_108 VPWR VGND VPWR VGND sky130_fd_sc_hd__decap_3
XFILLER_23_119 VPWR VGND VPWR VGND sky130_fd_sc_hd__decap_3
XFILLER_63_299 VPWR VGND VPWR VGND sky130_fd_sc_hd__decap_3
XFILLER_16_171 VPWR VGND VPWR VGND sky130_fd_sc_hd__decap_3
XFILLER_31_152 VPWR VGND VPWR VGND sky130_fd_sc_hd__decap_3
XFILLER_31_196 VPWR VGND VPWR VGND sky130_fd_sc_hd__decap_3
XFILLER_8_381 VPWR VGND VPWR VGND sky130_fd_sc_hd__decap_3
XFILLER_39_252 VPWR VGND VPWR VGND sky130_fd_sc_hd__decap_3
XFILLER_54_200 VPWR VGND VPWR VGND sky130_fd_sc_hd__decap_3
XFILLER_39_296 VPWR VGND VPWR VGND sky130_fd_sc_hd__decap_3
XFILLER_54_233 VPWR VGND VPWR VGND sky130_fd_sc_hd__decap_3
XFILLER_54_277 VPWR VGND VPWR VGND sky130_fd_sc_hd__decap_3
XFILLER_22_130 VPWR VGND VPWR VGND sky130_fd_sc_hd__decap_3
XFILLER_22_141 VPWR VGND VPWR VGND sky130_fd_sc_hd__decap_3
XFILLER_22_174 VPWR VGND VPWR VGND sky130_fd_sc_hd__decap_3
XFILLER_52_59 VPWR VGND VPWR VGND sky130_fd_sc_hd__decap_3
XFILLER_10_369 VPWR VGND VPWR VGND sky130_fd_sc_hd__decap_3
XFILLER_45_211 VPWR VGND VPWR VGND sky130_fd_sc_hd__decap_3
XFILLER_60_203 VPWR VGND VPWR VGND sky130_fd_sc_hd__decap_3
XFILLER_45_255 VPWR VGND VPWR VGND sky130_fd_sc_hd__decap_3
XFILLER_60_236 VPWR VGND VPWR VGND sky130_fd_sc_hd__decap_3
XFILLER_45_299 VPWR VGND VPWR VGND sky130_fd_sc_hd__decap_3
XFILLER_13_152 VPWR VGND VPWR VGND sky130_fd_sc_hd__decap_3
XFILLER_9_134 VPWR VGND VPWR VGND sky130_fd_sc_hd__decap_3
X_297_ VGND VPWR VPWR VGND clknet_2_2__leaf_clk_regs net32 _042_ genblk1\[9\].fa_inst.b
+ _297_/a_1462_47# _297_/a_543_47# _297_/a_651_413# _297_/a_193_47# _297_/a_805_47#
+ _297_/a_448_47# _297_/a_639_47# _297_/a_1283_21# _297_/a_761_289# _297_/a_1108_47#
+ _297_/a_1217_47# _297_/a_1270_413# _297_/a_27_47# sky130_fd_sc_hd__dfrtp_1
XFILLER_5_340 VPWR VGND VPWR VGND sky130_fd_sc_hd__decap_3
XFILLER_5_373 VPWR VGND VPWR VGND sky130_fd_sc_hd__decap_3
XFILLER_54_6 VPWR VGND VPWR VGND sky130_fd_sc_hd__decap_3
XFILLER_3_75 VPWR VGND VPWR VGND sky130_fd_sc_hd__decap_3
XFILLER_36_200 VPWR VGND VPWR VGND sky130_fd_sc_hd__decap_3
XFILLER_36_233 VPWR VGND VPWR VGND sky130_fd_sc_hd__decap_3
XFILLER_36_277 VPWR VGND VPWR VGND sky130_fd_sc_hd__decap_3
XFILLER_51_214 VPWR VGND VPWR VGND sky130_fd_sc_hd__decap_3
XFILLER_51_225 VPWR VGND VPWR VGND sky130_fd_sc_hd__decap_3
XFILLER_51_258 VPWR VGND VPWR VGND sky130_fd_sc_hd__decap_3
XFILLER_22_18 VPWR VGND VPWR VGND sky130_fd_sc_hd__decap_3
XFILLER_59_314 VPWR VGND VPWR VGND sky130_fd_sc_hd__decap_3
XFILLER_59_358 VPWR VGND VPWR VGND sky130_fd_sc_hd__decap_3
XFILLER_47_15 VPWR VGND VPWR VGND sky130_fd_sc_hd__decap_3
XFILLER_47_48 VPWR VGND VPWR VGND sky130_fd_sc_hd__decap_3
XFILLER_27_211 VPWR VGND VPWR VGND sky130_fd_sc_hd__decap_3
XFILLER_27_255 VPWR VGND VPWR VGND sky130_fd_sc_hd__decap_3
XFILLER_42_203 VPWR VGND VPWR VGND sky130_fd_sc_hd__decap_3
XFILLER_63_25 VPWR VGND VPWR VGND sky130_fd_sc_hd__decap_3
XFILLER_27_299 VPWR VGND VPWR VGND sky130_fd_sc_hd__decap_3
XFILLER_42_236 VPWR VGND VPWR VGND sky130_fd_sc_hd__decap_3
XFILLER_63_69 VPWR VGND VPWR VGND sky130_fd_sc_hd__decap_3
X_220_ net61 _015_ VPWR VGND VPWR VGND sky130_fd_sc_hd__inv_2
XFILLER_10_100 VPWR VGND VPWR VGND sky130_fd_sc_hd__decap_3
XFILLER_10_133 VPWR VGND VPWR VGND sky130_fd_sc_hd__decap_3
X_151_ VPWR VGND VGND VPWR genblk1\[5\].fa_inst.b _070_ genblk1\[5\].fa_inst.a _151_/a_113_47#
+ sky130_fd_sc_hd__nand2_1
XFILLER_50_280 VPWR VGND VPWR VGND sky130_fd_sc_hd__decap_3
XFILLER_10_177 VPWR VGND VPWR VGND sky130_fd_sc_hd__decap_3
XFILLER_10_144 VPWR VGND VPWR VGND sky130_fd_sc_hd__decap_3
XFILLER_6_115 VPWR VGND VPWR VGND sky130_fd_sc_hd__decap_3
XPHY_EDGE_ROW_15_1_Left_121 VPWR VGND VPWR VGND sky130_fd_sc_hd__decap_3
XFILLER_6_159 VPWR VGND VPWR VGND sky130_fd_sc_hd__decap_3
XFILLER_12_62 VPWR VGND VPWR VGND sky130_fd_sc_hd__decap_3
XFILLER_2_354 VPWR VGND VPWR VGND sky130_fd_sc_hd__decap_3
XFILLER_2_343 VPWR VGND VPWR VGND sky130_fd_sc_hd__decap_3
XFILLER_2_387 VPWR VGND VPWR VGND sky130_fd_sc_hd__decap_3
XFILLER_19_9 VPWR VGND VPWR VGND sky130_fd_sc_hd__decap_3
XFILLER_58_380 VPWR VGND VPWR VGND sky130_fd_sc_hd__decap_3
XFILLER_37_92 VPWR VGND VPWR VGND sky130_fd_sc_hd__decap_3
XFILLER_33_214 VPWR VGND VPWR VGND sky130_fd_sc_hd__decap_3
XFILLER_33_225 VPWR VGND VPWR VGND sky130_fd_sc_hd__decap_3
XFILLER_33_258 VPWR VGND VPWR VGND sky130_fd_sc_hd__decap_3
XPHY_EDGE_ROW_25_Right_46 VPWR VGND VPWR VGND sky130_fd_sc_hd__decap_3
XFILLER_56_339 VPWR VGND VPWR VGND sky130_fd_sc_hd__decap_3
XPHY_EDGE_ROW_34_Right_55 VPWR VGND VPWR VGND sky130_fd_sc_hd__decap_3
XFILLER_64_361 VPWR VGND VPWR VGND sky130_fd_sc_hd__decap_3
XFILLER_64_383 VPWR VGND VPWR VGND sky130_fd_sc_hd__decap_3
XFILLER_24_203 VPWR VGND VPWR VGND sky130_fd_sc_hd__decap_3
XFILLER_24_236 VPWR VGND VPWR VGND sky130_fd_sc_hd__decap_3
XFILLER_33_39 VPWR VGND VPWR VGND sky130_fd_sc_hd__decap_3
XFILLER_32_280 VPWR VGND VPWR VGND sky130_fd_sc_hd__decap_3
XPHY_EDGE_ROW_43_Right_64 VPWR VGND VPWR VGND sky130_fd_sc_hd__decap_3
XFILLER_58_47 VPWR VGND VPWR VGND sky130_fd_sc_hd__decap_3
XFILLER_59_144 VPWR VGND VPWR VGND sky130_fd_sc_hd__decap_3
XFILLER_58_69 VPWR VGND VPWR VGND sky130_fd_sc_hd__decap_3
XPHY_EDGE_ROW_52_Right_73 VPWR VGND VPWR VGND sky130_fd_sc_hd__decap_3
XFILLER_47_317 VPWR VGND VPWR VGND sky130_fd_sc_hd__decap_3
XFILLER_59_199 VPWR VGND VPWR VGND sky130_fd_sc_hd__decap_3
XFILLER_62_309 VPWR VGND VPWR VGND sky130_fd_sc_hd__decap_3
XFILLER_55_361 VPWR VGND VPWR VGND sky130_fd_sc_hd__decap_3
XFILLER_30_206 VPWR VGND VPWR VGND sky130_fd_sc_hd__decap_3
XPHY_EDGE_ROW_61_Right_82 VPWR VGND VPWR VGND sky130_fd_sc_hd__decap_3
XFILLER_30_239 VPWR VGND VPWR VGND sky130_fd_sc_hd__decap_3
X_203_ VPWR VGND VGND VPWR _109_ _111_ _112_ _203_/a_109_297# sky130_fd_sc_hd__nor2_1
XFILLER_23_72 VPWR VGND VPWR VGND sky130_fd_sc_hd__decap_3
X_134_ VGND VPWR _056_ genblk1\[1\].fa_inst.s _053_ VPWR VGND _134_/a_129_47# _134_/a_47_47#
+ _134_/a_285_47# _134_/a_377_297# sky130_fd_sc_hd__xnor2_1
XFILLER_2_162 VPWR VGND VPWR VGND sky130_fd_sc_hd__decap_3
XFILLER_38_339 VPWR VGND VPWR VGND sky130_fd_sc_hd__decap_3
XFILLER_17_6 VPWR VGND VPWR VGND sky130_fd_sc_hd__decap_3
XFILLER_48_80 VPWR VGND VPWR VGND sky130_fd_sc_hd__decap_3
XFILLER_48_91 VPWR VGND VPWR VGND sky130_fd_sc_hd__decap_3
XFILLER_0_32 VPWR VGND VPWR VGND sky130_fd_sc_hd__decap_3
XFILLER_0_21 VPWR VGND VPWR VGND sky130_fd_sc_hd__decap_3
XFILLER_61_320 VPWR VGND VPWR VGND sky130_fd_sc_hd__decap_3
XFILLER_46_383 VPWR VGND VPWR VGND sky130_fd_sc_hd__decap_3
XFILLER_61_364 VPWR VGND VPWR VGND sky130_fd_sc_hd__decap_3
XFILLER_21_206 VPWR VGND VPWR VGND sky130_fd_sc_hd__decap_3
XFILLER_9_52 VPWR VGND VPWR VGND sky130_fd_sc_hd__decap_3
XFILLER_9_63 VPWR VGND VPWR VGND sky130_fd_sc_hd__decap_3
XFILLER_9_96 VPWR VGND VPWR VGND sky130_fd_sc_hd__decap_3
XFILLER_28_39 VPWR VGND VPWR VGND sky130_fd_sc_hd__decap_3
XFILLER_29_317 VPWR VGND VPWR VGND sky130_fd_sc_hd__decap_3
XFILLER_56_103 VPWR VGND VPWR VGND sky130_fd_sc_hd__decap_3
XFILLER_56_136 VPWR VGND VPWR VGND sky130_fd_sc_hd__decap_3
XFILLER_56_147 VPWR VGND VPWR VGND sky130_fd_sc_hd__decap_3
XFILLER_44_309 VPWR VGND VPWR VGND sky130_fd_sc_hd__decap_3
XFILLER_37_361 VPWR VGND VPWR VGND sky130_fd_sc_hd__decap_3
XFILLER_52_342 VPWR VGND VPWR VGND sky130_fd_sc_hd__decap_3
XFILLER_44_38 VPWR VGND VPWR VGND sky130_fd_sc_hd__decap_3
XFILLER_52_386 VPWR VGND VPWR VGND sky130_fd_sc_hd__decap_3
XFILLER_60_59 VPWR VGND VPWR VGND sky130_fd_sc_hd__decap_3
XPHY_EDGE_ROW_3_1_Left_109 VPWR VGND VPWR VGND sky130_fd_sc_hd__decap_3
XFILLER_47_125 VPWR VGND VPWR VGND sky130_fd_sc_hd__decap_3
XFILLER_47_158 VPWR VGND VPWR VGND sky130_fd_sc_hd__decap_3
XFILLER_47_169 VPWR VGND VPWR VGND sky130_fd_sc_hd__decap_3
XFILLER_62_106 VPWR VGND VPWR VGND sky130_fd_sc_hd__decap_3
XFILLER_18_94 VPWR VGND VPWR VGND sky130_fd_sc_hd__decap_3
XFILLER_28_383 VPWR VGND VPWR VGND sky130_fd_sc_hd__decap_3
XFILLER_43_320 VPWR VGND VPWR VGND sky130_fd_sc_hd__decap_3
XFILLER_43_364 VPWR VGND VPWR VGND sky130_fd_sc_hd__decap_3
XFILLER_34_71 VPWR VGND VPWR VGND sky130_fd_sc_hd__decap_3
XFILLER_59_90 VPWR VGND VPWR VGND sky130_fd_sc_hd__decap_3
XFILLER_38_103 VPWR VGND VPWR VGND sky130_fd_sc_hd__decap_3
XFILLER_15_3 VPWR VGND VPWR VGND sky130_fd_sc_hd__decap_3
XFILLER_38_136 VPWR VGND VPWR VGND sky130_fd_sc_hd__decap_3
XFILLER_26_309 VPWR VGND VPWR VGND sky130_fd_sc_hd__decap_3
XFILLER_38_147 VPWR VGND VPWR VGND sky130_fd_sc_hd__decap_3
XFILLER_19_361 VPWR VGND VPWR VGND sky130_fd_sc_hd__decap_3
XFILLER_53_128 VPWR VGND VPWR VGND sky130_fd_sc_hd__decap_3
XFILLER_34_342 VPWR VGND VPWR VGND sky130_fd_sc_hd__decap_3
XFILLER_19_394 VPWR VGND VPWR VGND sky130_fd_sc_hd__decap_3
XFILLER_46_180 VPWR VGND VPWR VGND sky130_fd_sc_hd__decap_3
XFILLER_61_161 VPWR VGND VPWR VGND sky130_fd_sc_hd__decap_3
XFILLER_34_386 VPWR VGND VPWR VGND sky130_fd_sc_hd__decap_3
XFILLER_61_172 VPWR VGND VPWR VGND sky130_fd_sc_hd__decap_3
XFILLER_30_18 VPWR VGND VPWR VGND sky130_fd_sc_hd__decap_3
XFILLER_29_125 VPWR VGND VPWR VGND sky130_fd_sc_hd__decap_3
XFILLER_29_158 VPWR VGND VPWR VGND sky130_fd_sc_hd__decap_3
XFILLER_29_169 VPWR VGND VPWR VGND sky130_fd_sc_hd__decap_3
XFILLER_55_37 VPWR VGND VPWR VGND sky130_fd_sc_hd__decap_3
XFILLER_25_320 VPWR VGND VPWR VGND sky130_fd_sc_hd__decap_3
XFILLER_40_301 VPWR VGND VPWR VGND sky130_fd_sc_hd__decap_3
XFILLER_25_364 VPWR VGND VPWR VGND sky130_fd_sc_hd__decap_3
XFILLER_52_150 VPWR VGND VPWR VGND sky130_fd_sc_hd__decap_3
XFILLER_40_312 VPWR VGND VPWR VGND sky130_fd_sc_hd__decap_3
XFILLER_52_183 VPWR VGND VPWR VGND sky130_fd_sc_hd__decap_3
XFILLER_40_345 VPWR VGND VPWR VGND sky130_fd_sc_hd__decap_3
XPHY_EDGE_ROW_1_2_Right_87 VPWR VGND VPWR VGND sky130_fd_sc_hd__decap_3
XFILLER_40_389 VPWR VGND VPWR VGND sky130_fd_sc_hd__decap_3
XFILLER_20_73 VPWR VGND VPWR VGND sky130_fd_sc_hd__decap_3
XFILLER_20_62 VPWR VGND VPWR VGND sky130_fd_sc_hd__decap_3
XFILLER_48_401 VPWR VGND VPWR VGND sky130_fd_sc_hd__decap_3
XFILLER_29_60 VPWR VGND VPWR VGND sky130_fd_sc_hd__decap_3
XFILLER_29_93 VPWR VGND VPWR VGND sky130_fd_sc_hd__decap_3
XFILLER_35_106 VPWR VGND VPWR VGND sky130_fd_sc_hd__decap_3
XFILLER_35_128 VPWR VGND VPWR VGND sky130_fd_sc_hd__decap_3
XFILLER_16_331 VPWR VGND VPWR VGND sky130_fd_sc_hd__decap_3
XFILLER_28_180 VPWR VGND VPWR VGND sky130_fd_sc_hd__decap_3
XFILLER_16_375 VPWR VGND VPWR VGND sky130_fd_sc_hd__decap_3
XFILLER_43_161 VPWR VGND VPWR VGND sky130_fd_sc_hd__decap_3
XFILLER_50_109 VPWR VGND VPWR VGND sky130_fd_sc_hd__decap_3
XFILLER_31_323 VPWR VGND VPWR VGND sky130_fd_sc_hd__decap_3
XFILLER_43_172 VPWR VGND VPWR VGND sky130_fd_sc_hd__decap_3
XFILLER_31_367 VPWR VGND VPWR VGND sky130_fd_sc_hd__decap_3
XANTENNA_2 net44 VGND VPWR VPWR VGND sky130_fd_sc_hd__diode_2
XFILLER_6_53 VPWR VGND VPWR VGND sky130_fd_sc_hd__decap_3
Xpmu_inst_67 net67 pmu_inst_67/HI VPWR VGND VGND VPWR sky130_fd_sc_hd__conb_1
XFILLER_6_97 VPWR VGND VPWR VGND sky130_fd_sc_hd__decap_3
XFILLER_58_209 VPWR VGND VPWR VGND sky130_fd_sc_hd__decap_3
XFILLER_54_404 VPWR VGND VPWR VGND sky130_fd_sc_hd__decap_3
XFILLER_26_106 VPWR VGND VPWR VGND sky130_fd_sc_hd__decap_3
XFILLER_34_150 VPWR VGND VPWR VGND sky130_fd_sc_hd__decap_3
XFILLER_22_301 VPWR VGND VPWR VGND sky130_fd_sc_hd__decap_3
XFILLER_34_183 VPWR VGND VPWR VGND sky130_fd_sc_hd__decap_3
XFILLER_22_312 VPWR VGND VPWR VGND sky130_fd_sc_hd__decap_3
XFILLER_22_345 VPWR VGND VPWR VGND sky130_fd_sc_hd__decap_3
XFILLER_22_389 VPWR VGND VPWR VGND sky130_fd_sc_hd__decap_3
XFILLER_57_220 VPWR VGND VPWR VGND sky130_fd_sc_hd__decap_3
XFILLER_57_231 VPWR VGND VPWR VGND sky130_fd_sc_hd__decap_3
XFILLER_57_264 VPWR VGND VPWR VGND sky130_fd_sc_hd__decap_3
XFILLER_17_106 VPWR VGND VPWR VGND sky130_fd_sc_hd__decap_3
XFILLER_17_128 VPWR VGND VPWR VGND sky130_fd_sc_hd__decap_3
XFILLER_13_334 VPWR VGND VPWR VGND sky130_fd_sc_hd__decap_3
XFILLER_15_40 VPWR VGND VPWR VGND sky130_fd_sc_hd__decap_3
XFILLER_25_161 VPWR VGND VPWR VGND sky130_fd_sc_hd__decap_3
XFILLER_25_172 VPWR VGND VPWR VGND sky130_fd_sc_hd__decap_3
XFILLER_13_367 VPWR VGND VPWR VGND sky130_fd_sc_hd__decap_3
XFILLER_15_84 VPWR VGND VPWR VGND sky130_fd_sc_hd__decap_3
XFILLER_40_153 VPWR VGND VPWR VGND sky130_fd_sc_hd__decap_3
XFILLER_9_349 VPWR VGND VPWR VGND sky130_fd_sc_hd__decap_3
XFILLER_40_186 VPWR VGND VPWR VGND sky130_fd_sc_hd__decap_3
XFILLER_40_197 VPWR VGND VPWR VGND sky130_fd_sc_hd__decap_3
XFILLER_31_50 VPWR VGND VPWR VGND sky130_fd_sc_hd__decap_3
XFILLER_31_72 VPWR VGND VPWR VGND sky130_fd_sc_hd__decap_3
Xoutput50 VPWR VGND s[5] net50 VPWR VGND output50/a_27_47# sky130_fd_sc_hd__buf_2
XFILLER_49_9 VPWR VGND VPWR VGND sky130_fd_sc_hd__decap_3
XFILLER_48_253 VPWR VGND VPWR VGND sky130_fd_sc_hd__decap_3
XFILLER_48_242 VPWR VGND VPWR VGND sky130_fd_sc_hd__decap_3
XFILLER_36_404 VPWR VGND VPWR VGND sky130_fd_sc_hd__decap_3
XFILLER_48_286 VPWR VGND VPWR VGND sky130_fd_sc_hd__decap_3
XFILLER_63_234 VPWR VGND VPWR VGND sky130_fd_sc_hd__decap_3
XFILLER_56_91 VPWR VGND VPWR VGND sky130_fd_sc_hd__decap_3
XFILLER_63_267 VPWR VGND VPWR VGND sky130_fd_sc_hd__decap_3
XFILLER_16_150 VPWR VGND VPWR VGND sky130_fd_sc_hd__decap_3
XFILLER_31_131 VPWR VGND VPWR VGND sky130_fd_sc_hd__decap_3
XFILLER_31_164 VPWR VGND VPWR VGND sky130_fd_sc_hd__decap_3
XFILLER_31_175 VPWR VGND VPWR VGND sky130_fd_sc_hd__decap_3
XFILLER_8_360 VPWR VGND VPWR VGND sky130_fd_sc_hd__decap_3
XFILLER_8_393 VPWR VGND VPWR VGND sky130_fd_sc_hd__decap_3
XFILLER_39_231 VPWR VGND VPWR VGND sky130_fd_sc_hd__decap_3
XFILLER_39_220 VPWR VGND VPWR VGND sky130_fd_sc_hd__decap_3
XFILLER_39_264 VPWR VGND VPWR VGND sky130_fd_sc_hd__decap_3
XFILLER_54_212 VPWR VGND VPWR VGND sky130_fd_sc_hd__decap_3
XFILLER_36_39 VPWR VGND VPWR VGND sky130_fd_sc_hd__decap_3
XFILLER_54_245 VPWR VGND VPWR VGND sky130_fd_sc_hd__decap_3
XFILLER_14_109 VPWR VGND VPWR VGND sky130_fd_sc_hd__decap_3
XFILLER_54_256 VPWR VGND VPWR VGND sky130_fd_sc_hd__decap_3
XFILLER_54_289 VPWR VGND VPWR VGND sky130_fd_sc_hd__decap_3
XFILLER_52_38 VPWR VGND VPWR VGND sky130_fd_sc_hd__decap_3
XFILLER_22_153 VPWR VGND VPWR VGND sky130_fd_sc_hd__decap_3
XFILLER_10_337 VPWR VGND VPWR VGND sky130_fd_sc_hd__decap_3
XFILLER_22_186 VPWR VGND VPWR VGND sky130_fd_sc_hd__decap_3
XFILLER_22_197 VPWR VGND VPWR VGND sky130_fd_sc_hd__decap_3
XFILLER_45_234 VPWR VGND VPWR VGND sky130_fd_sc_hd__decap_3
XFILLER_45_267 VPWR VGND VPWR VGND sky130_fd_sc_hd__decap_3
XFILLER_60_215 VPWR VGND VPWR VGND sky130_fd_sc_hd__decap_3
XFILLER_26_72 VPWR VGND VPWR VGND sky130_fd_sc_hd__decap_3
XFILLER_60_259 VPWR VGND VPWR VGND sky130_fd_sc_hd__decap_3
XFILLER_60_248 VPWR VGND VPWR VGND sky130_fd_sc_hd__decap_3
XFILLER_13_131 VPWR VGND VPWR VGND sky130_fd_sc_hd__decap_3
XFILLER_26_94 VPWR VGND VPWR VGND sky130_fd_sc_hd__decap_3
XFILLER_13_175 VPWR VGND VPWR VGND sky130_fd_sc_hd__decap_3
XFILLER_13_164 VPWR VGND VPWR VGND sky130_fd_sc_hd__decap_3
XFILLER_9_102 VPWR VGND VPWR VGND sky130_fd_sc_hd__decap_3
XFILLER_9_146 VPWR VGND VPWR VGND sky130_fd_sc_hd__decap_3
X_296_ VGND VPWR VPWR VGND clknet_2_2__leaf_clk_regs net31 _041_ genblk1\[8\].fa_inst.b
+ _296_/a_1462_47# _296_/a_543_47# _296_/a_651_413# _296_/a_193_47# _296_/a_805_47#
+ _296_/a_448_47# _296_/a_639_47# _296_/a_1283_21# _296_/a_761_289# _296_/a_1108_47#
+ _296_/a_1217_47# _296_/a_1270_413# _296_/a_27_47# sky130_fd_sc_hd__dfrtp_1
XFILLER_42_71 VPWR VGND VPWR VGND sky130_fd_sc_hd__decap_3
XFILLER_5_352 VPWR VGND VPWR VGND sky130_fd_sc_hd__decap_3
XFILLER_5_385 VPWR VGND VPWR VGND sky130_fd_sc_hd__decap_3
XFILLER_47_6 VPWR VGND VPWR VGND sky130_fd_sc_hd__decap_3
XFILLER_3_87 VPWR VGND VPWR VGND sky130_fd_sc_hd__decap_3
XFILLER_36_212 VPWR VGND VPWR VGND sky130_fd_sc_hd__decap_3
XFILLER_36_256 VPWR VGND VPWR VGND sky130_fd_sc_hd__decap_3
XFILLER_36_245 VPWR VGND VPWR VGND sky130_fd_sc_hd__decap_3
XFILLER_36_289 VPWR VGND VPWR VGND sky130_fd_sc_hd__decap_3
XFILLER_51_237 VPWR VGND VPWR VGND sky130_fd_sc_hd__decap_3
XFILLER_59_337 VPWR VGND VPWR VGND sky130_fd_sc_hd__decap_3
XFILLER_59_326 VPWR VGND VPWR VGND sky130_fd_sc_hd__decap_3
XFILLER_47_27 VPWR VGND VPWR VGND sky130_fd_sc_hd__decap_3
XFILLER_27_234 VPWR VGND VPWR VGND sky130_fd_sc_hd__decap_3
XFILLER_27_267 VPWR VGND VPWR VGND sky130_fd_sc_hd__decap_3
XFILLER_63_37 VPWR VGND VPWR VGND sky130_fd_sc_hd__decap_3
XFILLER_42_215 VPWR VGND VPWR VGND sky130_fd_sc_hd__decap_3
XFILLER_42_248 VPWR VGND VPWR VGND sky130_fd_sc_hd__decap_3
XFILLER_42_259 VPWR VGND VPWR VGND sky130_fd_sc_hd__decap_3
XFILLER_50_292 VPWR VGND VPWR VGND sky130_fd_sc_hd__decap_3
XFILLER_10_112 VPWR VGND VPWR VGND sky130_fd_sc_hd__decap_3
X_150_ VPWR VGND VGND VPWR _069_ genblk1\[5\].fa_inst.b genblk1\[5\].fa_inst.a _150_/a_150_297#
+ _150_/a_68_297# sky130_fd_sc_hd__or2_1
XFILLER_10_156 VPWR VGND VPWR VGND sky130_fd_sc_hd__decap_3
XFILLER_6_127 VPWR VGND VPWR VGND sky130_fd_sc_hd__decap_3
XFILLER_12_41 VPWR VGND VPWR VGND sky130_fd_sc_hd__decap_3
XFILLER_12_85 VPWR VGND VPWR VGND sky130_fd_sc_hd__decap_3
XFILLER_12_74 VPWR VGND VPWR VGND sky130_fd_sc_hd__decap_3
XFILLER_2_366 VPWR VGND VPWR VGND sky130_fd_sc_hd__decap_3
XFILLER_2_399 VPWR VGND VPWR VGND sky130_fd_sc_hd__decap_3
XFILLER_58_392 VPWR VGND VPWR VGND sky130_fd_sc_hd__decap_3
XFILLER_37_60 VPWR VGND VPWR VGND sky130_fd_sc_hd__decap_3
XFILLER_33_237 VPWR VGND VPWR VGND sky130_fd_sc_hd__decap_3
XFILLER_53_81 VPWR VGND VPWR VGND sky130_fd_sc_hd__decap_3
XFILLER_41_270 VPWR VGND VPWR VGND sky130_fd_sc_hd__decap_3
XFILLER_41_281 VPWR VGND VPWR VGND sky130_fd_sc_hd__decap_3
X_279_ VGND VPWR VPWR VGND clknet_2_1__leaf_clk_regs net14 _024_ genblk1\[7\].fa_inst.a
+ _279_/a_1462_47# _279_/a_543_47# _279_/a_651_413# _279_/a_193_47# _279_/a_805_47#
+ _279_/a_448_47# _279_/a_639_47# _279_/a_1283_21# _279_/a_761_289# _279_/a_1108_47#
+ _279_/a_1217_47# _279_/a_1270_413# _279_/a_27_47# sky130_fd_sc_hd__dfrtp_1
XFILLER_45_3 VPWR VGND VPWR VGND sky130_fd_sc_hd__decap_3
XFILLER_56_318 VPWR VGND VPWR VGND sky130_fd_sc_hd__decap_3
XFILLER_49_370 VPWR VGND VPWR VGND sky130_fd_sc_hd__decap_3
XFILLER_64_340 VPWR VGND VPWR VGND sky130_fd_sc_hd__decap_3
XFILLER_24_215 VPWR VGND VPWR VGND sky130_fd_sc_hd__decap_3
XFILLER_24_248 VPWR VGND VPWR VGND sky130_fd_sc_hd__decap_3
XFILLER_24_259 VPWR VGND VPWR VGND sky130_fd_sc_hd__decap_3
XFILLER_32_292 VPWR VGND VPWR VGND sky130_fd_sc_hd__decap_3
XFILLER_3_119 VPWR VGND VPWR VGND sky130_fd_sc_hd__decap_3
XFILLER_58_15 VPWR VGND VPWR VGND sky130_fd_sc_hd__decap_3
XFILLER_59_123 VPWR VGND VPWR VGND sky130_fd_sc_hd__decap_3
XFILLER_59_178 VPWR VGND VPWR VGND sky130_fd_sc_hd__decap_3
XFILLER_59_156 VPWR VGND VPWR VGND sky130_fd_sc_hd__decap_3
XFILLER_47_329 VPWR VGND VPWR VGND sky130_fd_sc_hd__decap_3
XFILLER_55_340 VPWR VGND VPWR VGND sky130_fd_sc_hd__decap_3
XFILLER_55_373 VPWR VGND VPWR VGND sky130_fd_sc_hd__decap_3
XFILLER_30_218 VPWR VGND VPWR VGND sky130_fd_sc_hd__decap_3
X_202_ VPWR VGND VGND VPWR genblk1\[15\].fa_inst.b genblk1\[15\].fa_inst.a _111_ _202_/a_109_297#
+ sky130_fd_sc_hd__nor2_1
XFILLER_23_270 VPWR VGND VPWR VGND sky130_fd_sc_hd__decap_3
XFILLER_23_281 VPWR VGND VPWR VGND sky130_fd_sc_hd__decap_3
XFILLER_7_403 VPWR VGND VPWR VGND sky130_fd_sc_hd__decap_3
X_133_ VPWR VGND VGND VPWR _054_ _056_ _055_ _133_/a_113_47# sky130_fd_sc_hd__nand2_1
XFILLER_2_130 VPWR VGND VPWR VGND sky130_fd_sc_hd__decap_3
XFILLER_2_174 VPWR VGND VPWR VGND sky130_fd_sc_hd__decap_3
XFILLER_2_141 VPWR VGND VPWR VGND sky130_fd_sc_hd__decap_3
XFILLER_31_9 VPWR VGND VPWR VGND sky130_fd_sc_hd__decap_3
XFILLER_38_318 VPWR VGND VPWR VGND sky130_fd_sc_hd__decap_3
XFILLER_46_351 VPWR VGND VPWR VGND sky130_fd_sc_hd__decap_3
XFILLER_0_44 VPWR VGND VPWR VGND sky130_fd_sc_hd__decap_3
XFILLER_0_66 VPWR VGND VPWR VGND sky130_fd_sc_hd__decap_3
XFILLER_61_343 VPWR VGND VPWR VGND sky130_fd_sc_hd__decap_3
XFILLER_61_332 VPWR VGND VPWR VGND sky130_fd_sc_hd__decap_3
XFILLER_64_91 VPWR VGND VPWR VGND sky130_fd_sc_hd__decap_3
XFILLER_46_395 VPWR VGND VPWR VGND sky130_fd_sc_hd__decap_3
XFILLER_0_88 VPWR VGND VPWR VGND sky130_fd_sc_hd__decap_3
XFILLER_61_376 VPWR VGND VPWR VGND sky130_fd_sc_hd__decap_3
XFILLER_21_218 VPWR VGND VPWR VGND sky130_fd_sc_hd__decap_3
XFILLER_9_31 VPWR VGND VPWR VGND sky130_fd_sc_hd__decap_3
XFILLER_9_75 VPWR VGND VPWR VGND sky130_fd_sc_hd__decap_3
XFILLER_28_18 VPWR VGND VPWR VGND sky130_fd_sc_hd__decap_3
XFILLER_29_329 VPWR VGND VPWR VGND sky130_fd_sc_hd__decap_3
XFILLER_56_115 VPWR VGND VPWR VGND sky130_fd_sc_hd__decap_3
XFILLER_37_340 VPWR VGND VPWR VGND sky130_fd_sc_hd__decap_3
XFILLER_56_159 VPWR VGND VPWR VGND sky130_fd_sc_hd__decap_3
XFILLER_37_373 VPWR VGND VPWR VGND sky130_fd_sc_hd__decap_3
XFILLER_64_181 VPWR VGND VPWR VGND sky130_fd_sc_hd__decap_3
XFILLER_52_321 VPWR VGND VPWR VGND sky130_fd_sc_hd__decap_3
XFILLER_52_365 VPWR VGND VPWR VGND sky130_fd_sc_hd__decap_3
XFILLER_52_354 VPWR VGND VPWR VGND sky130_fd_sc_hd__decap_3
XFILLER_52_398 VPWR VGND VPWR VGND sky130_fd_sc_hd__decap_3
XFILLER_60_38 VPWR VGND VPWR VGND sky130_fd_sc_hd__decap_3
XFILLER_47_137 VPWR VGND VPWR VGND sky130_fd_sc_hd__decap_3
XFILLER_28_351 VPWR VGND VPWR VGND sky130_fd_sc_hd__decap_3
XFILLER_62_118 VPWR VGND VPWR VGND sky130_fd_sc_hd__decap_3
XFILLER_43_343 VPWR VGND VPWR VGND sky130_fd_sc_hd__decap_3
XFILLER_43_332 VPWR VGND VPWR VGND sky130_fd_sc_hd__decap_3
XFILLER_28_395 VPWR VGND VPWR VGND sky130_fd_sc_hd__decap_3
XFILLER_55_181 VPWR VGND VPWR VGND sky130_fd_sc_hd__decap_3
XFILLER_43_376 VPWR VGND VPWR VGND sky130_fd_sc_hd__decap_3
XPHY_EDGE_ROW_10_2_Left_31 VPWR VGND VPWR VGND sky130_fd_sc_hd__decap_3
XFILLER_34_50 VPWR VGND VPWR VGND sky130_fd_sc_hd__decap_3
XFILLER_34_94 VPWR VGND VPWR VGND sky130_fd_sc_hd__decap_3
XFILLER_50_71 VPWR VGND VPWR VGND sky130_fd_sc_hd__decap_3
XFILLER_38_115 VPWR VGND VPWR VGND sky130_fd_sc_hd__decap_3
XFILLER_19_340 VPWR VGND VPWR VGND sky130_fd_sc_hd__decap_3
XFILLER_38_159 VPWR VGND VPWR VGND sky130_fd_sc_hd__decap_3
XFILLER_19_373 VPWR VGND VPWR VGND sky130_fd_sc_hd__decap_3
XFILLER_34_321 VPWR VGND VPWR VGND sky130_fd_sc_hd__decap_3
XFILLER_46_192 VPWR VGND VPWR VGND sky130_fd_sc_hd__decap_3
XFILLER_61_140 VPWR VGND VPWR VGND sky130_fd_sc_hd__decap_3
XFILLER_34_354 VPWR VGND VPWR VGND sky130_fd_sc_hd__decap_3
XFILLER_34_365 VPWR VGND VPWR VGND sky130_fd_sc_hd__decap_3
XFILLER_61_184 VPWR VGND VPWR VGND sky130_fd_sc_hd__decap_3
XFILLER_34_398 VPWR VGND VPWR VGND sky130_fd_sc_hd__decap_3
XPHY_EDGE_ROW_10_1_Right_9 VPWR VGND VPWR VGND sky130_fd_sc_hd__decap_3
XFILLER_29_137 VPWR VGND VPWR VGND sky130_fd_sc_hd__decap_3
XFILLER_44_118 VPWR VGND VPWR VGND sky130_fd_sc_hd__decap_3
XFILLER_37_181 VPWR VGND VPWR VGND sky130_fd_sc_hd__decap_3
XFILLER_25_332 VPWR VGND VPWR VGND sky130_fd_sc_hd__decap_3
XFILLER_25_343 VPWR VGND VPWR VGND sky130_fd_sc_hd__decap_3
XFILLER_25_376 VPWR VGND VPWR VGND sky130_fd_sc_hd__decap_3
XFILLER_52_162 VPWR VGND VPWR VGND sky130_fd_sc_hd__decap_3
XFILLER_40_324 VPWR VGND VPWR VGND sky130_fd_sc_hd__decap_3
XFILLER_40_368 VPWR VGND VPWR VGND sky130_fd_sc_hd__decap_3
XFILLER_40_357 VPWR VGND VPWR VGND sky130_fd_sc_hd__decap_3
XFILLER_20_41 VPWR VGND VPWR VGND sky130_fd_sc_hd__decap_3
XFILLER_20_85 VPWR VGND VPWR VGND sky130_fd_sc_hd__decap_3
XFILLER_29_72 VPWR VGND VPWR VGND sky130_fd_sc_hd__decap_3
XFILLER_28_192 VPWR VGND VPWR VGND sky130_fd_sc_hd__decap_3
XFILLER_16_354 VPWR VGND VPWR VGND sky130_fd_sc_hd__decap_3
XFILLER_16_343 VPWR VGND VPWR VGND sky130_fd_sc_hd__decap_3
XFILLER_45_82 VPWR VGND VPWR VGND sky130_fd_sc_hd__decap_3
XFILLER_43_140 VPWR VGND VPWR VGND sky130_fd_sc_hd__decap_3
XFILLER_16_387 VPWR VGND VPWR VGND sky130_fd_sc_hd__decap_3
XFILLER_31_302 VPWR VGND VPWR VGND sky130_fd_sc_hd__decap_3
XFILLER_43_184 VPWR VGND VPWR VGND sky130_fd_sc_hd__decap_3
XFILLER_31_346 VPWR VGND VPWR VGND sky130_fd_sc_hd__decap_3
XFILLER_31_379 VPWR VGND VPWR VGND sky130_fd_sc_hd__decap_3
XFILLER_61_81 VPWR VGND VPWR VGND sky130_fd_sc_hd__decap_3
XFILLER_6_21 VPWR VGND VPWR VGND sky130_fd_sc_hd__decap_3
XFILLER_6_32 VPWR VGND VPWR VGND sky130_fd_sc_hd__decap_3
XANTENNA_3 net52 VGND VPWR VPWR VGND sky130_fd_sc_hd__diode_2
Xpmu_inst_68 net68 pmu_inst_68/HI VPWR VGND VGND VPWR sky130_fd_sc_hd__conb_1
XFILLER_39_402 VPWR VGND VPWR VGND sky130_fd_sc_hd__decap_3
XFILLER_26_118 VPWR VGND VPWR VGND sky130_fd_sc_hd__decap_3
XFILLER_34_162 VPWR VGND VPWR VGND sky130_fd_sc_hd__decap_3
XFILLER_22_324 VPWR VGND VPWR VGND sky130_fd_sc_hd__decap_3
XFILLER_22_357 VPWR VGND VPWR VGND sky130_fd_sc_hd__decap_3
XFILLER_22_368 VPWR VGND VPWR VGND sky130_fd_sc_hd__decap_3
XFILLER_57_243 VPWR VGND VPWR VGND sky130_fd_sc_hd__decap_3
XFILLER_57_276 VPWR VGND VPWR VGND sky130_fd_sc_hd__decap_3
XFILLER_25_140 VPWR VGND VPWR VGND sky130_fd_sc_hd__decap_3
XFILLER_25_184 VPWR VGND VPWR VGND sky130_fd_sc_hd__decap_3
XFILLER_13_346 VPWR VGND VPWR VGND sky130_fd_sc_hd__decap_3
XFILLER_15_63 VPWR VGND VPWR VGND sky130_fd_sc_hd__decap_3
XFILLER_15_52 VPWR VGND VPWR VGND sky130_fd_sc_hd__decap_3
XFILLER_40_121 VPWR VGND VPWR VGND sky130_fd_sc_hd__decap_3
XFILLER_9_328 VPWR VGND VPWR VGND sky130_fd_sc_hd__decap_3
XFILLER_15_96 VPWR VGND VPWR VGND sky130_fd_sc_hd__decap_3
XFILLER_40_165 VPWR VGND VPWR VGND sky130_fd_sc_hd__decap_3
XFILLER_31_84 VPWR VGND VPWR VGND sky130_fd_sc_hd__decap_3
Xoutput40 VPWR VGND s[10] net40 VPWR VGND output40/a_27_47# sky130_fd_sc_hd__buf_2
Xoutput51 VPWR VGND s[6] net51 VPWR VGND output51/a_27_47# sky130_fd_sc_hd__buf_2
XFILLER_48_221 VPWR VGND VPWR VGND sky130_fd_sc_hd__decap_3
XFILLER_63_202 VPWR VGND VPWR VGND sky130_fd_sc_hd__decap_3
XFILLER_48_265 VPWR VGND VPWR VGND sky130_fd_sc_hd__decap_3
XFILLER_63_246 VPWR VGND VPWR VGND sky130_fd_sc_hd__decap_3
XFILLER_48_298 VPWR VGND VPWR VGND sky130_fd_sc_hd__decap_3
XFILLER_16_162 VPWR VGND VPWR VGND sky130_fd_sc_hd__decap_3
XFILLER_31_143 VPWR VGND VPWR VGND sky130_fd_sc_hd__decap_3
XFILLER_12_390 VPWR VGND VPWR VGND sky130_fd_sc_hd__decap_3
XFILLER_31_187 VPWR VGND VPWR VGND sky130_fd_sc_hd__decap_3
XFILLER_8_372 VPWR VGND VPWR VGND sky130_fd_sc_hd__decap_3
XFILLER_39_243 VPWR VGND VPWR VGND sky130_fd_sc_hd__decap_3
XFILLER_36_18 VPWR VGND VPWR VGND sky130_fd_sc_hd__decap_3
XFILLER_39_276 VPWR VGND VPWR VGND sky130_fd_sc_hd__decap_3
XFILLER_39_287 VPWR VGND VPWR VGND sky130_fd_sc_hd__decap_3
XFILLER_54_224 VPWR VGND VPWR VGND sky130_fd_sc_hd__decap_3
XFILLER_54_268 VPWR VGND VPWR VGND sky130_fd_sc_hd__decap_3
XFILLER_22_121 VPWR VGND VPWR VGND sky130_fd_sc_hd__decap_3
XFILLER_22_165 VPWR VGND VPWR VGND sky130_fd_sc_hd__decap_3
XFILLER_10_349 VPWR VGND VPWR VGND sky130_fd_sc_hd__decap_3
XFILLER_7_6 VPWR VGND VPWR VGND sky130_fd_sc_hd__decap_3
XFILLER_45_202 VPWR VGND VPWR VGND sky130_fd_sc_hd__decap_3
XFILLER_45_246 VPWR VGND VPWR VGND sky130_fd_sc_hd__decap_3
XFILLER_60_227 VPWR VGND VPWR VGND sky130_fd_sc_hd__decap_3
XFILLER_53_290 VPWR VGND VPWR VGND sky130_fd_sc_hd__decap_3
XFILLER_13_143 VPWR VGND VPWR VGND sky130_fd_sc_hd__decap_3
XFILLER_9_125 VPWR VGND VPWR VGND sky130_fd_sc_hd__decap_3
XFILLER_9_158 VPWR VGND VPWR VGND sky130_fd_sc_hd__decap_3
X_295_ VGND VPWR VPWR VGND clknet_2_1__leaf_clk_regs net30 _040_ genblk1\[7\].fa_inst.b
+ _295_/a_1462_47# _295_/a_543_47# _295_/a_651_413# _295_/a_193_47# _295_/a_805_47#
+ _295_/a_448_47# _295_/a_639_47# _295_/a_1283_21# _295_/a_761_289# _295_/a_1108_47#
+ _295_/a_1217_47# _295_/a_1270_413# _295_/a_27_47# sky130_fd_sc_hd__dfrtp_1
XFILLER_42_50 VPWR VGND VPWR VGND sky130_fd_sc_hd__decap_3
XFILLER_9_169 VPWR VGND VPWR VGND sky130_fd_sc_hd__decap_3
XFILLER_61_9 VPWR VGND VPWR VGND sky130_fd_sc_hd__decap_3
XFILLER_5_331 VPWR VGND VPWR VGND sky130_fd_sc_hd__decap_3
XFILLER_5_364 VPWR VGND VPWR VGND sky130_fd_sc_hd__decap_3
XFILLER_5_397 VPWR VGND VPWR VGND sky130_fd_sc_hd__decap_3
XFILLER_3_66 VPWR VGND VPWR VGND sky130_fd_sc_hd__decap_3
XFILLER_36_224 VPWR VGND VPWR VGND sky130_fd_sc_hd__decap_3
XFILLER_36_268 VPWR VGND VPWR VGND sky130_fd_sc_hd__decap_3
XFILLER_51_205 VPWR VGND VPWR VGND sky130_fd_sc_hd__decap_3
XFILLER_51_249 VPWR VGND VPWR VGND sky130_fd_sc_hd__decap_3
XFILLER_59_305 VPWR VGND VPWR VGND sky130_fd_sc_hd__decap_3
XFILLER_59_349 VPWR VGND VPWR VGND sky130_fd_sc_hd__decap_3
XFILLER_47_39 VPWR VGND VPWR VGND sky130_fd_sc_hd__decap_3
XFILLER_27_202 VPWR VGND VPWR VGND sky130_fd_sc_hd__decap_3
XFILLER_27_246 VPWR VGND VPWR VGND sky130_fd_sc_hd__decap_3
XFILLER_63_49 VPWR VGND VPWR VGND sky130_fd_sc_hd__decap_3
XFILLER_63_16 VPWR VGND VPWR VGND sky130_fd_sc_hd__decap_3
XFILLER_42_227 VPWR VGND VPWR VGND sky130_fd_sc_hd__decap_3
XFILLER_35_290 VPWR VGND VPWR VGND sky130_fd_sc_hd__decap_3
XFILLER_10_124 VPWR VGND VPWR VGND sky130_fd_sc_hd__decap_3
XFILLER_50_271 VPWR VGND VPWR VGND sky130_fd_sc_hd__decap_3
XFILLER_10_168 VPWR VGND VPWR VGND sky130_fd_sc_hd__decap_3
XFILLER_6_106 VPWR VGND VPWR VGND sky130_fd_sc_hd__decap_3
XFILLER_12_53 VPWR VGND VPWR VGND sky130_fd_sc_hd__decap_3
XFILLER_12_97 VPWR VGND VPWR VGND sky130_fd_sc_hd__decap_3
XFILLER_2_334 VPWR VGND VPWR VGND sky130_fd_sc_hd__decap_3
XFILLER_5_3 VPWR VGND VPWR VGND sky130_fd_sc_hd__decap_3
XFILLER_2_378 VPWR VGND VPWR VGND sky130_fd_sc_hd__decap_3
XFILLER_58_360 VPWR VGND VPWR VGND sky130_fd_sc_hd__decap_3
XFILLER_58_371 VPWR VGND VPWR VGND sky130_fd_sc_hd__decap_3
XFILLER_37_83 VPWR VGND VPWR VGND sky130_fd_sc_hd__decap_3
XFILLER_33_205 VPWR VGND VPWR VGND sky130_fd_sc_hd__decap_3
XFILLER_33_249 VPWR VGND VPWR VGND sky130_fd_sc_hd__decap_3
XFILLER_53_60 VPWR VGND VPWR VGND sky130_fd_sc_hd__decap_3
XFILLER_41_293 VPWR VGND VPWR VGND sky130_fd_sc_hd__decap_3
XFILLER_53_93 VPWR VGND VPWR VGND sky130_fd_sc_hd__decap_3
X_278_ VGND VPWR VPWR VGND clknet_2_1__leaf_clk_regs net13 _023_ genblk1\[6\].fa_inst.a
+ _278_/a_1462_47# _278_/a_543_47# _278_/a_651_413# _278_/a_193_47# _278_/a_805_47#
+ _278_/a_448_47# _278_/a_639_47# _278_/a_1283_21# _278_/a_761_289# _278_/a_1108_47#
+ _278_/a_1217_47# _278_/a_1270_413# _278_/a_27_47# sky130_fd_sc_hd__dfrtp_1
XFILLER_5_161 VPWR VGND VPWR VGND sky130_fd_sc_hd__decap_3
XFILLER_5_172 VPWR VGND VPWR VGND sky130_fd_sc_hd__decap_3
XFILLER_49_393 VPWR VGND VPWR VGND sky130_fd_sc_hd__decap_3
XFILLER_49_382 VPWR VGND VPWR VGND sky130_fd_sc_hd__decap_3
XFILLER_64_352 VPWR VGND VPWR VGND sky130_fd_sc_hd__decap_3
XFILLER_64_374 VPWR VGND VPWR VGND sky130_fd_sc_hd__decap_3
XFILLER_24_227 VPWR VGND VPWR VGND sky130_fd_sc_hd__decap_3
XFILLER_64_396 VPWR VGND VPWR VGND sky130_fd_sc_hd__decap_3
XFILLER_32_271 VPWR VGND VPWR VGND sky130_fd_sc_hd__decap_3
XFILLER_59_102 VPWR VGND VPWR VGND sky130_fd_sc_hd__decap_3
XFILLER_58_38 VPWR VGND VPWR VGND sky130_fd_sc_hd__decap_3
XFILLER_59_135 VPWR VGND VPWR VGND sky130_fd_sc_hd__decap_3
XFILLER_47_308 VPWR VGND VPWR VGND sky130_fd_sc_hd__decap_3
XFILLER_55_352 VPWR VGND VPWR VGND sky130_fd_sc_hd__decap_3
XFILLER_55_385 VPWR VGND VPWR VGND sky130_fd_sc_hd__decap_3
XFILLER_55_396 VPWR VGND VPWR VGND sky130_fd_sc_hd__decap_3
XFILLER_11_400 VPWR VGND VPWR VGND sky130_fd_sc_hd__decap_3
X_201_ VGND VPWR VPWR VGND _106_ _108_ _110_ _105_ _201_/a_61_47# _201_/a_479_47#
+ _201_/a_217_297# _201_/a_637_47# sky130_fd_sc_hd__a21boi_2
X_132_ VPWR VGND VGND VPWR genblk1\[1\].fa_inst.b _055_ genblk1\[1\].fa_inst.a _132_/a_113_47#
+ sky130_fd_sc_hd__nand2_1
XFILLER_23_63 VPWR VGND VPWR VGND sky130_fd_sc_hd__decap_3
XFILLER_23_293 VPWR VGND VPWR VGND sky130_fd_sc_hd__decap_3
XFILLER_23_96 VPWR VGND VPWR VGND sky130_fd_sc_hd__decap_3
XFILLER_2_153 VPWR VGND VPWR VGND sky130_fd_sc_hd__decap_3
XFILLER_24_9 VPWR VGND VPWR VGND sky130_fd_sc_hd__decap_3
XFILLER_46_330 VPWR VGND VPWR VGND sky130_fd_sc_hd__decap_3
XFILLER_0_12 VPWR VGND VPWR VGND sky130_fd_sc_hd__decap_3
XFILLER_61_311 VPWR VGND VPWR VGND sky130_fd_sc_hd__decap_3
XFILLER_46_374 VPWR VGND VPWR VGND sky130_fd_sc_hd__decap_3
XFILLER_0_78 VPWR VGND VPWR VGND sky130_fd_sc_hd__decap_3
XFILLER_64_81 VPWR VGND VPWR VGND sky130_fd_sc_hd__decap_3
XFILLER_61_355 VPWR VGND VPWR VGND sky130_fd_sc_hd__decap_3
XFILLER_61_399 VPWR VGND VPWR VGND sky130_fd_sc_hd__decap_3
XFILLER_61_388 VPWR VGND VPWR VGND sky130_fd_sc_hd__decap_3
XFILLER_9_43 VPWR VGND VPWR VGND sky130_fd_sc_hd__decap_3
XFILLER_9_87 VPWR VGND VPWR VGND sky130_fd_sc_hd__decap_3
XFILLER_29_308 VPWR VGND VPWR VGND sky130_fd_sc_hd__decap_3
XPHY_EDGE_ROW_14_1_Left_120 VPWR VGND VPWR VGND sky130_fd_sc_hd__decap_3
XFILLER_56_127 VPWR VGND VPWR VGND sky130_fd_sc_hd__decap_3
XFILLER_49_190 VPWR VGND VPWR VGND sky130_fd_sc_hd__decap_3
XFILLER_37_352 VPWR VGND VPWR VGND sky130_fd_sc_hd__decap_3
XFILLER_37_385 VPWR VGND VPWR VGND sky130_fd_sc_hd__decap_3
XFILLER_64_193 VPWR VGND VPWR VGND sky130_fd_sc_hd__decap_3
XFILLER_52_333 VPWR VGND VPWR VGND sky130_fd_sc_hd__decap_3
XFILLER_37_396 VPWR VGND VPWR VGND sky130_fd_sc_hd__decap_3
XFILLER_44_18 VPWR VGND VPWR VGND sky130_fd_sc_hd__decap_3
XFILLER_44_29 VPWR VGND VPWR VGND sky130_fd_sc_hd__decap_3
XFILLER_52_377 VPWR VGND VPWR VGND sky130_fd_sc_hd__decap_3
XFILLER_47_116 VPWR VGND VPWR VGND sky130_fd_sc_hd__decap_3
XFILLER_47_105 VPWR VGND VPWR VGND sky130_fd_sc_hd__decap_3
XFILLER_18_41 VPWR VGND VPWR VGND sky130_fd_sc_hd__decap_3
XFILLER_28_330 VPWR VGND VPWR VGND sky130_fd_sc_hd__decap_3
XFILLER_47_149 VPWR VGND VPWR VGND sky130_fd_sc_hd__decap_3
XFILLER_18_74 VPWR VGND VPWR VGND sky130_fd_sc_hd__decap_3
XFILLER_18_85 VPWR VGND VPWR VGND sky130_fd_sc_hd__decap_3
XFILLER_28_374 VPWR VGND VPWR VGND sky130_fd_sc_hd__decap_3
XFILLER_43_311 VPWR VGND VPWR VGND sky130_fd_sc_hd__decap_3
XFILLER_55_193 VPWR VGND VPWR VGND sky130_fd_sc_hd__decap_3
XFILLER_43_355 VPWR VGND VPWR VGND sky130_fd_sc_hd__decap_3
XFILLER_43_399 VPWR VGND VPWR VGND sky130_fd_sc_hd__decap_3
XFILLER_43_388 VPWR VGND VPWR VGND sky130_fd_sc_hd__decap_3
XFILLER_34_62 VPWR VGND VPWR VGND sky130_fd_sc_hd__decap_3
XFILLER_50_50 VPWR VGND VPWR VGND sky130_fd_sc_hd__decap_3
XFILLER_50_94 VPWR VGND VPWR VGND sky130_fd_sc_hd__decap_3
XFILLER_59_81 VPWR VGND VPWR VGND sky130_fd_sc_hd__decap_3
XFILLER_22_6 VPWR VGND VPWR VGND sky130_fd_sc_hd__decap_3
XFILLER_38_127 VPWR VGND VPWR VGND sky130_fd_sc_hd__decap_3
XFILLER_19_352 VPWR VGND VPWR VGND sky130_fd_sc_hd__decap_3
XFILLER_53_108 VPWR VGND VPWR VGND sky130_fd_sc_hd__decap_3
XFILLER_53_119 VPWR VGND VPWR VGND sky130_fd_sc_hd__decap_3
XFILLER_19_385 VPWR VGND VPWR VGND sky130_fd_sc_hd__decap_3
XFILLER_34_333 VPWR VGND VPWR VGND sky130_fd_sc_hd__decap_3
XFILLER_46_171 VPWR VGND VPWR VGND sky130_fd_sc_hd__decap_3
XFILLER_61_152 VPWR VGND VPWR VGND sky130_fd_sc_hd__decap_3
XFILLER_34_377 VPWR VGND VPWR VGND sky130_fd_sc_hd__decap_3
XFILLER_61_196 VPWR VGND VPWR VGND sky130_fd_sc_hd__decap_3
XFILLER_29_116 VPWR VGND VPWR VGND sky130_fd_sc_hd__decap_3
XFILLER_29_149 VPWR VGND VPWR VGND sky130_fd_sc_hd__decap_3
XFILLER_37_193 VPWR VGND VPWR VGND sky130_fd_sc_hd__decap_3
XFILLER_25_311 VPWR VGND VPWR VGND sky130_fd_sc_hd__decap_3
XFILLER_25_355 VPWR VGND VPWR VGND sky130_fd_sc_hd__decap_3
XFILLER_52_141 VPWR VGND VPWR VGND sky130_fd_sc_hd__decap_3
XFILLER_25_388 VPWR VGND VPWR VGND sky130_fd_sc_hd__decap_3
XFILLER_25_399 VPWR VGND VPWR VGND sky130_fd_sc_hd__decap_3
XFILLER_52_174 VPWR VGND VPWR VGND sky130_fd_sc_hd__decap_3
XFILLER_40_336 VPWR VGND VPWR VGND sky130_fd_sc_hd__decap_3
XPHY_EDGE_ROW_33_Left_139 VPWR VGND VPWR VGND sky130_fd_sc_hd__decap_3
XPHY_EDGE_ROW_49_Right_70 VPWR VGND VPWR VGND sky130_fd_sc_hd__decap_3
XFILLER_20_53 VPWR VGND VPWR VGND sky130_fd_sc_hd__decap_3
XPHY_EDGE_ROW_42_Left_148 VPWR VGND VPWR VGND sky130_fd_sc_hd__decap_3
XFILLER_29_84 VPWR VGND VPWR VGND sky130_fd_sc_hd__decap_3
XFILLER_35_119 VPWR VGND VPWR VGND sky130_fd_sc_hd__decap_3
XFILLER_28_171 VPWR VGND VPWR VGND sky130_fd_sc_hd__decap_3
XFILLER_16_366 VPWR VGND VPWR VGND sky130_fd_sc_hd__decap_3
XFILLER_45_50 VPWR VGND VPWR VGND sky130_fd_sc_hd__decap_3
XFILLER_43_152 VPWR VGND VPWR VGND sky130_fd_sc_hd__decap_3
XFILLER_16_399 VPWR VGND VPWR VGND sky130_fd_sc_hd__decap_3
XFILLER_31_314 VPWR VGND VPWR VGND sky130_fd_sc_hd__decap_3
XFILLER_45_94 VPWR VGND VPWR VGND sky130_fd_sc_hd__decap_3
XFILLER_31_358 VPWR VGND VPWR VGND sky130_fd_sc_hd__decap_3
XPHY_EDGE_ROW_51_Left_157 VPWR VGND VPWR VGND sky130_fd_sc_hd__decap_3
XFILLER_43_196 VPWR VGND VPWR VGND sky130_fd_sc_hd__decap_3
XFILLER_61_60 VPWR VGND VPWR VGND sky130_fd_sc_hd__decap_3
XFILLER_61_93 VPWR VGND VPWR VGND sky130_fd_sc_hd__decap_3
XFILLER_6_44 VPWR VGND VPWR VGND sky130_fd_sc_hd__decap_3
Xpmu_inst_69 net69 pmu_inst_69/HI VPWR VGND VGND VPWR sky130_fd_sc_hd__conb_1
XFILLER_6_88 VPWR VGND VPWR VGND sky130_fd_sc_hd__decap_3
XPHY_EDGE_ROW_60_Left_166 VPWR VGND VPWR VGND sky130_fd_sc_hd__decap_3
XPHY_EDGE_ROW_2_1_Left_108 VPWR VGND VPWR VGND sky130_fd_sc_hd__decap_3
XFILLER_34_130 VPWR VGND VPWR VGND sky130_fd_sc_hd__decap_3
XFILLER_34_141 VPWR VGND VPWR VGND sky130_fd_sc_hd__decap_3
XPHY_EDGE_ROW_4_2_Left_25 VPWR VGND VPWR VGND sky130_fd_sc_hd__decap_3
XFILLER_34_174 VPWR VGND VPWR VGND sky130_fd_sc_hd__decap_3
XFILLER_22_336 VPWR VGND VPWR VGND sky130_fd_sc_hd__decap_3
XFILLER_30_380 VPWR VGND VPWR VGND sky130_fd_sc_hd__decap_3
XFILLER_57_211 VPWR VGND VPWR VGND sky130_fd_sc_hd__decap_3
XFILLER_57_255 VPWR VGND VPWR VGND sky130_fd_sc_hd__decap_3
XFILLER_17_119 VPWR VGND VPWR VGND sky130_fd_sc_hd__decap_3
XFILLER_25_152 VPWR VGND VPWR VGND sky130_fd_sc_hd__decap_3
XFILLER_13_358 VPWR VGND VPWR VGND sky130_fd_sc_hd__decap_3
XFILLER_15_75 VPWR VGND VPWR VGND sky130_fd_sc_hd__decap_3
XFILLER_25_196 VPWR VGND VPWR VGND sky130_fd_sc_hd__decap_3
XFILLER_40_133 VPWR VGND VPWR VGND sky130_fd_sc_hd__decap_3
XFILLER_40_144 VPWR VGND VPWR VGND sky130_fd_sc_hd__decap_3
XFILLER_40_177 VPWR VGND VPWR VGND sky130_fd_sc_hd__decap_3
XFILLER_21_380 VPWR VGND VPWR VGND sky130_fd_sc_hd__decap_3
XFILLER_31_41 VPWR VGND VPWR VGND sky130_fd_sc_hd__decap_3
XFILLER_31_63 VPWR VGND VPWR VGND sky130_fd_sc_hd__decap_3
XFILLER_31_96 VPWR VGND VPWR VGND sky130_fd_sc_hd__decap_3
Xoutput41 VPWR VGND s[11] net41 VPWR VGND output41/a_27_47# sky130_fd_sc_hd__buf_2
Xoutput52 VPWR VGND s[7] net52 VPWR VGND output52/a_27_47# sky130_fd_sc_hd__buf_2
XFILLER_48_200 VPWR VGND VPWR VGND sky130_fd_sc_hd__decap_3
XFILLER_48_233 VPWR VGND VPWR VGND sky130_fd_sc_hd__decap_3
XFILLER_48_277 VPWR VGND VPWR VGND sky130_fd_sc_hd__decap_3
XFILLER_63_225 VPWR VGND VPWR VGND sky130_fd_sc_hd__decap_3
XFILLER_63_214 VPWR VGND VPWR VGND sky130_fd_sc_hd__decap_3
XFILLER_56_71 VPWR VGND VPWR VGND sky130_fd_sc_hd__decap_3
XFILLER_63_258 VPWR VGND VPWR VGND sky130_fd_sc_hd__decap_3
XFILLER_16_141 VPWR VGND VPWR VGND sky130_fd_sc_hd__decap_3
XFILLER_16_174 VPWR VGND VPWR VGND sky130_fd_sc_hd__decap_3
XFILLER_31_122 VPWR VGND VPWR VGND sky130_fd_sc_hd__decap_3
XFILLER_31_155 VPWR VGND VPWR VGND sky130_fd_sc_hd__decap_3
XFILLER_31_199 VPWR VGND VPWR VGND sky130_fd_sc_hd__decap_3
XFILLER_8_340 VPWR VGND VPWR VGND sky130_fd_sc_hd__decap_3
XFILLER_8_384 VPWR VGND VPWR VGND sky130_fd_sc_hd__decap_3
XPHY_EDGE_ROW_0_2_Right_86 VPWR VGND VPWR VGND sky130_fd_sc_hd__decap_3
C0 net4 _278_/a_543_47# 0.01269f
C1 net27 net62 0.16801f
C2 _285_/a_448_47# clknet_2_3__leaf_clk_regs 0.01419f
C3 _276_/a_27_47# _291_/a_27_47# 0
C4 _281_/a_639_47# net31 0
C5 genblk1\[11\].fa_inst.a _043_ 0
C6 VPWR _287_/a_1217_47# 0
C7 net5 b[6] 0
C8 genblk1\[0\].fa_inst.a _050_ 0.00763f
C9 net46 pmu_inst/dc_inst.x6.x4/a_27_47# 0.00304f
C10 _271_/a_448_47# cout_next 0.00491f
C11 _276_/a_448_47# net16 0
C12 _292_/a_1462_47# clknet_2_0__leaf_clk_regs 0.00184f
C13 VPWR net73 0.29751f
C14 _300_/a_193_47# net60 0.00195f
C15 _273_/a_448_47# clknet_2_1__leaf_clk_regs 0
C16 _273_/a_1283_21# _018_ 0.05464f
C17 _273_/a_193_47# genblk1\[1\].fa_inst.a 0.0014f
C18 VPWR _205_/a_47_47# 0.04913f
C19 _203_/a_109_297# _109_ 0.00285f
C20 _096_ VPWR 0.54968f
C21 _285_/a_448_47# net32 0
C22 _100_ _096_ 0.03808f
C23 net47 VPWR 4.24996f
C24 _292_/a_805_47# VPWR 0
C25 clknet_2_0__leaf_clk_regs _261_/a_27_47# 0
C26 net30 _040_ 0.1747f
C27 _270_/a_1270_413# clk 0
C28 _285_/a_1270_413# net60 0
C29 a[2] net9 0.00206f
C30 _130_/a_298_297# cin_q 0.01424f
C31 net58 _262_/a_1217_47# 0
C32 clkbuf_2_2__f_clk_regs/a_110_47# genblk1\[10\].fa_inst.s 0.00221f
C33 _273_/a_193_47# _272_/a_193_47# 0.00159f
C34 _275_/a_27_47# _274_/a_543_47# 0
C35 _275_/a_761_289# _274_/a_193_47# 0
C36 _275_/a_193_47# _274_/a_761_289# 0
C37 _275_/a_543_47# _274_/a_27_47# 0.00318f
C38 _131_/a_150_297# genblk1\[1\].fa_inst.a 0
C39 _058_ _055_ 0
C40 net58 clkbuf_2_0__f_clk_regs/a_110_47# 0.00429f
C41 _263_/a_543_47# net53 0
C42 net46 pmu_inst/_10_ 0.01523f
C43 _204_/a_561_297# _111_ 0
C44 _032_ net7 0.00127f
C45 net6 clknet_2_3__leaf_clk_regs 0.07079f
C46 _266_/a_27_47# clknet_2_3__leaf_clk_regs 0.06002f
C47 net2 a[11] 0
C48 _276_/a_1108_47# _021_ 0.00586f
C49 _290_/a_1270_413# VPWR 0
C50 _258_/a_1283_21# net36 0.01171f
C51 _164_/a_47_47# _079_ 0.01618f
C52 hold1/a_391_47# _055_ 0.0472f
C53 net6 net32 0.01621f
C54 genblk1\[11\].fa_inst.b genblk1\[13\].fa_inst.a 0
C55 net27 net7 0.02197f
C56 clknet_2_2__leaf_clk_regs b[6] 0
C57 _281_/a_448_47# net16 0.00231f
C58 VPWR pmu_inst/dc_inst.x5.net9 0
C59 _144_/a_129_47# _063_ 0
C60 _144_/a_47_47# genblk1\[3\].fa_inst.s 0.00368f
C61 _281_/a_1270_413# _026_ -0
C62 _281_/a_1108_47# genblk1\[9\].fa_inst.a 0
C63 _288_/a_805_47# _033_ -0.00125f
C64 _283_/a_1283_21# net30 0.00554f
C65 _284_/a_448_47# clknet_2_3__leaf_clk_regs 0.00161f
C66 net11 genblk1\[2\].fa_inst.b 0
C67 _282_/a_543_47# net30 0.00466f
C68 VPWR net36 8.31201f
C69 _134_/a_377_297# _056_ 0.00464f
C70 _134_/a_47_47# _053_ 0.18629f
C71 _063_ _064_ 0.13506f
C72 _280_/a_1270_413# _025_ -0
C73 _280_/a_1108_47# genblk1\[8\].fa_inst.a 0
C74 fanout59/a_27_47# _264_/a_27_47# 0
C75 _264_/a_1108_47# net59 0.00236f
C76 net25 a[15] 0
C77 _289_/a_761_289# net56 0
C78 _294_/a_193_47# _294_/a_27_47# -0
C79 net6 b[2] 0.22255f
C80 genblk1\[13\].fa_inst.a _299_/a_761_289# 0
C81 _030_ clknet_2_3__leaf_clk_regs 0
C82 _284_/a_448_47# net32 0
C83 VPWR _195_/a_68_297# 0.03631f
C84 net58 _064_ 0
C85 _016_ cout_next 0.02151f
C86 net39 pmu_inst/dc_inst.x1.net7 0
C87 _300_/a_1462_47# net60 0
C88 clknet_2_1__leaf_clk_regs _018_ 0
C89 _273_/a_1462_47# genblk1\[1\].fa_inst.a 0
C90 net47 pmu_inst/dc_inst.net3 0.0017f
C91 _059_ _057_ 0
C92 _277_/a_1108_47# net58 0.03011f
C93 net27 _277_/a_193_47# 0
C94 net16 _278_/a_448_47# 0
C95 _180_/a_68_297# genblk1\[12\].fa_inst.a 0
C96 _276_/a_27_47# net56 0.00195f
C97 genblk1\[4\].fa_inst.b _072_ 0.00979f
C98 genblk1\[8\].fa_inst.s VPWR 0.4605f
C99 net39 pmu_inst/dc_inst.x5.net11 0.01275f
C100 genblk1\[3\].fa_inst.b _062_ 0.07269f
C101 _154_/a_47_47# _153_/a_215_297# 0
C102 _269_/a_761_289# net44 0
C103 _269_/a_1108_47# _014_ 0.0143f
C104 genblk1\[12\].fa_inst.b _185_/a_150_297# 0
C105 VPWR net52 22.71494f
C106 net33 _284_/a_27_47# 0
C107 _283_/a_193_47# _283_/a_448_47# -0.00297f
C108 net6 net19 0.34951f
C109 VPWR _295_/a_761_289# 0.013f
C110 clkload1/a_110_47# VPWR -0
C111 _270_/a_448_47# _015_ 0
C112 _270_/a_543_47# net45 0
C113 genblk1\[11\].fa_inst.b genblk1\[12\].fa_inst.a 0.40806f
C114 _292_/a_805_47# net2 0
C115 _022_ _292_/a_27_47# 0
C116 _090_ _175_/a_68_297# 0.06684f
C117 _284_/a_651_413# _298_/a_761_289# 0
C118 _303_/a_1108_47# _048_ 0.00452f
C119 _303_/a_761_289# genblk1\[15\].fa_inst.b 0
C120 net21 clknet_2_2__leaf_clk_regs 0.2165f
C121 _284_/a_1283_21# _298_/a_1108_47# 0
C122 _284_/a_1108_47# _298_/a_1283_21# 0
C123 _284_/a_761_289# _298_/a_651_413# 0
C124 output46/a_27_47# s[1] 0.00972f
C125 _064_ _057_ 0.0834f
C126 _280_/a_1283_21# net62 0.00177f
C127 VPWR pmu_inst/dc_inst.x5.x3/a_27_47# 0
C128 VPWR pmu_inst/dc_inst.x7.net4 0.0034f
C129 _276_/a_805_47# net36 0
C130 net33 _190_/a_150_297# 0
C131 _278_/a_1108_47# genblk1\[6\].fa_inst.a 0.00125f
C132 genblk1\[11\].fa_inst.a _089_ 0
C133 _026_ net16 0
C134 clknet_2_0__leaf_clk_regs _143_/a_27_413# 0
C135 clknet_2_1__leaf_clk_regs _279_/a_543_47# 0
C136 b[15] clknet_2_3__leaf_clk_regs 0
C137 genblk1\[15\].fa_inst.b _109_ 0.0714f
C138 genblk1\[12\].fa_inst.a _299_/a_761_289# 0
C139 _029_ clknet_2_3__leaf_clk_regs 0.00404f
C140 _065_ net17 0
C141 _145_/a_150_297# _065_ 0
C142 _300_/a_805_47# net19 0
C143 _285_/a_193_47# net36 0.00128f
C144 _163_/a_215_297# _159_/a_47_47# 0
C145 net20 _287_/a_27_47# 0
C146 _022_ net33 0
C147 _158_/a_382_47# _070_ 0
C148 net61 _264_/a_1270_413# 0
C149 net61 genblk1\[14\].fa_inst.s 0
C150 _294_/a_27_47# net14 0
C151 _030_ net19 0.02924f
C152 _029_ net32 0
C153 genblk1\[9\].fa_inst.b net30 0
C154 _286_/a_448_47# clknet_2_3__leaf_clk_regs 0.01408f
C155 net6 b[1] 0.04303f
C156 _165_/a_68_297# VPWR 0.03593f
C157 clk _265_/a_1283_21# 0.002f
C158 _029_ _044_ 0
C159 net61 _266_/a_448_47# 0
C160 _066_ _145_/a_68_297# 0
C161 net29 _294_/a_27_47# 0.08704f
C162 _088_ genblk1\[9\].fa_inst.b 0
C163 net2 net36 0.02508f
C164 cout_next net74 0.49777f
C165 net33 genblk1\[5\].fa_inst.b 0.14714f
C166 _284_/a_27_47# net35 0.05003f
C167 net14 net56 0
C168 VPWR pmu_inst/dc_inst.x5.net1 0
C169 VPWR _154_/a_285_47# 0
C170 net58 _279_/a_1108_47# 0.02387f
C171 VPWR net51 5.34714f
C172 _275_/a_1108_47# genblk1\[2\].fa_inst.a 0.01406f
C173 net47 net71 0
C174 _259_/a_193_47# VPWR 0.02205f
C175 net39 pmu_inst/_09_ 0.01032f
C176 _154_/a_129_47# _072_ 0.00196f
C177 _294_/a_543_47# _279_/a_1108_47# 0
C178 _255_/a_1108_47# net57 0.00175f
C179 _304_/a_193_47# genblk1\[1\].fa_inst.b 0.03661f
C180 genblk1\[2\].fa_inst.b _136_/a_150_297# 0
C181 genblk1\[12\].fa_inst.a net59 0.03692f
C182 net33 _284_/a_1217_47# 0
C183 _273_/a_1270_413# net1 0
C184 _275_/a_27_47# net9 0.004f
C185 _273_/a_651_413# VPWR 0.00142f
C186 _283_/a_193_47# _028_ 0
C187 _131_/a_68_297# _054_ 0.00126f
C188 _199_/a_285_47# _112_ 0
C189 genblk1\[14\].fa_inst.s _205_/a_47_47# 0
C190 _199_/a_47_47# genblk1\[15\].fa_inst.s 0
C191 _199_/a_129_47# _110_ 0.00296f
C192 genblk1\[8\].fa_inst.b net7 0
C193 _272_/a_193_47# _272_/a_1283_21# -0
C194 _022_ _292_/a_1217_47# 0
C195 _284_/a_543_47# _043_ 0
C196 _029_ _298_/a_543_47# 0
C197 _039_ net26 0
C198 VPWR _269_/a_761_289# 0.01413f
C199 _304_/a_193_47# _288_/a_1283_21# 0
C200 _276_/a_27_47# _290_/a_193_47# 0.001f
C201 _163_/a_298_297# _076_ 0.00362f
C202 VPWR _081_ 0.68704f
C203 _268_/a_543_47# genblk1\[13\].fa_inst.s 0
C204 clkload2/a_27_47# _265_/a_543_47# 0
C205 net28 _295_/a_193_47# 0.0013f
C206 _164_/a_47_47# VPWR 0.03842f
C207 net58 net62 1.18581f
C208 _302_/a_27_47# _302_/a_761_289# -0
C209 net75 _050_ 0.06619f
C210 _301_/a_27_47# clknet_2_3__leaf_clk_regs 0.02312f
C211 _284_/a_193_47# net36 0
C212 _273_/a_543_47# net8 0.00387f
C213 _294_/a_543_47# net62 0.0041f
C214 net27 net6 0.0162f
C215 VPWR _177_/a_113_47# -0
C216 input35/a_27_47# net36 0
C217 net5 net15 1.16028f
C218 _163_/a_27_413# _080_ 0
C219 VPWR _134_/a_47_47# 0.01254f
C220 _143_/a_298_297# _058_ 0.03172f
C221 net59 _296_/a_1270_413# 0
C222 _029_ net19 0
C223 _155_/a_68_297# _073_ 0.00595f
C224 VPWR _280_/a_639_47# 0
C225 _266_/a_1108_47# net35 0
C226 clknet_2_1__leaf_clk_regs a[15] 0
C227 net29 _298_/a_193_47# 0
C228 _301_/a_761_289# net60 0.00395f
C229 input27/a_75_212# b[5] 0
C230 net25 a[14] 0
C231 net46 pmu_inst/dc_inst.x6.x3/a_27_47# 0.00304f
C232 _286_/a_448_47# net19 0.02486f
C233 _031_ clknet_2_3__leaf_clk_regs 0.01415f
C234 clk clknet_2_3__leaf_clk_regs 3.37558f
C235 net61 _011_ 0.03388f
C236 clknet_2_2__leaf_clk_regs _297_/a_448_47# 0.0252f
C237 VPWR _283_/a_27_47# 0.09645f
C238 _303_/a_27_47# net60 0
C239 b[12] clknet_2_3__leaf_clk_regs 0
C240 genblk1\[5\].fa_inst.a clknet_2_0__leaf_clk_regs 0.02356f
C241 _288_/a_1270_413# net56 0
C242 net39 pmu_inst/dc_inst.x7.x7/a_27_47# 0
C243 clknet_2_3__leaf_clk_regs net31 0.03886f
C244 input23/a_75_212# net34 0.00325f
C245 net26 a[13] 0
C246 _256_/a_543_47# genblk1\[1\].fa_inst.s 0.00363f
C247 _270_/a_1283_21# clknet_2_3__leaf_clk_regs 0.05625f
C248 net46 pmu_inst/dc_inst.x1.x12/a_27_47# 0.00278f
C249 genblk1\[1\].fa_inst.a clknet_2_0__leaf_clk_regs 0.06094f
C250 net32 net31 0.02391f
C251 net58 net7 0
C252 genblk1\[0\].fa_inst.a _135_/a_215_297# 0
C253 a[8] a[9] 0.10601f
C254 _259_/a_1108_47# genblk1\[4\].fa_inst.s 0.00104f
C255 _263_/a_651_413# net59 0
C256 genblk1\[0\].fa_inst.s net57 0
C257 _304_/a_1462_47# genblk1\[1\].fa_inst.b 0
C258 net3 _296_/a_639_47# 0.00198f
C259 _130_/a_215_297# net56 0.00197f
C260 _294_/a_543_47# net7 0
C261 net17 net15 0.00355f
C262 _286_/a_27_47# net35 0.03545f
C263 net39 pmu_inst/dc_inst.x6.x8/a_27_47# 0.0013f
C264 _304_/a_1283_21# _060_ 0
C265 net21 input21/a_75_212# 0.00211f
C266 _272_/a_193_47# clknet_2_0__leaf_clk_regs 0.57994f
C267 _107_ _197_/a_113_47# 0
C268 _281_/a_1270_413# net59 0
C269 net7 _283_/a_448_47# 0
C270 _304_/a_27_47# net17 0.00197f
C271 _272_/a_27_47# net1 0.04f
C272 _290_/a_193_47# net14 0.00115f
C273 net52 _262_/a_651_413# 0
C274 net28 _295_/a_1462_47# 0
C275 _301_/a_27_47# net19 0
C276 fanout60/a_27_47# net60 0.00791f
C277 net20 net36 0.02736f
C278 _286_/a_1283_21# net18 0
C279 genblk1\[3\].fa_inst.a _288_/a_1108_47# 0.00456f
C280 cin_q _304_/a_761_289# 0
C281 VPWR _155_/a_68_297# 0.03272f
C282 _303_/a_639_47# clknet_2_3__leaf_clk_regs 0.00222f
C283 net12 a[8] 0
C284 net46 pmu_inst/dc_inst.x4.x8/a_27_47# 0
C285 VPWR genblk1\[8\].fa_inst.a 0.86998f
C286 _184_/a_285_47# VPWR 0
C287 _277_/a_193_47# net58 0.01439f
C288 _303_/a_1283_21# _287_/a_27_47# 0
C289 _286_/a_193_47# net36 0.03587f
C290 _293_/a_193_47# _278_/a_1283_21# 0
C291 _031_ net19 0.46479f
C292 _277_/a_651_413# net36 0
C293 VPWR _283_/a_1217_47# 0
C294 clknet_2_2__leaf_clk_regs _042_ 0.65528f
C295 _303_/a_1217_47# net60 0
C296 _105_ genblk1\[13\].fa_inst.b 0
C297 VPWR _279_/a_1283_21# 0.0497f
C298 VPWR _282_/a_805_47# 0
C299 _188_/a_215_297# genblk1\[11\].fa_inst.a 0
C300 net39 pmu_inst/dc_inst.x4.net15 0.00301f
C301 _257_/a_639_47# net57 0.00107f
C302 net47 pmu_inst/dc_inst.x3.x13/a_27_47# 0.00387f
C303 _038_ _278_/a_1283_21# 0.00106f
C304 genblk1\[0\].fa_inst.b _288_/a_1108_47# 0.00146f
C305 _140_/a_68_297# net36 0.00949f
C306 _302_/a_543_47# VPWR 0.01287f
C307 _110_ _201_/a_61_47# 0.00139f
C308 _112_ _201_/a_217_297# 0
C309 pmu_inst/dc_inst.x3.net1 cout_next 0
C310 VPWR _171_/a_113_47# -0
C311 _271_/a_1108_47# net37 0
C312 VPWR pmu_inst/_15_/a_193_47# 0
C313 _039_ _294_/a_761_289# 0
C314 _297_/a_27_47# _297_/a_448_47# -0.00346f
C315 net59 net16 0
C316 _023_ _278_/a_639_47# -0
C317 net6 input26/a_75_212# 0.02109f
C318 genblk1\[14\].fa_inst.b _110_ 0
C319 _272_/a_1462_47# clknet_2_0__leaf_clk_regs 0
C320 _272_/a_805_47# _017_ -0.00125f
C321 _293_/a_193_47# net17 0.0343f
C322 _279_/a_448_47# genblk1\[7\].fa_inst.a 0
C323 clknet_0_clk_regs _264_/a_1283_21# 0.00184f
C324 net36 b[5] 0
C325 net7 _028_ 0.00467f
C326 net48 net58 0
C327 net3 _278_/a_639_47# 0
C328 _293_/a_805_47# net33 0
C329 net7 _279_/a_805_47# 0
C330 _168_/a_382_47# _078_ 0
C331 _087_ genblk1\[9\].fa_inst.b 0
C332 _272_/a_805_47# VPWR 0
C333 net25 input14/a_75_212# 0
C334 clknet_2_2__leaf_clk_regs _298_/a_1283_21# 0
C335 _302_/a_639_47# net7 0.0015f
C336 _269_/a_1283_21# cout_next 0
C337 _275_/a_27_47# _275_/a_193_47# -0.04831f
C338 hold1/a_49_47# _057_ 0.0443f
C339 input1/a_75_212# a[0] 0.00901f
C340 net17 _038_ 0.02466f
C341 net21 _287_/a_193_47# 0
C342 genblk1\[3\].fa_inst.a net17 0.35358f
C343 fanout60/a_27_47# _013_ 0
C344 _188_/a_382_47# VPWR -0
C345 pmu_inst/dc_inst.x5.net3 pmu_inst/dc_inst.x5.net12 0
C346 _277_/a_761_289# _035_ 0
C347 VPWR _153_/a_298_297# 0
C348 genblk1\[15\].fa_inst.b clknet_2_3__leaf_clk_regs 0
C349 _188_/a_382_47# _100_ 0.00136f
C350 _281_/a_27_47# net36 0.00478f
C351 _153_/a_215_297# _072_ 0.00869f
C352 _270_/a_805_47# net61 0
C353 pmu_inst/_15_/a_1279_413# net66 0
C354 _205_/a_47_47# _204_/a_225_47# 0
C355 _269_/a_761_289# genblk1\[14\].fa_inst.s 0.00213f
C356 genblk1\[12\].fa_inst.b _300_/a_27_47# 0
C357 net36 b[10] 0
C358 clknet_2_1__leaf_clk_regs a[14] 0
C359 _294_/a_193_47# _280_/a_761_289# 0
C360 VPWR pmu_inst/dc_inst.x5.x7/a_27_47# 0
C361 _274_/a_193_47# _273_/a_651_413# 0
C362 _274_/a_1108_47# _273_/a_543_47# 0.00113f
C363 _274_/a_651_413# _273_/a_193_47# 0
C364 _274_/a_761_289# _273_/a_448_47# 0
C365 _274_/a_1283_21# _273_/a_1283_21# 0.00257f
C366 net29 genblk1\[7\].fa_inst.b 0
C367 _164_/a_47_47# _075_ 0
C368 _255_/a_193_47# _000_ 0.00129f
C369 _255_/a_761_289# genblk1\[0\].fa_inst.s 0.00213f
C370 VPWR pmu_inst/dc_inst.x1.x1/a_27_47# 0.0024f
C371 _105_ _201_/a_61_47# 0.07086f
C372 net35 input19/a_75_212# 0.00405f
C373 _265_/a_27_47# clknet_2_3__leaf_clk_regs 0.21639f
C374 net3 genblk1\[9\].fa_inst.a 0
C375 net2 genblk1\[8\].fa_inst.a 0
C376 net47 net57 0.00543f
C377 _174_/a_285_47# _086_ 0
C378 _265_/a_1108_47# genblk1\[10\].fa_inst.s 0
C379 _271_/a_193_47# _271_/a_1283_21# -0
C380 genblk1\[0\].fa_inst.b net17 0
C381 _054_ _049_ 0
C382 _256_/a_1108_47# VPWR 0.00946f
C383 _144_/a_285_47# _062_ 0
C384 input16/a_75_212# net16 0.00198f
C385 net27 _281_/a_1108_47# 0.001f
C386 genblk1\[10\].fa_inst.a _086_ 0.0031f
C387 clknet_2_2__leaf_clk_regs _092_ 0.5548f
C388 _276_/a_193_47# _036_ 0
C389 _303_/a_448_47# net34 0.0162f
C390 net36 _278_/a_27_47# 0
C391 genblk1\[6\].fa_inst.b _163_/a_382_47# 0
C392 _112_ _203_/a_109_297# 0.00134f
C393 _258_/a_805_47# clknet_2_0__leaf_clk_regs 0
C394 _291_/a_27_47# net56 0.01161f
C395 VPWR _262_/a_1283_21# 0.02012f
C396 s[12] s[13] 0
C397 _022_ _277_/a_1108_47# 0.00195f
C398 genblk1\[12\].fa_inst.s _267_/a_761_289# 0
C399 _297_/a_193_47# net32 0.01533f
C400 _297_/a_27_47# _042_ -0
C401 genblk1\[14\].fa_inst.b _105_ 0.0535f
C402 net27 net31 0.01937f
C403 _270_/a_193_47# genblk1\[15\].fa_inst.s -0.00317f
C404 _023_ genblk1\[6\].fa_inst.a 0.00288f
C405 _281_/a_27_47# _295_/a_761_289# 0
C406 _281_/a_761_289# _295_/a_27_47# 0
C407 _281_/a_193_47# _295_/a_193_47# 0
C408 net4 net36 0.02506f
C409 _259_/a_805_47# net36 0
C410 _024_ genblk1\[7\].fa_inst.a 0
C411 _198_/a_27_413# _108_ 0
C412 net3 genblk1\[6\].fa_inst.a 0
C413 net33 _065_ 0.00507f
C414 genblk1\[13\].fa_inst.a _193_/a_215_297# 0
C415 _256_/a_27_47# _001_ 0.03844f
C416 net27 _278_/a_1108_47# 0.00389f
C417 clkbuf_2_0__f_clk_regs/a_110_47# _260_/a_761_289# 0
C418 net13 net16 0.05643f
C419 net29 _295_/a_448_47# 0.01302f
C420 _303_/a_1283_21# net36 0
C421 _277_/a_27_47# _292_/a_761_289# 0
C422 _268_/a_27_47# _268_/a_193_47# -0.05394f
C423 net57 net36 0.04547f
C424 _292_/a_27_47# _277_/a_543_47# 0
C425 genblk1\[12\].fa_inst.s net61 0
C426 genblk1\[11\].fa_inst.b _299_/a_1283_21# 0.00295f
C427 clknet_2_0__leaf_clk_regs hold1/a_285_47# 0
C428 _276_/a_651_413# net36 0.0017f
C429 genblk1\[7\].fa_inst.s _262_/a_193_47# 0.00923f
C430 output53/a_27_47# net53 0.0207f
C431 net59 _297_/a_1283_21# 0.07812f
C432 _200_/a_59_75# genblk1\[14\].fa_inst.b 0
C433 net67 net66 0
C434 _290_/a_543_47# net12 0.0097f
C435 _110_ _111_ 0.0243f
C436 VPWR _262_/a_448_47# -0.00533f
C437 net75 _135_/a_215_297# 0
C438 _276_/a_193_47# _021_ 0
C439 _274_/a_1283_21# clknet_2_1__leaf_clk_regs 0
C440 _019_ _273_/a_761_289# 0
C441 VPWR net8 0.94615f
C442 _291_/a_448_47# net26 0.00574f
C443 _291_/a_1108_47# _036_ 0.00621f
C444 net29 _280_/a_761_289# 0
C445 _275_/a_448_47# net56 0
C446 _265_/a_448_47# net40 0
C447 _271_/a_448_47# clknet_2_3__leaf_clk_regs 0.00188f
C448 net21 net35 0.02824f
C449 clknet_2_3__leaf_clk_regs _299_/a_193_47# 0
C450 net53 net35 0.02399f
C451 _258_/a_543_47# net48 0
C452 _258_/a_448_47# _003_ 0.00116f
C453 clknet_0_clk_regs _007_ 0
C454 _037_ net17 0.02895f
C455 _048_ net34 0.16563f
C456 _285_/a_27_47# net7 0.02214f
C457 genblk1\[8\].fa_inst.b _296_/a_1108_47# 0
C458 net28 genblk1\[10\].fa_inst.a 0.03361f
C459 _299_/a_193_47# net32 0
C460 _291_/a_1217_47# net56 0
C461 _022_ _277_/a_1462_47# 0
C462 _294_/a_448_47# net3 0.00402f
C463 genblk1\[11\].fa_inst.s _266_/a_27_47# 0.16014f
C464 input8/a_75_212# net8 0.00223f
C465 _168_/a_27_413# _077_ 0.01446f
C466 _168_/a_215_297# genblk1\[7\].fa_inst.b 0
C467 _044_ _299_/a_193_47# 0.00241f
C468 net60 _299_/a_543_47# 0.01119f
C469 _297_/a_1217_47# _042_ -0
C470 _268_/a_1283_21# clknet_2_3__leaf_clk_regs 0
C471 net39 pmu_inst/_06_ 0
C472 a[3] a[4] 0.06871f
C473 b[13] b[14] 0.07915f
C474 net46 pmu_inst/dc_inst.x5.net7 0.0076f
C475 _046_ net36 0
C476 clknet_2_1__leaf_clk_regs input14/a_75_212# 0.01354f
C477 _275_/a_543_47# genblk1\[3\].fa_inst.a 0
C478 _291_/a_27_47# _290_/a_193_47# 0
C479 clknet_0_clk_regs _260_/a_805_47# 0
C480 clknet_0_clk clkbuf_1_0__f_clk/a_110_47# 0.0158f
C481 net29 _040_ 0
C482 net61 _265_/a_448_47# 0
C483 clkbuf_2_3__f_clk_regs/a_110_47# _266_/a_193_47# 0.0195f
C484 net47 pmu_inst/_24_/a_27_47# 0.00779f
C485 _183_/a_27_413# _094_ 0
C486 VPWR _285_/a_1108_47# 0.02031f
C487 _006_ _005_ 0
C488 _021_ _291_/a_1108_47# 0
C489 _260_/a_1270_413# genblk1\[5\].fa_inst.s 0
C490 _105_ _111_ 0
C491 net6 input31/a_75_212# 0.02109f
C492 _289_/a_639_47# net11 0.0017f
C493 genblk1\[3\].fa_inst.b _148_/a_27_413# 0
C494 _291_/a_193_47# net13 0
C495 _274_/a_805_47# genblk1\[1\].fa_inst.a 0
C496 _039_ _294_/a_1462_47# 0
C497 net26 _036_ 0.02818f
C498 _302_/a_543_47# net20 0
C499 net7 _284_/a_27_47# 0.03063f
C500 _020_ net56 0.03145f
C501 _066_ net36 0
C502 VPWR _264_/a_193_47# -0.02637f
C503 _010_ net40 0.19322f
C504 _016_ clknet_2_3__leaf_clk_regs 0.00595f
C505 VPWR _199_/a_129_47# -0
C506 _299_/a_193_47# net19 0.09189f
C507 _273_/a_1108_47# net9 0
C508 _287_/a_761_289# clknet_2_3__leaf_clk_regs 0
C509 genblk1\[10\].fa_inst.b _298_/a_193_47# 0
C510 _302_/a_27_47# _286_/a_1283_21# 0
C511 _302_/a_193_47# _286_/a_543_47# 0
C512 net33 _094_ 0.02111f
C513 genblk1\[1\].fa_inst.b _135_/a_215_297# 0
C514 _259_/a_193_47# net57 0.00158f
C515 genblk1\[8\].fa_inst.b net31 0
C516 _267_/a_1283_21# clknet_2_3__leaf_clk_regs 0
C517 VPWR fanout57/a_27_47# 0.06596f
C518 _080_ _160_/a_150_297# 0
C519 _304_/a_27_47# net33 -0.00603f
C520 pmu_inst/dc_inst.x3.net11 net67 0
C521 _282_/a_543_47# _296_/a_651_413# 0
C522 _282_/a_1108_47# _296_/a_1108_47# 0
C523 net29 _282_/a_543_47# 0.00339f
C524 VPWR pmu_inst/dc_inst.x1.x7/a_27_47# 0
C525 input2/a_27_47# a[10] 0.0147f
C526 VPWR _150_/a_68_297# 0.0285f
C527 _287_/a_1283_21# net60 0.01715f
C528 net39 pmu_inst/dc_inst.x4.x17/a_27_47# 0.00895f
C529 genblk1\[10\].fa_inst.s _092_ 0.00314f
C530 net59 _298_/a_761_289# 0.00123f
C531 _267_/a_27_47# _267_/a_193_47# -0.07655f
C532 _153_/a_298_297# _069_ 0
C533 _281_/a_1270_413# net30 0
C534 _264_/a_543_47# genblk1\[9\].fa_inst.s 0.00127f
C535 net3 net32 0.00808f
C536 net27 _297_/a_193_47# 0
C537 net33 _148_/a_215_297# 0
C538 input3/a_27_47# a[11] 0.0147f
C539 output52/a_27_47# s[7] 0.00968f
C540 net5 b[9] 0
C541 VPWR _284_/a_1108_47# 0.01621f
C542 _300_/a_639_47# VPWR 0
C543 _272_/a_27_47# _288_/a_27_47# 0.00159f
C544 _183_/a_382_47# genblk1\[10\].fa_inst.b 0
C545 _013_ net60 0.18962f
C546 net47 pmu_inst/_25_/a_193_47# 0.01037f
C547 net58 _263_/a_1283_21# 0
C548 net61 _010_ 0.04488f
C549 _198_/a_298_297# _101_ 0
C550 net47 pmu_inst/dc_inst.x8/a_247_21# 0
C551 _280_/a_193_47# net16 0.02954f
C552 _268_/a_543_47# net43 0
C553 _268_/a_448_47# _013_ 0
C554 _096_ _093_ 0.1172f
C555 VPWR pmu_inst/dc_inst.x6.net3 0.00366f
C556 net56 _055_ 0.04928f
C557 _039_ _279_/a_761_289# 0
C558 net4 _283_/a_27_47# 0.01821f
C559 VPWR genblk1\[13\].fa_inst.b 1.79746f
C560 net39 pmu_inst/dc_inst.x1.net19 -0
C561 genblk1\[0\].fa_inst.s _050_ 0.00196f
C562 _021_ net26 0
C563 _200_/a_145_75# _109_ 0
C564 pmu_inst/_25_/a_27_47# net35 0
C565 _290_/a_193_47# net56 0
C566 clknet_2_1__leaf_clk_regs _278_/a_543_47# 0.03594f
C567 net17 _280_/a_1108_47# 0.00167f
C568 net33 _042_ 0
C569 genblk1\[1\].fa_inst.b net11 0
C570 clknet_0_clk_regs _008_ 0.00314f
C571 genblk1\[2\].fa_inst.s _304_/a_1108_47# 0
C572 _291_/a_1283_21# net36 0.00763f
C573 clk net58 0.09595f
C574 _283_/a_193_47# b[6] 0
C575 net3 _298_/a_543_47# 0
C576 _094_ net35 0.07058f
C577 _277_/a_1283_21# net56 0.00132f
C578 _022_ _277_/a_193_47# 0
C579 net7 _284_/a_1217_47# 0
C580 VPWR s[6] 0.37243f
C581 genblk1\[6\].fa_inst.b net3 0
C582 VPWR a[3] 0.24753f
C583 VPWR pmu_inst/dc_inst.x7.net6 0.01985f
C584 _084_ _173_/a_298_297# 0.01144f
C585 _274_/a_651_413# clknet_2_0__leaf_clk_regs 0
C586 _164_/a_47_47# _159_/a_47_47# 0
C587 VPWR b[4] 0.23715f
C588 b[9] clknet_2_2__leaf_clk_regs 0
C589 _293_/a_193_47# net33 0.03631f
C590 fanout59/a_27_47# net61 0.07061f
C591 _286_/a_27_47# net7 0
C592 _283_/a_448_47# net31 0.01022f
C593 _097_ _193_/a_27_413# 0.01345f
C594 _274_/a_1108_47# VPWR 0.0103f
C595 _138_/a_113_47# _057_ 0
C596 _293_/a_1108_47# clknet_2_1__leaf_clk_regs 0.04013f
C597 net58 _278_/a_1108_47# 0.01748f
C598 _282_/a_1283_21# _041_ 0.00173f
C599 _027_ _296_/a_1283_21# 0
C600 net47 net72 0
C601 _292_/a_1108_47# _023_ 0
C602 net16 net30 0
C603 _270_/a_1108_47# fanout61/a_27_47# 0
C604 net5 _279_/a_27_47# 0
C605 net29 genblk1\[9\].fa_inst.b 0
C606 genblk1\[4\].fa_inst.a net17 0.24153f
C607 genblk1\[3\].fa_inst.a net33 0.51302f
C608 genblk1\[4\].fa_inst.a _145_/a_150_297# 0
C609 net33 _038_ 0.13091f
C610 _012_ net60 0.01409f
C611 net4 genblk1\[8\].fa_inst.a 0
C612 _126_/a_68_297# genblk1\[0\].fa_inst.b 0.02017f
C613 VPWR _289_/a_805_47# 0
C614 clkload0/Y clkbuf_2_0__f_clk_regs/a_110_47# 0.00165f
C615 _279_/a_193_47# _278_/a_543_47# 0
C616 _279_/a_761_289# _278_/a_761_289# 0
C617 _279_/a_543_47# _278_/a_193_47# 0
C618 _084_ genblk1\[8\].fa_inst.b 0
C619 _183_/a_27_413# _092_ 0.0031f
C620 _302_/a_805_47# genblk1\[14\].fa_inst.b 0
C621 _274_/a_193_47# net8 0.00442f
C622 _292_/a_27_47# _292_/a_448_47# -0.00642f
C623 cin_q _135_/a_298_297# 0.00225f
C624 _257_/a_448_47# net47 0
C625 genblk1\[13\].fa_inst.a _108_ 0
C626 net47 pmu_inst/_25_/a_1462_47# 0
C627 cout_next pmu_inst/dc_inst.x3.net8 0
C628 net47 pmu_inst/dc_inst.x9/a_750_97# 0.00248f
C629 _276_/a_193_47# genblk1\[2\].fa_inst.b 0.00175f
C630 VPWR _286_/a_1108_47# 0.01366f
C631 _285_/a_27_47# _030_ -0
C632 net46 pmu_inst/dc_inst.x1.net7 0.02517f
C633 _148_/a_298_297# net36 0.00591f
C634 fanout56/a_27_47# net16 0
C635 VPWR _201_/a_61_47# 0.02831f
C636 _290_/a_1462_47# net56 0
C637 net61 _267_/a_805_47# 0
C638 _065_ _064_ 0
C639 _259_/a_651_413# clkbuf_2_0__f_clk_regs/a_110_47# 0
C640 _302_/a_1283_21# _301_/a_1108_47# 0
C641 genblk1\[11\].fa_inst.s clk 0.01376f
C642 _293_/a_1217_47# net33 0
C643 VPWR _296_/a_1283_21# 0.08188f
C644 net24 net7 0.02164f
C645 cin_q genblk1\[1\].fa_inst.s 0
C646 clknet_2_1__leaf_clk_regs _159_/a_285_47# 0
C647 net46 pmu_inst/dc_inst.x5.net11 0
C648 _054_ genblk1\[1\].fa_inst.a 0.10563f
C649 VPWR _194_/a_285_47# -0.00209f
C650 _282_/a_448_47# clknet_2_2__leaf_clk_regs 0.00161f
C651 _282_/a_193_47# genblk1\[9\].fa_inst.a 0
C652 VPWR genblk1\[14\].fa_inst.b 0.41249f
C653 net17 _279_/a_27_47# 0
C654 _287_/a_761_289# _032_ 0
C655 net35 _298_/a_1283_21# 0
C656 _104_ _101_ 0.21885f
C657 _130_/a_27_413# genblk1\[1\].fa_inst.s 0
C658 VPWR _260_/a_651_413# 0
C659 net58 net12 0
C660 clkload0/a_361_47# net58 0.03417f
C661 _028_ net31 0
C662 clknet_0_clk_regs _265_/a_761_289# 0.00241f
C663 tdo pmu_inst_71/HI 0
C664 _189_/a_377_297# _097_ 0
C665 _275_/a_27_47# _273_/a_448_47# 0
C666 _275_/a_1108_47# _273_/a_193_47# 0
C667 _275_/a_193_47# _273_/a_1108_47# 0
C668 net27 _023_ 0.01892f
C669 _267_/a_543_47# net42 0
C670 _284_/a_193_47# _284_/a_1108_47# -0.00656f
C671 a[4] a[5] 0.06434f
C672 _277_/a_193_47# net24 0
C673 net5 input7/a_27_47# 0
C674 VPWR _263_/a_543_47# 0.00691f
C675 _091_ _089_ 0.03595f
C676 VPWR pmu_inst_68/HI 0.05234f
C677 net27 net3 3.86727f
C678 _272_/a_448_47# net17 0
C679 clknet_2_0__leaf_clk_regs _288_/a_651_413# 0.00166f
C680 _017_ _288_/a_1108_47# 0
C681 net71 pmu_inst/dc_inst.x5.x18/a_27_47# 0
C682 _292_/a_27_47# _037_ 0.00138f
C683 _292_/a_193_47# net27 0.37967f
C684 net26 _295_/a_193_47# 0
C685 input31/a_75_212# net31 0.0021f
C686 _002_ net47 0.02121f
C687 _036_ _035_ 0.0025f
C688 _045_ _285_/a_1283_21# 0
C689 _300_/a_1283_21# _030_ 0
C690 genblk1\[5\].fa_inst.a genblk1\[6\].fa_inst.a 0
C691 net1 _288_/a_448_47# 0
C692 VPWR _288_/a_1108_47# 0.0231f
C693 VPWR _281_/a_1283_21# 0.04998f
C694 net17 _073_ 0
C695 net39 pmu_inst/dc_inst.x4.net10 0.00326f
C696 _273_/a_27_47# net56 0
C697 pmu_inst/dc_inst.x7.net4 net72 -0
C698 _297_/a_1283_21# net30 0.00349f
C699 net39 pmu_inst/dc_inst.x1.x14/a_27_47# 0
C700 _286_/a_1283_21# _285_/a_761_289# 0
C701 _106_ _102_ 0
C702 net25 a[11] 0
C703 _148_/a_27_413# _143_/a_27_413# 0
C704 _294_/a_27_47# _280_/a_761_289# 0
C705 clkload2/a_27_47# clkbuf_2_3__f_clk_regs/a_110_47# 0.03028f
C706 net71 pmu_inst/dc_inst.x6.net3 -0
C707 _047_ _301_/a_543_47# 0
C708 _037_ net33 0
C709 _108_ _103_ 0.07919f
C710 net55 pmu_inst/dc_inst.x5.x13/a_27_47# 0
C711 _150_/a_68_297# _069_ 0.0061f
C712 _269_/a_193_47# _268_/a_27_47# 0
C713 _269_/a_27_47# _268_/a_193_47# 0
C714 _095_ _089_ 0
C715 _270_/a_543_47# VPWR 0.01361f
C716 VPWR net5 3.03819f
C717 net46 pmu_inst/_09_ 0.00776f
C718 _027_ clknet_2_2__leaf_clk_regs 0.00406f
C719 clknet_2_2__leaf_clk_regs _174_/a_47_47# 0.03637f
C720 _256_/a_1108_47# net57 0.03031f
C721 VPWR _278_/a_1283_21# 0.04107f
C722 net7 _281_/a_805_47# 0
C723 _287_/a_805_47# genblk1\[15\].fa_inst.a 0
C724 _047_ genblk1\[14\].fa_inst.a 0.00137f
C725 _304_/a_27_47# _059_ 0
C726 genblk1\[2\].fa_inst.a _058_ 0.07484f
C727 _163_/a_298_297# _073_ 0.01515f
C728 _104_ _201_/a_217_297# 0
C729 net53 net62 0.05254f
C730 _286_/a_27_47# net6 0.14166f
C731 _275_/a_761_289# clknet_2_1__leaf_clk_regs 0.00197f
C732 _258_/a_1270_413# net57 0
C733 _021_ _035_ 0.04321f
C734 net59 _173_/a_215_297# 0
C735 _283_/a_193_47# _297_/a_448_47# 0
C736 _282_/a_1108_47# _297_/a_193_47# 0
C737 _282_/a_543_47# _297_/a_543_47# 0
C738 _205_/a_377_297# _110_ 0.00383f
C739 _205_/a_129_47# _112_ 0
C740 _264_/a_27_47# net54 0
C741 _264_/a_543_47# _009_ 0.00438f
C742 _301_/a_805_47# VPWR 0
C743 _284_/a_27_47# _029_ -0
C744 _290_/a_1108_47# net36 0.0036f
C745 VPWR _111_ 0.38017f
C746 _291_/a_651_413# clknet_2_1__leaf_clk_regs 0.00108f
C747 _292_/a_1270_413# genblk1\[4\].fa_inst.b 0
C748 _292_/a_1217_47# _037_ -0
C749 _303_/a_1270_413# VPWR -0
C750 net17 _136_/a_68_297# 0
C751 net20 genblk1\[13\].fa_inst.b 0
C752 net36 net18 0.02551f
C753 VPWR pmu_inst/dc_inst.x3.net19 0
C754 genblk1\[14\].fa_inst.a _108_ 0
C755 _269_/a_1283_21# clknet_2_3__leaf_clk_regs 0
C756 a[1] a[2] 0.06337f
C757 _274_/a_193_47# a[3] 0
C758 _274_/a_27_47# net10 0.04135f
C759 VPWR _145_/a_150_297# 0
C760 VPWR net17 5.18466f
C761 net37 net62 0.00444f
C762 VPWR clknet_2_2__leaf_clk_regs 4.4696f
C763 _273_/a_1217_47# net56 0
C764 net33 _105_ 0.00742f
C765 _185_/a_68_297# _094_ 0
C766 _145_/a_68_297# _072_ 0
C767 _065_ _153_/a_382_47# 0.00308f
C768 net62 _076_ 0
C769 net45 net62 0.03942f
C770 _031_ _285_/a_27_47# 0
C771 _148_/a_215_297# _064_ 0.02766f
C772 _160_/a_68_297# _160_/a_150_297# 0
C773 genblk1\[15\].fa_inst.b _202_/a_109_297# 0
C774 genblk1\[12\].fa_inst.b genblk1\[11\].fa_inst.b 0.06318f
C775 _274_/a_27_47# _274_/a_448_47# -0.00297f
C776 net46 pmu_inst/dc_inst.x7.x7/a_27_47# 0.00139f
C777 net21 net7 0.10368f
C778 _189_/a_129_47# VPWR -0
C779 _189_/a_129_47# _100_ 0.00106f
C780 _275_/a_543_47# a[4] 0
C781 net24 net6 0.01643f
C782 _158_/a_382_47# _072_ 0.0013f
C783 output38/a_27_47# cout 0.02384f
C784 net5 _285_/a_193_47# 0.01001f
C785 s[1] VPWR 0.4098f
C786 VPWR a[5] 0.2547f
C787 clkload0/a_27_47# VPWR 0.05891f
C788 _098_ _299_/a_27_47# 0
C789 net46 pmu_inst/dc_inst.x6.x8/a_27_47# 0.00661f
C790 _290_/a_651_413# _035_ 0
C791 _259_/a_543_47# net36 0.0026f
C792 _163_/a_298_297# VPWR -0
C793 genblk1\[14\].fa_inst.s _201_/a_61_47# 0
C794 _107_ _201_/a_479_47# 0.00208f
C795 _200_/a_59_75# net33 0.00178f
C796 _298_/a_761_289# net30 0.01641f
C797 net2 net5 0
C798 VPWR pmu_inst/dc_inst.x7.net14 0
C799 _289_/a_27_47# net24 0.03969f
C800 _283_/a_193_47# _042_ 0
C801 _301_/a_193_47# _300_/a_543_47# 0
C802 _301_/a_1283_21# _300_/a_27_47# 0
C803 _301_/a_543_47# _300_/a_193_47# 0
C804 _301_/a_761_289# _300_/a_761_289# 0
C805 clkbuf_2_3__f_clk_regs/a_110_47# _265_/a_193_47# 0
C806 genblk1\[8\].fa_inst.b net3 0
C807 genblk1\[3\].fa_inst.a _059_ 0
C808 _282_/a_27_47# _042_ 0
C809 _027_ _297_/a_27_47# 0.00126f
C810 _264_/a_1217_47# net54 0
C811 _004_ _003_ 0
C812 _107_ _106_ 0.09717f
C813 net25 net36 0.17804f
C814 net46 pmu_inst/dc_inst.x7.x5/a_27_47# 0
C815 net47 pmu_inst/dc_inst.x3.x10/a_27_47# 0.00225f
C816 net15 input17/a_27_47# 0
C817 genblk1\[9\].fa_inst.b _297_/a_543_47# 0
C818 _054_ hold1/a_285_47# 0.07741f
C819 net5 input6/a_27_47# 0
C820 input5/a_27_47# net6 0
C821 net33 _280_/a_1108_47# 0
C822 _283_/a_1283_21# genblk1\[10\].fa_inst.b 0
C823 _271_/a_27_47# net62 0.00216f
C824 net39 pmu_inst/dc_inst.x5.net15 0.00337f
C825 net47 pmu_inst/clknet_0_clk 0.05447f
C826 net40 s[10] 0.09627f
C827 _271_/a_1108_47# net44 0.05529f
C828 net20 _286_/a_1108_47# 0.03022f
C829 _300_/a_193_47# genblk1\[14\].fa_inst.a 0
C830 _285_/a_193_47# clknet_2_2__leaf_clk_regs 0.03479f
C831 _276_/a_543_47# _291_/a_761_289# 0
C832 clknet_2_1__leaf_clk_regs a[11] 0
C833 net34 pmu_inst/clknet_1_0__leaf_clk 0
C834 genblk1\[3\].fa_inst.a _064_ 0
C835 _293_/a_1108_47# net28 0
C836 _284_/a_27_47# net31 0.03178f
C837 _256_/a_543_47# _255_/a_1283_21# 0.00108f
C838 _256_/a_27_47# _255_/a_651_413# 0
C839 _283_/a_1108_47# net59 0.0041f
C840 _286_/a_27_47# _286_/a_448_47# -0.00642f
C841 genblk1\[2\].fa_inst.s _059_ 0
C842 genblk1\[3\].fa_inst.b _063_ 0
C843 net27 _295_/a_1283_21# 0.00118f
C844 _282_/a_1283_21# net59 0.03759f
C845 _274_/a_27_47# _019_ -0
C846 net47 pmu_inst/dc_inst.x3.net7 0.00632f
C847 net53 output52/a_27_47# 0
C848 b[4] b[5] 0.07915f
C849 _283_/a_27_47# _298_/a_1108_47# 0
C850 _283_/a_1108_47# _298_/a_27_47# 0
C851 _283_/a_761_289# _298_/a_543_47# 0
C852 _283_/a_543_47# _298_/a_761_289# 0
C853 _283_/a_1283_21# _298_/a_193_47# 0
C854 _014_ net60 0
C855 _181_/a_113_47# genblk1\[11\].fa_inst.a 0
C856 net5 _284_/a_193_47# 0
C857 _272_/a_543_47# net56 0.03605f
C858 net6 input19/a_75_212# 0.03161f
C859 genblk1\[3\].fa_inst.b net58 0
C860 net2 net17 0.02098f
C861 net2 clknet_2_2__leaf_clk_regs 0.50569f
C862 VPWR _297_/a_27_47# 0.10082f
C863 _179_/a_47_47# _090_ 0.00114f
C864 genblk1\[13\].fa_inst.s _101_ 0.00102f
C865 net58 _023_ 0.31055f
C866 clk clkbuf_2_2__f_clk_regs/a_110_47# 0.00514f
C867 net6 b[6] 0.22255f
C868 _133_/a_113_47# _055_ 0
C869 _050_ _134_/a_47_47# 0.00498f
C870 genblk1\[2\].fa_inst.a _289_/a_761_289# 0.00183f
C871 _290_/a_448_47# genblk1\[2\].fa_inst.b 0
C872 _295_/a_27_47# _295_/a_193_47# -0.20744f
C873 clk _264_/a_651_413# 0.00353f
C874 _270_/a_1108_47# cout_next 0
C875 _195_/a_150_297# _105_ 0
C876 genblk1\[4\].fa_inst.a net33 0.24507f
C877 fanout57/a_27_47# net57 0.00709f
C878 net58 net3 0.00169f
C879 net27 _280_/a_27_47# 0.02486f
C880 _292_/a_193_47# net58 0.04535f
C881 _292_/a_1283_21# fanout56/a_27_47# 0
C882 _294_/a_639_47# VPWR 0
C883 _294_/a_651_413# _280_/a_543_47# 0
C884 net61 _269_/a_805_47# 0
C885 net4 _284_/a_1108_47# 0
C886 _294_/a_543_47# net3 0.01555f
C887 clk _266_/a_1108_47# 0.00311f
C888 cout_next net50 0.03133f
C889 _289_/a_651_413# genblk1\[1\].fa_inst.b 0
C890 net49 net34 0.02804f
C891 _302_/a_27_47# _287_/a_27_47# 0
C892 _255_/a_448_47# VPWR 0.00122f
C893 net33 _079_ 0
C894 _027_ _297_/a_1217_47# 0
C895 _188_/a_215_297# _095_ 0.00994f
C896 _188_/a_382_47# _093_ 0.0017f
C897 net3 _283_/a_448_47# 0.01457f
C898 _130_/a_298_297# net75 0.001f
C899 _196_/a_113_47# genblk1\[14\].fa_inst.b 0
C900 genblk1\[7\].fa_inst.b _295_/a_448_47# 0
C901 net7 _297_/a_448_47# 0
C902 _301_/a_448_47# genblk1\[13\].fa_inst.b 0
C903 _275_/a_1108_47# clknet_2_0__leaf_clk_regs 0.00123f
C904 genblk1\[3\].fa_inst.a _272_/a_27_47# 0
C905 _149_/a_47_47# _153_/a_215_297# 0.00155f
C906 _284_/a_193_47# clknet_2_2__leaf_clk_regs 0
C907 _300_/a_1108_47# clknet_2_2__leaf_clk_regs 0
C908 VPWR input21/a_75_212# 0.09177f
C909 _275_/a_543_47# VPWR 0.01374f
C910 s[2] s[3] 0
C911 _259_/a_193_47# _259_/a_543_47# 0
C912 clknet_0_clk_regs _261_/a_761_289# 0
C913 _294_/a_1217_47# VPWR 0
C914 _098_ net33 0
C915 _261_/a_448_47# net51 0
C916 genblk1\[10\].fa_inst.b genblk1\[9\].fa_inst.b 0
C917 b[9] net35 0
C918 _256_/a_761_289# genblk1\[0\].fa_inst.s 0
C919 _256_/a_193_47# _000_ 0
C920 _277_/a_193_47# _291_/a_543_47# 0
C921 net7 net15 0.0352f
C922 _269_/a_193_47# genblk1\[15\].fa_inst.s 0
C923 _286_/a_27_47# _031_ -0
C924 VPWR pmu_inst/_19_/a_27_47# 0
C925 _291_/a_1270_413# VPWR 0
C926 _271_/a_1108_47# VPWR -0.00116f
C927 VPWR _299_/a_27_47# 0.10327f
C928 _274_/a_1270_413# genblk1\[2\].fa_inst.a 0
C929 _283_/a_27_47# net18 0.00115f
C930 genblk1\[14\].fa_inst.s _111_ 0
C931 VPWR genblk1\[10\].fa_inst.s 0.32405f
C932 cout_next pmu_inst/_04_ 0
C933 _281_/a_193_47# _296_/a_543_47# 0
C934 _281_/a_543_47# _296_/a_193_47# 0
C935 _014_ _013_ 0
C936 _274_/a_543_47# net9 0.00284f
C937 VPWR pmu_inst/dc_inst.x1.x13/a_27_47# 0.00204f
C938 _257_/a_193_47# clknet_2_0__leaf_clk_regs 0.00363f
C939 VPWR _297_/a_1217_47# 0
C940 _198_/a_27_413# net60 0
C941 net33 input36/a_27_47# 0
C942 _083_ _082_ 0.06283f
C943 net5 _286_/a_193_47# 0
C944 _035_ genblk1\[2\].fa_inst.b 0.00282f
C945 _184_/a_47_47# _096_ 0.02321f
C946 _049_ _057_ 0.00817f
C947 _070_ _150_/a_68_297# 0
C948 VPWR _268_/a_543_47# 0.01216f
C949 net27 _280_/a_1217_47# 0
C950 VPWR pmu_inst/dc_inst.x8/a_750_97# -0
C951 clknet_0_clk clknet_1_0__leaf_clk 0.00419f
C952 net26 a[15] 0
C953 _277_/a_193_47# net15 0
C954 net22 clknet_2_3__leaf_clk_regs 0.03447f
C955 VPWR pmu_inst/dc_inst.x4.x6/a_27_47# 0
C956 pmu_inst/_06_ net66 0
C957 clknet_2_1__leaf_clk_regs _262_/a_805_47# 0
C958 net2 _297_/a_27_47# 0
C959 _046_ _300_/a_639_47# 0
C960 net7 _299_/a_448_47# 0
C961 net17 _069_ 0
C962 _000_ VPWR 0.19988f
C963 clknet_2_0__leaf_clk_regs _304_/a_651_413# 0
C964 _037_ _277_/a_1108_47# 0
C965 net62 _038_ 0.0405f
C966 net58 _261_/a_27_47# 0
C967 clknet_2_1__leaf_clk_regs net36 2.71823f
C968 net3 _028_ 0.00416f
C969 _303_/a_543_47# b[15] 0
C970 _303_/a_761_289# net23 0
C971 _022_ net12 0
C972 _149_/a_285_47# VPWR 0.00224f
C973 net3 _279_/a_805_47# 0
C974 net7 _042_ 0.00108f
C975 VPWR input22/a_75_212# 0.09177f
C976 _304_/a_1108_47# VPWR 0.00559f
C977 _280_/a_1108_47# _295_/a_543_47# 0
C978 _280_/a_193_47# _295_/a_651_413# 0
C979 _280_/a_1283_21# _295_/a_1283_21# 0
C980 _280_/a_651_413# _295_/a_193_47# 0
C981 genblk1\[7\].fa_inst.b _040_ 0
C982 _167_/a_113_47# VPWR -0
C983 net27 _282_/a_193_47# 0.01979f
C984 genblk1\[10\].fa_inst.a _178_/a_215_297# 0
C985 _301_/a_651_413# _286_/a_1283_21# 0
C986 _046_ genblk1\[13\].fa_inst.b 0
C987 _286_/a_543_47# b[11] 0
C988 net33 _073_ 0
C989 net20 clknet_2_2__leaf_clk_regs 0.14295f
C990 _085_ genblk1\[9\].fa_inst.b 0.12508f
C991 _276_/a_27_47# net16 0
C992 net5 b[5] 0
C993 _288_/a_27_47# _288_/a_448_47# -0.00346f
C994 _286_/a_193_47# clknet_2_2__leaf_clk_regs 0.0337f
C995 _290_/a_1270_413# net11 0
C996 genblk1\[3\].fa_inst.s net36 0.01851f
C997 _260_/a_1283_21# _005_ 0.01244f
C998 _260_/a_193_47# net50 0
C999 _006_ net51 0.19322f
C1000 _294_/a_193_47# net16 0.00711f
C1001 _025_ net36 0
C1002 net59 genblk1\[9\].fa_inst.s 0
C1003 _286_/a_1270_413# genblk1\[14\].fa_inst.a 0
C1004 _286_/a_1217_47# _031_ -0
C1005 net47 pmu_inst/_23_/a_1270_413# 0
C1006 net33 _027_ 0
C1007 input36/a_27_47# net35 0.002f
C1008 delay_sel[2] net34 0.04489f
C1009 clknet_2_1__leaf_clk_regs _261_/a_639_47# 0
C1010 net51 output50/a_27_47# 0
C1011 VPWR _287_/a_193_47# 0.0156f
C1012 _294_/a_761_289# _279_/a_543_47# 0
C1013 clknet_2_2__leaf_clk_regs _296_/a_27_47# 0.04572f
C1014 net43 net62 0.05751f
C1015 _064_ _142_/a_113_47# 0
C1016 _292_/a_761_289# clknet_2_0__leaf_clk_regs 0.02199f
C1017 _183_/a_27_413# VPWR 0.01876f
C1018 VPWR _267_/a_543_47# 0.0132f
C1019 _188_/a_27_413# _096_ 0
C1020 VPWR _126_/a_68_297# 0.03422f
C1021 net11 net36 0.006f
C1022 _292_/a_27_47# VPWR 0.06592f
C1023 input4/a_27_47# a[12] 0.0147f
C1024 clknet_2_1__leaf_clk_regs _295_/a_761_289# 0
C1025 clk genblk1\[13\].fa_inst.s 0.0229f
C1026 net36 _279_/a_193_47# 0
C1027 _295_/a_448_47# _040_ 0
C1028 _295_/a_651_413# net30 0
C1029 net5 b[10] 0
C1030 net46 pmu_inst/_06_ 0.00177f
C1031 _296_/a_805_47# net31 0
C1032 _183_/a_298_297# _090_ 0.03978f
C1033 _302_/a_27_47# net36 0.00916f
C1034 _178_/a_382_47# _086_ 0.00297f
C1035 _258_/a_27_47# _003_ 0.03889f
C1036 _269_/a_27_47# _269_/a_193_47# -0.01782f
C1037 net46 pmu_inst/_19_/a_205_47# 0
C1038 net22 net19 0
C1039 _037_ _277_/a_1462_47# 0
C1040 _047_ _287_/a_1108_47# 0
C1041 net33 _136_/a_68_297# 0.01163f
C1042 net47 pmu_inst/dc_inst.x3.x18/a_27_47# 0.0021f
C1043 _270_/a_27_47# _270_/a_761_289# -0.01661f
C1044 _287_/a_651_413# net7 0.00675f
C1045 clknet_2_2__leaf_clk_regs b[5] 0
C1046 _173_/a_215_297# _088_ 0.01277f
C1047 net24 a[9] 0
C1048 net47 pmu_inst/dc_inst.x7.net17 0.00597f
C1049 net33 VPWR 6.23157f
C1050 _303_/a_27_47# _303_/a_193_47# -0.16563f
C1051 net39 pmu_inst/dc_inst.x5.x12/a_27_47# 0.00727f
C1052 _280_/a_543_47# net30 0
C1053 _025_ _295_/a_761_289# 0
C1054 _280_/a_761_289# _040_ 0
C1055 _301_/a_1108_47# _031_ 0.00386f
C1056 _034_ net17 0
C1057 clknet_2_0__leaf_clk_regs net13 0
C1058 clk _263_/a_639_47# 0.00176f
C1059 VPWR _298_/a_639_47# 0
C1060 clk _204_/a_561_297# 0
C1061 b[12] input19/a_75_212# 0.00306f
C1062 input20/a_75_212# b[11] 0
C1063 clkload0/a_27_47# _260_/a_543_47# 0.01223f
C1064 net39 pmu_inst/dc_inst.x4.x13/a_27_47# 0.00332f
C1065 net17 _281_/a_27_47# 0
C1066 _281_/a_27_47# clknet_2_2__leaf_clk_regs 0.14973f
C1067 _288_/a_193_47# net17 0.0019f
C1068 _288_/a_27_47# _033_ -0
C1069 net47 pmu_inst_67/HI 0.00732f
C1070 net4 net5 0
C1071 net42 net62 0.05569f
C1072 net14 net16 0.05822f
C1073 _300_/a_1283_21# _299_/a_193_47# 0
C1074 _300_/a_27_47# clknet_2_3__leaf_clk_regs 0
C1075 _300_/a_1108_47# _299_/a_27_47# 0
C1076 net46 net39 8.7373f
C1077 _276_/a_1283_21# net58 0
C1078 clknet_2_2__leaf_clk_regs b[10] 0
C1079 VPWR pmu_inst/dc_inst.x2.net18 0.01161f
C1080 net6 net15 0.83579f
C1081 net29 net16 0
C1082 net58 _280_/a_27_47# 0.00357f
C1083 VPWR _287_/a_1462_47# 0
C1084 _285_/a_651_413# clknet_2_3__leaf_clk_regs 0.00127f
C1085 net24 net12 1.75012f
C1086 _276_/a_27_47# _291_/a_193_47# 0
C1087 genblk1\[7\].fa_inst.s _262_/a_1462_47# 0
C1088 _300_/a_27_47# net32 0
C1089 net39 pmu_inst/dc_inst.x6.net1 0.00148f
C1090 pmu_inst/dc_inst.x7.net18 net34 0
C1091 _294_/a_543_47# _280_/a_27_47# 0.00142f
C1092 output53/a_27_47# VPWR 0.07863f
C1093 _271_/a_651_413# cout_next 0.0016f
C1094 _300_/a_761_289# net60 0.00213f
C1095 _273_/a_1108_47# _018_ 0.00818f
C1096 _273_/a_761_289# genblk1\[1\].fa_inst.a 0.00119f
C1097 clknet_2_0__leaf_clk_regs _051_ 0
C1098 _276_/a_761_289# net12 0
C1099 _292_/a_448_47# _277_/a_193_47# 0
C1100 _292_/a_1217_47# VPWR 0
C1101 net46 pmu_inst/dc_inst.x4.x17/a_27_47# 0
C1102 genblk1\[4\].fa_inst.b _153_/a_27_413# 0.00166f
C1103 net17 _278_/a_27_47# 0
C1104 _293_/a_1283_21# genblk1\[5\].fa_inst.a 0.00104f
C1105 _301_/a_27_47# net21 0.03962f
C1106 _275_/a_761_289# _274_/a_761_289# 0
C1107 _275_/a_193_47# _274_/a_543_47# 0
C1108 _275_/a_543_47# _274_/a_193_47# 0.01243f
C1109 _275_/a_27_47# _274_/a_1283_21# 0.00728f
C1110 _259_/a_193_47# genblk1\[3\].fa_inst.s 0
C1111 clknet_2_1__leaf_clk_regs _164_/a_47_47# 0
C1112 _263_/a_1283_21# net53 0.00589f
C1113 VPWR net35 16.36461f
C1114 _100_ net35 0.03614f
C1115 net26 a[14] 0
C1116 genblk1\[2\].fa_inst.s hold1/a_49_47# 0.00176f
C1117 pmu_inst/_02_ cout_next 0
C1118 _204_/a_225_47# _111_ 0.0517f
C1119 _266_/a_193_47# clknet_2_3__leaf_clk_regs 0.0207f
C1120 net39 pmu_inst/dc_inst.x1.x5/a_27_47# 0
C1121 net4 clknet_2_2__leaf_clk_regs 0.2078f
C1122 net17 net4 0.02098f
C1123 _139_/a_47_47# _058_ 0.00435f
C1124 _290_/a_639_47# VPWR 0
C1125 _292_/a_27_47# net2 0.0261f
C1126 _164_/a_377_297# _079_ 0.00127f
C1127 _301_/a_448_47# clknet_2_2__leaf_clk_regs 0.00269f
C1128 net47 pmu_inst/dc_inst.net4 0.00203f
C1129 _258_/a_1108_47# net36 0.00923f
C1130 _099_ _104_ 0
C1131 _143_/a_27_413# _057_ 0.0011f
C1132 a[10] input16/a_75_212# 0
C1133 net27 _024_ 0.02187f
C1134 net21 _031_ 0
C1135 net46 pmu_inst/dc_inst.x1.net19 0.0026f
C1136 clk net53 0
C1137 _268_/a_543_47# genblk1\[14\].fa_inst.s 0
C1138 net21 b[12] 0
C1139 net46 pmu_inst/dc_inst.net2 0
C1140 _144_/a_377_297# genblk1\[3\].fa_inst.s 0
C1141 _144_/a_285_47# _063_ 0.01803f
C1142 _281_/a_448_47# genblk1\[9\].fa_inst.a 0
C1143 _283_/a_1108_47# net30 0.01157f
C1144 genblk1\[12\].fa_inst.b _193_/a_215_297# 0
C1145 _282_/a_1283_21# net30 0
C1146 _300_/a_27_47# net19 0.03658f
C1147 _131_/a_68_297# _288_/a_27_47# 0
C1148 _134_/a_377_297# _053_ 0
C1149 fanout59/a_27_47# _264_/a_193_47# 0
C1150 _280_/a_448_47# genblk1\[8\].fa_inst.a 0
C1151 cout VPWR 0.22444f
C1152 _289_/a_543_47# net56 0
C1153 _285_/a_651_413# net19 0.00208f
C1154 net72 pmu_inst/dc_inst.x6.net3 0
C1155 genblk1\[9\].fa_inst.a _041_ 0
C1156 VPWR _195_/a_150_297# 0
C1157 pmu_inst/_10_ cout_next 0
C1158 _291_/a_193_47# net14 0
C1159 a[10] net13 0
C1160 net47 pmu_inst/dc_inst.x3.x7/a_27_47# 0.00385f
C1161 net39 pmu_inst/dc_inst.x4.x2/a_27_47# 0
C1162 _037_ _277_/a_193_47# 0
C1163 genblk1\[13\].fa_inst.a net60 0.16832f
C1164 net17 _278_/a_1217_47# 0
C1165 _301_/a_805_47# _046_ 0
C1166 _094_ _029_ 0
C1167 _269_/a_543_47# net44 0
C1168 _269_/a_448_47# _014_ 0
C1169 _098_ _185_/a_68_297# 0
C1170 genblk1\[5\].fa_inst.a net58 0.00249f
C1171 net33 _284_/a_193_47# 0
C1172 _130_/a_27_413# cin_q 0.00566f
C1173 _144_/a_285_47# _057_ 0
C1174 _270_/a_1283_21# net45 0.00291f
C1175 VPWR _295_/a_543_47# 0.01751f
C1176 _090_ _175_/a_150_297# 0.00119f
C1177 _046_ clknet_2_2__leaf_clk_regs 0
C1178 _284_/a_543_47# _298_/a_651_413# 0
C1179 _284_/a_1108_47# _298_/a_1108_47# 0
C1180 _259_/a_1217_47# _003_ 0
C1181 a[7] a[8] 0.06871f
C1182 _022_ _292_/a_193_47# 0.00214f
C1183 _303_/a_543_47# genblk1\[15\].fa_inst.b 0
C1184 output48/a_27_47# s[4] 0
C1185 _280_/a_1108_47# net62 0.00362f
C1186 clknet_2_2__leaf_clk_regs _170_/a_68_297# 0
C1187 _276_/a_1108_47# net36 0.00906f
C1188 _278_/a_448_47# genblk1\[6\].fa_inst.a 0
C1189 _275_/a_1283_21# _288_/a_27_47# 0
C1190 genblk1\[10\].fa_inst.a _089_ 0.00145f
C1191 _026_ genblk1\[9\].fa_inst.a 0
C1192 genblk1\[12\].fa_inst.a _299_/a_543_47# 0
C1193 _276_/a_448_47# a[8] 0
C1194 clknet_2_1__leaf_clk_regs _279_/a_1283_21# 0
C1195 net4 _297_/a_27_47# 0.02666f
C1196 net23 clknet_2_3__leaf_clk_regs 0.07105f
C1197 _300_/a_1217_47# net19 0
C1198 net20 _287_/a_193_47# 0
C1199 net7 _295_/a_639_47# 0.00162f
C1200 _025_ genblk1\[8\].fa_inst.a 0
C1201 _009_ net59 0.11083f
C1202 net28 net36 0.02769f
C1203 net33 _075_ 0
C1204 _165_/a_150_297# VPWR 0
C1205 clk _265_/a_1108_47# 0.00311f
C1206 _286_/a_651_413# clknet_2_3__leaf_clk_regs 0.00774f
C1207 net61 _266_/a_651_413# 0
C1208 VPWR pmu_inst/dc_inst.x4.x3/a_27_47# 0
C1209 _293_/a_448_47# _293_/a_27_47# -0.00642f
C1210 genblk1\[12\].fa_inst.a net60 0
C1211 genblk1\[3\].fa_inst.a net10 0
C1212 genblk1\[1\].fa_inst.a _057_ 0
C1213 genblk1\[12\].fa_inst.a genblk1\[10\].fa_inst.b 0
C1214 VPWR clkbuf_2_0__f_clk_regs/a_110_47# 0.10436f
C1215 _277_/a_761_289# _036_ 0
C1216 net33 _069_ 0.00725f
C1217 cout_next pmu_inst_74/HI 0.00242f
C1218 _280_/a_1283_21# _024_ 0
C1219 _284_/a_193_47# net35 0.54533f
C1220 input35/a_27_47# net35 0.00678f
C1221 delay_sel[1] net34 0.07616f
C1222 net40 net54 0.00184f
C1223 _189_/a_129_47# genblk1\[12\].fa_inst.s 0
C1224 _275_/a_448_47# genblk1\[2\].fa_inst.a 0
C1225 _290_/a_543_47# _289_/a_193_47# 0
C1226 _290_/a_193_47# _289_/a_543_47# 0
C1227 _297_/a_448_47# net31 0.00945f
C1228 _304_/a_761_289# genblk1\[1\].fa_inst.b 0.00678f
C1229 _059_ _136_/a_68_297# 0
C1230 _154_/a_285_47# _072_ 0.00459f
C1231 _079_ net62 0.05372f
C1232 _273_/a_1270_413# VPWR 0
C1233 _255_/a_448_47# net57 0
C1234 net47 pmu_inst/dc_inst.x3.net13 0.00552f
C1235 net33 _284_/a_1462_47# 0
C1236 _275_/a_193_47# net9 0
C1237 VPWR _059_ 0.79581f
C1238 _277_/a_651_413# _292_/a_27_47# 0
C1239 _283_/a_193_47# _027_ 0
C1240 net33 input33/a_27_47# 0.0021f
C1241 _272_/a_193_47# _272_/a_1108_47# -0.00863f
C1242 _272_/a_27_47# _272_/a_448_47# -0.00346f
C1243 net39 pmu_inst/dc_inst.x4.x12/a_27_47# 0.00268f
C1244 output53/a_27_47# s[9] 0
C1245 _282_/a_27_47# _027_ 0.0022f
C1246 _029_ _298_/a_1283_21# 0
C1247 _199_/a_285_47# _110_ 0.05195f
C1248 net60 _103_ 0.08087f
C1249 _198_/a_215_297# _193_/a_215_297# 0
C1250 _284_/a_1283_21# _043_ 0
C1251 VPWR _269_/a_543_47# 0.01848f
C1252 net46 pmu_inst/dc_inst.x4.net10 0
C1253 _304_/a_193_47# _288_/a_1108_47# 0
C1254 _276_/a_27_47# _290_/a_761_289# 0
C1255 genblk1\[4\].fa_inst.a _153_/a_382_47# 0
C1256 _163_/a_382_47# _076_ 0.00118f
C1257 _268_/a_1283_21# genblk1\[13\].fa_inst.s 0
C1258 net46 pmu_inst/dc_inst.x1.x14/a_27_47# 0.00267f
C1259 _164_/a_377_297# VPWR -0.00192f
C1260 net28 _295_/a_761_289# 0
C1261 delay_sel[0] delay_sel[2] 0.10788f
C1262 _301_/a_193_47# clknet_2_3__leaf_clk_regs 0.00135f
C1263 _273_/a_1283_21# net8 0
C1264 VPWR _144_/a_129_47# -0
C1265 _293_/a_639_47# _038_ -0
C1266 genblk1\[2\].fa_inst.a net56 0.19262f
C1267 _143_/a_382_47# _058_ 0
C1268 clknet_2_0__leaf_clk_regs fanout56/a_27_47# 0
C1269 _163_/a_215_297# _080_ 0.00831f
C1270 _129_/a_129_47# _051_ 0
C1271 VPWR _134_/a_377_297# 0
C1272 _277_/a_543_47# net12 0
C1273 _155_/a_150_297# _073_ 0
C1274 VPWR _280_/a_805_47# 0
C1275 net33 _296_/a_27_47# 0
C1276 VPWR _064_ 0.36086f
C1277 _291_/a_27_47# net16 0
C1278 net62 _279_/a_27_47# 0
C1279 _080_ _159_/a_285_47# 0
C1280 net61 net54 0.08458f
C1281 net33 _140_/a_68_297# 0.01093f
C1282 _291_/a_1283_21# net17 0
C1283 net33 _196_/a_113_47# 0
C1284 _301_/a_543_47# net60 0
C1285 net24 net3 0.02163f
C1286 genblk1\[9\].fa_inst.s _088_ 0.00298f
C1287 _277_/a_1108_47# VPWR 0.01877f
C1288 _292_/a_193_47# net24 0
C1289 clknet_2_1__leaf_clk_regs _262_/a_1283_21# 0
C1290 _100_ _186_/a_113_47# 0
C1291 _186_/a_113_47# VPWR -0
C1292 _303_/a_193_47# net60 0
C1293 VPWR _283_/a_193_47# 0.03785f
C1294 _185_/a_68_297# VPWR 0.02049f
C1295 VPWR _282_/a_27_47# 0.07038f
C1296 _100_ _185_/a_68_297# 0
C1297 _068_ _061_ 0.07936f
C1298 _256_/a_1283_21# genblk1\[1\].fa_inst.s 0
C1299 genblk1\[1\].fa_inst.b _132_/a_113_47# 0
C1300 cin net34 0.12625f
C1301 genblk1\[14\].fa_inst.a net60 0.13757f
C1302 net20 net35 0.03308f
C1303 net58 _024_ 0.23688f
C1304 _270_/a_1108_47# clknet_2_3__leaf_clk_regs 0.05673f
C1305 net44 net62 3.77698f
C1306 _020_ genblk1\[2\].fa_inst.a 0.03994f
C1307 genblk1\[0\].fa_inst.a _135_/a_298_297# 0
C1308 net46 pmu_inst/dc_inst.x7.net2 0.00119f
C1309 _294_/a_543_47# _024_ 0
C1310 _263_/a_1270_413# net59 0
C1311 _042_ net31 0
C1312 net15 a[9] 0.12623f
C1313 genblk1\[1\].fa_inst.a net1 0.00293f
C1314 _000_ net57 0.06583f
C1315 net3 _296_/a_805_47# 0
C1316 _286_/a_193_47# net35 0.01439f
C1317 _281_/a_448_47# b[2] 0
C1318 _272_/a_761_289# clknet_2_0__leaf_clk_regs 0.02139f
C1319 _272_/a_27_47# _017_ 0
C1320 genblk1\[4\].fa_inst.a _277_/a_193_47# 0
C1321 _277_/a_27_47# _291_/a_27_47# 0
C1322 _156_/a_113_47# _073_ 0
C1323 _282_/a_1217_47# _027_ 0
C1324 net62 _073_ 0
C1325 net7 _283_/a_651_413# 0.0026f
C1326 _304_/a_193_47# net17 0
C1327 _304_/a_27_47# _033_ 0
C1328 net33 _288_/a_193_47# 0
C1329 net7 _279_/a_27_47# 0
C1330 net7 _282_/a_448_47# 0
C1331 clkload2/a_27_47# clknet_2_3__leaf_clk_regs 0.03885f
C1332 _272_/a_193_47# net1 0.05491f
C1333 _272_/a_27_47# VPWR 0.04094f
C1334 net24 a[6] 0
C1335 _294_/a_1108_47# genblk1\[6\].fa_inst.b 0
C1336 _290_/a_543_47# a[7] 0
C1337 _290_/a_761_289# net14 0
C1338 clknet_2_1__leaf_clk_regs _262_/a_448_47# 0.00188f
C1339 _128_/a_113_47# _051_ 0
C1340 _301_/a_193_47# net19 0
C1341 clknet_2_1__leaf_clk_regs net8 0.00216f
C1342 genblk1\[3\].fa_inst.a _288_/a_448_47# 0.02534f
C1343 _004_ _258_/a_27_47# 0
C1344 _286_/a_1108_47# net18 0
C1345 cin_q _304_/a_543_47# 0
C1346 VPWR pmu_inst/dc_inst.x7.net1 0.00208f
C1347 _294_/a_27_47# net16 0.04224f
C1348 VPWR _155_/a_150_297# 0
C1349 net28 _081_ 0
C1350 _303_/a_805_47# clknet_2_3__leaf_clk_regs 0
C1351 net12 net15 0
C1352 net41 net34 0.02585f
C1353 _261_/a_761_289# _260_/a_27_47# 0
C1354 _261_/a_27_47# _260_/a_761_289# 0
C1355 _303_/a_1283_21# _287_/a_193_47# 0
C1356 _276_/a_448_47# _290_/a_543_47# 0
C1357 VPWR input17/a_27_47# 0.0923f
C1358 _270_/a_27_47# net61 0.00707f
C1359 _293_/a_193_47# _278_/a_1108_47# 0
C1360 _277_/a_1462_47# VPWR 0
C1361 hold1/a_49_47# _053_ 0
C1362 hold1/a_285_47# _056_ 0.01416f
C1363 net3 b[6] 0
C1364 _303_/a_1462_47# net60 0
C1365 _291_/a_27_47# _291_/a_193_47# -0
C1366 net16 net56 0
C1367 net36 _296_/a_193_47# 0
C1368 VPWR _283_/a_1462_47# 0.00209f
C1369 genblk1\[2\].fa_inst.s _138_/a_113_47# 0
C1370 VPWR _279_/a_1108_47# 0.02057f
C1371 net58 _262_/a_1108_47# 0.00256f
C1372 net3 _281_/a_805_47# 0
C1373 VPWR _282_/a_1217_47# 0
C1374 genblk1\[0\].fa_inst.b _288_/a_448_47# 0
C1375 _257_/a_805_47# net57 0
C1376 _302_/a_1283_21# VPWR 0.03947f
C1377 VPWR pmu_inst/dc_inst.x1.net9 0.0075f
C1378 _140_/a_150_297# net36 0
C1379 clknet_2_2__leaf_clk_regs _178_/a_27_413# 0
C1380 _112_ _201_/a_479_47# 0
C1381 clk _267_/a_639_47# 0.00114f
C1382 genblk1\[4\].fa_inst.s _067_ 0.00173f
C1383 VPWR pmu_inst/_15_/a_872_316# 0.00257f
C1384 _086_ _171_/a_113_47# 0
C1385 _023_ _278_/a_805_47# -0.00125f
C1386 VPWR _156_/a_113_47# -0
C1387 net2 _282_/a_27_47# 0.03772f
C1388 genblk1\[11\].fa_inst.a genblk1\[10\].fa_inst.a 0
C1389 net33 _303_/a_1283_21# 0
C1390 net35 b[10] 0
C1391 a[12] net13 0
C1392 net46 pmu_inst/dc_inst.x5.net15 0
C1393 net39 pmu_inst/dc_inst.x2.net6 0.00534f
C1394 net33 _060_ 0
C1395 VPWR net62 18.71614f
C1396 genblk1\[4\].fa_inst.s _068_ 0.00702f
C1397 clknet_0_clk_regs _264_/a_1108_47# 0
C1398 genblk1\[9\].fa_inst.a net59 0.03141f
C1399 VPWR pmu_inst_70/HI 0.0392f
C1400 net7 _027_ 0.00831f
C1401 _272_/a_1217_47# VPWR 0
C1402 net3 _278_/a_805_47# 0
C1403 _131_/a_68_297# _304_/a_27_47# 0
C1404 hold1/a_285_47# _057_ 0
C1405 clknet_2_2__leaf_clk_regs _298_/a_1108_47# 0
C1406 _302_/a_805_47# net7 0
C1407 _277_/a_27_47# net56 0
C1408 input7/a_27_47# net7 0.00198f
C1409 input1/a_75_212# net1 0.00207f
C1410 genblk1\[3\].fa_inst.a _033_ 0.14321f
C1411 net47 pmu_inst/dc_inst.x3.x1/a_27_47# 0.00278f
C1412 _046_ _287_/a_193_47# 0
C1413 net6 b[9] 0.04299f
C1414 VPWR _153_/a_382_47# -0
C1415 output50/a_27_47# s[6] 0
C1416 _281_/a_193_47# net36 0
C1417 _153_/a_298_297# _072_ 0.00465f
C1418 _270_/a_1217_47# net61 0
C1419 genblk1\[12\].fa_inst.b _300_/a_193_47# 0
C1420 _269_/a_543_47# genblk1\[14\].fa_inst.s 0.00387f
C1421 _294_/a_193_47# _280_/a_543_47# 0
C1422 net28 genblk1\[8\].fa_inst.a 0.02379f
C1423 net5 net18 0.00318f
C1424 _274_/a_1283_21# _273_/a_1108_47# 0
C1425 _274_/a_1108_47# _273_/a_1283_21# 0
C1426 input15/a_75_212# a[8] 0.01942f
C1427 net27 _294_/a_1108_47# 0
C1428 net4 net35 0.0364f
C1429 clkbuf_1_0__f_clk/a_110_47# clknet_1_0__leaf_clk 0.00568f
C1430 genblk1\[8\].fa_inst.s _263_/a_27_47# 0.15424f
C1431 _105_ _201_/a_217_297# 0.02489f
C1432 net41 output41/a_27_47# 0.02076f
C1433 _265_/a_193_47# clknet_2_3__leaf_clk_regs 0.1707f
C1434 _255_/a_761_289# _000_ 0
C1435 _255_/a_543_47# genblk1\[0\].fa_inst.s 0.00477f
C1436 _276_/a_1270_413# net36 0
C1437 net33 _146_/a_113_47# 0
C1438 _271_/a_193_47# _271_/a_1108_47# -0.00656f
C1439 VPWR pmu_inst/dc_inst.x4.net16 0
C1440 VPWR pmu_inst/dc_inst.x5.net6 0
C1441 genblk1\[0\].fa_inst.b _033_ 0.16421f
C1442 net47 pmu_inst/dc_inst.x3.x20/a_27_47# 0.00196f
C1443 _265_/a_448_47# genblk1\[10\].fa_inst.s 0.00652f
C1444 clknet_2_3__leaf_clk_regs _179_/a_47_47# 0
C1445 _256_/a_448_47# VPWR 0.00164f
C1446 _016_ net37 0.00419f
C1447 net38 fanout62/a_110_47# 0.07979f
C1448 clk _110_ 0.03557f
C1449 VPWR net7 3.39175f
C1450 _192_/a_113_47# _101_ 0
C1451 clk net42 0
C1452 _303_/a_651_413# net34 0.02633f
C1453 _016_ net45 0
C1454 _291_/a_193_47# net56 0.01294f
C1455 net36 _278_/a_193_47# 0
C1456 _110_ _203_/a_109_297# 0
C1457 net33 _046_ 0
C1458 _258_/a_1217_47# clknet_2_0__leaf_clk_regs 0
C1459 VPWR net69 0.37465f
C1460 VPWR pmu_inst/dc_inst.x1.net4 0.01697f
C1461 net33 _070_ 0
C1462 net33 _170_/a_68_297# 0.00429f
C1463 genblk1\[12\].fa_inst.s _267_/a_543_47# 0.00118f
C1464 net39 pmu_inst/dc_inst.x2.net3 0.00133f
C1465 _297_/a_761_289# net32 0
C1466 _297_/a_193_47# _042_ -0.00122f
C1467 _087_ genblk1\[9\].fa_inst.s 0.00135f
C1468 net27 _041_ 0.0293f
C1469 _270_/a_761_289# genblk1\[15\].fa_inst.s 0
C1470 _281_/a_193_47# _295_/a_761_289# 0
C1471 _281_/a_27_47# _295_/a_543_47# 0.00129f
C1472 _281_/a_543_47# _295_/a_27_47# 0
C1473 _281_/a_761_289# _295_/a_193_47# 0
C1474 clknet_2_0__leaf_clk_regs _058_ 0
C1475 _198_/a_215_297# _108_ 0.00186f
C1476 _022_ genblk1\[5\].fa_inst.a 0.00253f
C1477 _256_/a_193_47# _001_ 0.03934f
C1478 _277_/a_1283_21# net16 0
C1479 net24 _280_/a_27_47# 0
C1480 clknet_2_2__leaf_clk_regs net18 0.09699f
C1481 clkbuf_2_0__f_clk_regs/a_110_47# _260_/a_543_47# 0
C1482 clknet_0_clk_regs _260_/a_27_47# 0
C1483 _303_/a_1108_47# net36 0
C1484 _277_/a_193_47# VPWR 0.03087f
C1485 _277_/a_27_47# _292_/a_543_47# 0.00156f
C1486 net2 net62 0
C1487 clknet_2_1__leaf_clk_regs a[3] 0.01778f
C1488 genblk1\[3\].fa_inst.a _131_/a_68_297# 0.01409f
C1489 clknet_2_0__leaf_clk_regs hold1/a_391_47# 0
C1490 _292_/a_193_47# _277_/a_543_47# 0
C1491 genblk1\[11\].fa_inst.b _299_/a_1108_47# 0
C1492 genblk1\[11\].fa_inst.b clknet_2_3__leaf_clk_regs 0
C1493 net33 _066_ 0.01849f
C1494 net25 net5 0.61507f
C1495 net59 _297_/a_1108_47# 0.05872f
C1496 _054_ _051_ 0.00213f
C1497 VPWR hold1/a_49_47# 0.02299f
C1498 genblk1\[5\].fa_inst.a genblk1\[5\].fa_inst.b 0.36051f
C1499 net75 _135_/a_298_297# 0
C1500 delay_sel[0] delay_sel[1] 0.43606f
C1501 _098_ _101_ 0
C1502 _274_/a_1108_47# clknet_2_1__leaf_clk_regs 0.00104f
C1503 _019_ _273_/a_543_47# 0
C1504 _274_/a_543_47# _018_ 0
C1505 _274_/a_27_47# genblk1\[1\].fa_inst.a 0
C1506 genblk1\[11\].fa_inst.b _044_ 0
C1507 _291_/a_448_47# _036_ 0
C1508 net29 _280_/a_543_47# 0.01726f
C1509 _294_/a_805_47# net3 0
C1510 VPWR output52/a_27_47# 0.0417f
C1511 _271_/a_27_47# _016_ 0.01139f
C1512 _258_/a_1283_21# net48 0.01577f
C1513 _258_/a_651_413# _003_ 0.00442f
C1514 net27 _026_ 0.01847f
C1515 _010_ genblk1\[10\].fa_inst.s 0.00446f
C1516 _001_ VPWR 0.24347f
C1517 net13 genblk1\[6\].fa_inst.a 0.00143f
C1518 _157_/a_113_47# _073_ 0
C1519 _064_ _140_/a_68_297# 0
C1520 _277_/a_27_47# _277_/a_1283_21# -0
C1521 _285_/a_193_47# net7 0.02456f
C1522 _299_/a_761_289# net32 0
C1523 _291_/a_1462_47# net56 0
C1524 genblk1\[8\].fa_inst.b _296_/a_448_47# 0
C1525 net75 genblk1\[1\].fa_inst.s 0.00655f
C1526 _293_/a_27_47# genblk1\[7\].fa_inst.a 0
C1527 _168_/a_298_297# genblk1\[7\].fa_inst.b 0
C1528 _168_/a_215_297# _077_ 0.03625f
C1529 genblk1\[11\].fa_inst.s _266_/a_193_47# 0.10987f
C1530 net46 pmu_inst/dc_inst.x4.x4/a_27_47# -0
C1531 _304_/a_27_47# _304_/a_448_47# -0.00297f
C1532 _282_/a_27_47# _296_/a_27_47# 0.00125f
C1533 _044_ _299_/a_761_289# 0.0038f
C1534 net60 _299_/a_1283_21# 0.00773f
C1535 _297_/a_1462_47# _042_ -0
C1536 _108_ _102_ 0.06914f
C1537 net48 VPWR 4.80884f
C1538 _268_/a_1108_47# clknet_2_3__leaf_clk_regs 0.00172f
C1539 net25 clknet_2_2__leaf_clk_regs 0
C1540 net10 a[4] 0
C1541 net2 net7 0.01932f
C1542 net25 net17 0.02487f
C1543 _256_/a_639_47# net46 0
C1544 _291_/a_193_47# _290_/a_193_47# 0
C1545 _275_/a_1283_21# genblk1\[3\].fa_inst.a 0.00292f
C1546 clknet_0_clk_regs _260_/a_1217_47# 0
C1547 _294_/a_1108_47# _280_/a_1283_21# 0
C1548 VPWR pmu_inst/dc_inst.x3.x12/a_27_47# 0
C1549 net6 input7/a_27_47# 0.02123f
C1550 _262_/a_651_413# net62 0.00243f
C1551 clknet_2_3__leaf_clk_regs net59 0.03027f
C1552 clkbuf_2_3__f_clk_regs/a_110_47# _266_/a_761_289# 0.01109f
C1553 net46 net66 0
C1554 net47 pmu_inst/_24_/a_193_47# 0.00453f
C1555 _183_/a_27_413# _093_ 0
C1556 VPWR _285_/a_448_47# 0.00166f
C1557 _021_ _291_/a_448_47# 0
C1558 net3 net15 0.03432f
C1559 clknet_2_3__leaf_clk_regs _298_/a_27_47# 0.00133f
C1560 genblk1\[11\].fa_inst.b net19 0
C1561 _292_/a_193_47# net15 0
C1562 net59 net32 0
C1563 genblk1\[14\].fa_inst.s net62 0
C1564 a[8] input16/a_75_212# 0
C1565 _304_/a_639_47# net56 0
C1566 _289_/a_805_47# net11 0
C1567 genblk1\[3\].fa_inst.b _148_/a_215_297# 0
C1568 _284_/a_1283_21# genblk1\[11\].fa_inst.a 0
C1569 b[7] clknet_2_3__leaf_clk_regs 0
C1570 _298_/a_27_47# net32 0.04236f
C1571 cin delay_sel[0] 0.06447f
C1572 _274_/a_1217_47# genblk1\[1\].fa_inst.a 0
C1573 _277_/a_193_47# net2 0
C1574 net61 _268_/a_27_47# 0.00148f
C1575 net7 _284_/a_193_47# 0.0363f
C1576 net46 pmu_inst/dc_inst.x4.x1/a_27_47# 0
C1577 _299_/a_761_289# net19 0
C1578 b[7] net32 0
C1579 net57 clkbuf_2_0__f_clk_regs/a_110_47# 0
C1580 input25/a_75_212# b[2] 0.01625f
C1581 _168_/a_298_297# _173_/a_27_413# 0
C1582 VPWR _264_/a_761_289# 0.02091f
C1583 VPWR _199_/a_285_47# -0
C1584 _273_/a_448_47# net9 0.00203f
C1585 clknet_2_0__leaf_clk_regs _129_/a_47_47# 0
C1586 _276_/a_193_47# net36 0.01302f
C1587 VPWR _157_/a_113_47# -0
C1588 _287_/a_543_47# clknet_2_3__leaf_clk_regs 0.00203f
C1589 net39 pmu_inst/dc_inst.x1.net2 0
C1590 genblk1\[10\].fa_inst.b _298_/a_761_289# 0
C1591 net33 _093_ 0
C1592 _302_/a_193_47# _286_/a_1283_21# 0
C1593 VPWR net6 2.32355f
C1594 _267_/a_1108_47# clknet_2_3__leaf_clk_regs 0.00125f
C1595 VPWR _266_/a_27_47# 0.01603f
C1596 net26 a[11] 0
C1597 genblk1\[8\].fa_inst.b _041_ 0.00122f
C1598 net46 pmu_inst/dc_inst.x5.x12/a_27_47# 0
C1599 _304_/a_27_47# _049_ -0
C1600 _304_/a_193_47# net33 0.03426f
C1601 _060_ _059_ 0.03394f
C1602 net13 a[8] 0.08749f
C1603 VPWR _150_/a_150_297# 0
C1604 _287_/a_1108_47# net60 0.02986f
C1605 _187_/a_113_47# _099_ 0
C1606 genblk1\[1\].fa_inst.a _288_/a_27_47# 0
C1607 cout_next net67 0.07355f
C1608 _072_ _150_/a_68_297# 0
C1609 net59 _298_/a_543_47# 0
C1610 net72 pmu_inst/dc_inst.x6.x7/a_27_47# 0
C1611 _264_/a_1283_21# genblk1\[9\].fa_inst.s 0
C1612 net3 _042_ 0.02368f
C1613 net46 pmu_inst/dc_inst.x4.x13/a_27_47# 0
C1614 net27 _297_/a_761_289# 0
C1615 VPWR _289_/a_27_47# 0.07161f
C1616 net33 _148_/a_298_297# 0
C1617 _302_/a_27_47# genblk1\[14\].fa_inst.b 0
C1618 VPWR _284_/a_448_47# -0.00287f
C1619 _272_/a_27_47# _288_/a_193_47# 0
C1620 net39 pmu_inst/dc_inst.x1.net15 0
C1621 _257_/a_27_47# genblk1\[2\].fa_inst.s 0.04956f
C1622 _300_/a_805_47# VPWR 0
C1623 _262_/a_761_289# _262_/a_27_47# -0.01166f
C1624 genblk1\[13\].fa_inst.a _198_/a_27_413# 0
C1625 _300_/a_27_47# _285_/a_27_47# 0
C1626 net47 pmu_inst/_25_/a_761_289# 0.00495f
C1627 _293_/a_193_47# _023_ 0
C1628 _108_ _190_/a_68_297# 0
C1629 _198_/a_382_47# _101_ 0.00252f
C1630 clknet_2_1__leaf_clk_regs net5 0
C1631 _064_ _060_ 0
C1632 net47 pmu_inst/_24_/a_1462_47# 0
C1633 net47 pmu_inst/dc_inst.x8/a_277_47# 0.00214f
C1634 _039_ _279_/a_543_47# 0
C1635 _294_/a_1108_47# net58 0.02601f
C1636 _108_ cout_next 0
C1637 _268_/a_1283_21# net43 0.00291f
C1638 VPWR _030_ 0.15674f
C1639 _285_/a_193_47# _285_/a_448_47# -0
C1640 net46 pmu_inst/dc_inst.x6.net1 0.0098f
C1641 _021_ _036_ 0
C1642 _281_/a_1283_21# _025_ 0
C1643 net4 _282_/a_27_47# 0.02731f
C1644 net4 _283_/a_193_47# 0.01779f
C1645 VPWR _101_ 0.20456f
C1646 net49 _004_ 0.14587f
C1647 net50 genblk1\[5\].fa_inst.s 0
C1648 net61 _267_/a_27_47# 0.00147f
C1649 _290_/a_761_289# net56 0
C1650 genblk1\[3\].fa_inst.a genblk1\[3\].fa_inst.b 0.33042f
C1651 clknet_2_1__leaf_clk_regs _278_/a_1283_21# 0.09768f
C1652 genblk1\[15\].fa_inst.b _105_ 0
C1653 net39 net55 0.03338f
C1654 net46 pmu_inst_72/HI 0.0022f
C1655 _291_/a_1108_47# net36 0.00751f
C1656 _023_ _038_ 0.00409f
C1657 _294_/a_1283_21# _279_/a_1283_21# 0
C1658 net33 _178_/a_27_413# 0
C1659 _093_ net35 0.28981f
C1660 _011_ net62 0
C1661 net47 pmu_inst/dc_inst.x3.x11/a_27_47# 0.00432f
C1662 _107_ _108_ 0.14391f
C1663 net7 _284_/a_1462_47# 0
C1664 _062_ _058_ 0
C1665 net3 _038_ 0
C1666 VPWR net10 0.49255f
C1667 net20 net7 0.70793f
C1668 _018_ net9 0.00103f
C1669 genblk1\[0\].fa_inst.a _052_ 0
C1670 net46 pmu_inst/dc_inst.x1.x5/a_27_47# 0.00218f
C1671 input24/a_27_47# b[2] 0.00371f
C1672 b[1] input25/a_75_212# 0
C1673 _274_/a_1270_413# clknet_2_0__leaf_clk_regs 0
C1674 _294_/a_193_47# genblk1\[7\].fa_inst.a 0
C1675 _286_/a_193_47# net7 0
C1676 _274_/a_448_47# VPWR 0.00166f
C1677 _282_/a_1108_47# _041_ 0
C1678 _282_/a_448_47# net31 0
C1679 _027_ _296_/a_1108_47# 0
C1680 _200_/a_59_75# genblk1\[15\].fa_inst.b 0.07957f
C1681 net16 _040_ 0
C1682 _054_ _134_/a_285_47# 0
C1683 clknet_2_1__leaf_clk_regs net17 0.05352f
C1684 net58 net50 0.03093f
C1685 clknet_2_1__leaf_clk_regs clknet_2_2__leaf_clk_regs 0
C1686 net7 _296_/a_27_47# 0.03176f
C1687 genblk1\[9\].fa_inst.a net30 0
C1688 net5 _279_/a_193_47# 0
C1689 net40 net34 0.02399f
C1690 genblk1\[3\].fa_inst.a _049_ 0
C1691 net2 net6 0
C1692 _126_/a_150_297# genblk1\[0\].fa_inst.b 0
C1693 _126_/a_68_297# _050_ 0
C1694 VPWR _289_/a_1217_47# 0
C1695 _149_/a_47_47# net36 0
C1696 _279_/a_1108_47# _278_/a_27_47# 0
C1697 _279_/a_761_289# _278_/a_543_47# 0
C1698 _279_/a_27_47# _278_/a_1108_47# 0
C1699 _279_/a_543_47# _278_/a_761_289# 0
C1700 _183_/a_215_297# _092_ 0.01076f
C1701 _302_/a_1217_47# genblk1\[14\].fa_inst.b 0
C1702 _292_/a_193_47# _292_/a_448_47# -0.00297f
C1703 genblk1\[9\].fa_inst.a _088_ 0
C1704 VPWR b[15] 0.24605f
C1705 _268_/a_1283_21# net42 0
C1706 VPWR _029_ 0.02608f
C1707 _291_/a_651_413# _035_ 0
C1708 _300_/a_651_413# _285_/a_1283_21# 0
C1709 clknet_2_0__leaf_clk_regs net14 0
C1710 input6/a_27_47# net6 0.03615f
C1711 net33 _287_/a_1270_413# 0
C1712 _285_/a_193_47# _030_ 0
C1713 net47 pmu_inst/dc_inst.x9/a_1290_413# 0.00142f
C1714 _148_/a_382_47# net36 0
C1715 VPWR _286_/a_448_47# 0
C1716 clknet_2_1__leaf_clk_regs a[5] 0.01777f
C1717 net17 _025_ 0.04471f
C1718 _166_/a_113_47# _082_ 0
C1719 VPWR _201_/a_217_297# 0.02039f
C1720 net61 _267_/a_1217_47# 0
C1721 _270_/a_1283_21# net44 0
C1722 net46 pmu_inst/dc_inst.x4.x2/a_27_47# 0.00144f
C1723 net46 pmu_inst/dc_inst.x2.x20/a_27_47# 0
C1724 _277_/a_448_47# net16 0.01444f
C1725 _302_/a_543_47# _301_/a_651_413# 0
C1726 net26 net36 0.3475f
C1727 VPWR _296_/a_1108_47# 0.04654f
C1728 net27 net59 0.00222f
C1729 _198_/a_27_413# _103_ 0
C1730 VPWR pmu_inst/dc_inst.x5.net3 0
C1731 genblk1\[2\].fa_inst.s _049_ 0
C1732 VPWR pmu_inst/dc_inst.x6.x9/a_27_47# 0
C1733 net6 _284_/a_193_47# 0
C1734 _292_/a_1283_21# _277_/a_1283_21# 0
C1735 _164_/a_47_47# _080_ 0.04403f
C1736 _282_/a_1108_47# _026_ 0
C1737 _080_ _081_ 0
C1738 net61 net34 0
C1739 net17 _279_/a_193_47# 0
C1740 _084_ _079_ 0.0047f
C1741 _302_/a_27_47# clknet_2_2__leaf_clk_regs 0.0665f
C1742 net4 net62 0
C1743 net7 _281_/a_27_47# 0.02328f
C1744 _287_/a_27_47# genblk1\[15\].fa_inst.a 0
C1745 _287_/a_543_47# _032_ 0
C1746 net14 genblk1\[7\].fa_inst.a 0
C1747 _294_/a_651_413# genblk1\[6\].fa_inst.b 0
C1748 net35 _298_/a_1108_47# 0
C1749 genblk1\[12\].fa_inst.s _186_/a_113_47# 0
C1750 _286_/a_1462_47# net7 0
C1751 genblk1\[5\].fa_inst.a _065_ 0
C1752 input24/a_27_47# b[1] 0.014f
C1753 clknet_0_clk_regs _265_/a_543_47# 0.00186f
C1754 _019_ VPWR -0.01757f
C1755 _027_ net31 0
C1756 output44/a_27_47# net45 0.00278f
C1757 _275_/a_193_47# _273_/a_448_47# 0
C1758 _015_ fanout61/a_27_47# 0.02387f
C1759 _037_ _023_ 0
C1760 _267_/a_1283_21# net42 0.0024f
C1761 _284_/a_193_47# _284_/a_448_47# -0.00482f
C1762 pmu_inst/dc_inst.x1.net7 cout_next 0
C1763 _280_/a_27_47# net15 0.15498f
C1764 _301_/a_27_47# VPWR 0.07162f
C1765 net11 a[5] 0
C1766 VPWR _263_/a_1283_21# 0.02269f
C1767 _199_/a_285_47# genblk1\[14\].fa_inst.s 0
C1768 _037_ net3 0.00125f
C1769 _292_/a_761_289# net27 0.04418f
C1770 _292_/a_193_47# _037_ -0.00128f
C1771 _157_/a_113_47# _075_ 0
C1772 clknet_2_0__leaf_clk_regs _288_/a_1270_413# 0
C1773 VPWR _138_/a_113_47# -0
C1774 net47 pmu_inst/clkload0/X 0.00424f
C1775 VPWR _281_/a_1108_47# 0.02078f
C1776 _300_/a_27_47# _286_/a_27_47# 0.00108f
C1777 VPWR _288_/a_448_47# 0.0023f
C1778 _285_/a_639_47# genblk1\[13\].fa_inst.a 0
C1779 _273_/a_193_47# net56 0
C1780 net47 net34 0.10099f
C1781 _297_/a_1108_47# net30 0.00696f
C1782 VPWR _031_ 0.19233f
C1783 net16 b[0] 0
C1784 clk VPWR 9.21162f
C1785 _286_/a_1108_47# _285_/a_761_289# 0
C1786 _148_/a_215_297# _143_/a_27_413# 0
C1787 _148_/a_27_413# _143_/a_215_297# 0
C1788 _277_/a_543_47# genblk1\[5\].fa_inst.a 0
C1789 _294_/a_27_47# _280_/a_543_47# 0
C1790 net61 genblk1\[15\].fa_inst.s 0.04261f
C1791 net4 net7 0.01949f
C1792 _130_/a_215_297# clknet_2_0__leaf_clk_regs 0
C1793 VPWR _203_/a_109_297# 0
C1794 _302_/a_1283_21# _046_ 0
C1795 VPWR b[12] 0.21338f
C1796 _301_/a_448_47# net7 0
C1797 VPWR net31 0.8042f
C1798 _131_/a_150_297# net56 0
C1799 VPWR pmu_inst/dc_inst.x6.net19 0.00291f
C1800 _150_/a_150_297# _069_ 0
C1801 _269_/a_193_47# _268_/a_193_47# 0
C1802 clknet_2_2__leaf_clk_regs _174_/a_377_297# 0.00402f
C1803 _270_/a_1283_21# VPWR 0.02964f
C1804 _303_/a_1283_21# net7 0
C1805 _256_/a_448_47# net57 0
C1806 net47 pmu_inst/dc_inst.x3.net4 0.00337f
C1807 _277_/a_448_47# _291_/a_193_47# 0
C1808 _277_/a_1108_47# _291_/a_1283_21# 0
C1809 VPWR _278_/a_1108_47# 0.01441f
C1810 net17 _279_/a_1462_47# 0
C1811 net28 _296_/a_1283_21# 0.01112f
C1812 net20 net6 0
C1813 a[10] net14 0
C1814 net27 net13 0
C1815 net39 pmu_inst/dc_inst.x2.net10 0.00337f
C1816 _287_/a_1217_47# genblk1\[15\].fa_inst.a 0
C1817 _304_/a_543_47# genblk1\[2\].fa_inst.b 0
C1818 net35 net18 0.04656f
C1819 net47 pmu_inst/capture_d 0.01904f
C1820 _163_/a_382_47# _073_ 0.003f
C1821 _080_ _155_/a_68_297# 0
C1822 net39 pmu_inst/dc_inst.x5.net4 0.00123f
C1823 _286_/a_193_47# net6 0.00289f
C1824 genblk1\[4\].fa_inst.s clknet_2_0__leaf_clk_regs 0.21062f
C1825 _275_/a_543_47# clknet_2_1__leaf_clk_regs 0.00336f
C1826 _275_/a_193_47# _018_ 0
C1827 net59 _173_/a_298_297# 0
C1828 _283_/a_1283_21# _297_/a_1283_21# 0.00102f
C1829 net34 net36 0.13331f
C1830 VPWR pmu_inst/dc_inst.x4.net14 0.00114f
C1831 _282_/a_193_47# _297_/a_448_47# 0
C1832 _205_/a_47_47# genblk1\[15\].fa_inst.s 0.00368f
C1833 _205_/a_129_47# _110_ 0
C1834 _284_/a_193_47# _029_ -0
C1835 VPWR pmu_inst/dc_inst.x6.net11 0.00242f
C1836 _264_/a_193_47# net54 0
C1837 _264_/a_1283_21# _009_ 0.00291f
C1838 _108_ _204_/a_33_297# 0.00135f
C1839 _301_/a_1217_47# VPWR 0
C1840 input10/a_75_212# a[3] 0.01461f
C1841 _290_/a_448_47# net36 0
C1842 _291_/a_1270_413# clknet_2_1__leaf_clk_regs 0
C1843 _292_/a_1462_47# _037_ -0
C1844 _303_/a_639_47# VPWR 0
C1845 _017_ _033_ -0
C1846 _084_ _174_/a_47_47# 0
C1847 clknet_2_3__leaf_clk_regs net30 0.49117f
C1848 VPWR a[9] 0.21115f
C1849 net27 _294_/a_651_413# 0.00452f
C1850 net20 _030_ 0
C1851 _269_/a_1108_47# clknet_2_3__leaf_clk_regs 0
C1852 _300_/a_448_47# _286_/a_1108_47# 0
C1853 _266_/a_27_47# _011_ 0
C1854 net8 a[2] 0.01255f
C1855 pmu_inst/_09_ cout_next 0
C1856 _274_/a_193_47# net10 0.00448f
C1857 VPWR _033_ 0.0843f
C1858 VPWR pmu_inst/dc_inst.x2.x6/a_27_47# 0
C1859 _273_/a_1462_47# net56 0
C1860 _052_ net75 0.02516f
C1861 VPWR pmu_inst/dc_inst.x7.x13/a_27_47# 0
C1862 _262_/a_761_289# _007_ 0
C1863 genblk1\[8\].fa_inst.b net59 0.00188f
C1864 net32 net30 0.01533f
C1865 clknet_2_2__leaf_clk_regs _086_ 0.04086f
C1866 _092_ _175_/a_68_297# 0
C1867 cin_q genblk1\[0\].fa_inst.a 0
C1868 net47 pmu_inst/dc_inst.x3.x9/a_27_47# 0.00314f
C1869 net3 _295_/a_639_47# 0.00198f
C1870 _108_ _109_ 0
C1871 _031_ _285_/a_193_47# 0
C1872 net28 _281_/a_1283_21# 0.00603f
C1873 net22 net21 0.04796f
C1874 _274_/a_193_47# _274_/a_448_47# -0.00297f
C1875 net6 b[5] 0.04299f
C1876 _046_ net7 0.02117f
C1877 net52 net34 0.02399f
C1878 _189_/a_285_47# VPWR 0.00305f
C1879 _189_/a_285_47# _100_ 0.00633f
C1880 _285_/a_193_47# net31 0
C1881 _275_/a_543_47# net11 0
C1882 _067_ _071_ 0
C1883 _066_ _153_/a_382_47# 0
C1884 net5 _285_/a_761_289# 0
C1885 _001_ net57 0.20343f
C1886 VPWR net12 0.98788f
C1887 clkload0/a_361_47# VPWR 0.08624f
C1888 _098_ _299_/a_193_47# 0
C1889 genblk1\[12\].fa_inst.b _299_/a_543_47# 0
C1890 genblk1\[1\].fa_inst.a _304_/a_27_47# 0.00408f
C1891 net3 _280_/a_1108_47# 0
C1892 _107_ _201_/a_637_47# 0.00204f
C1893 genblk1\[14\].fa_inst.s _201_/a_217_297# 0
C1894 _304_/a_1462_47# _059_ 0
C1895 _290_/a_1270_413# _035_ 0
C1896 _163_/a_382_47# VPWR -0
C1897 _084_ VPWR 0.58877f
C1898 net28 net5 0.03721f
C1899 _283_/a_543_47# clknet_2_3__leaf_clk_regs 0
C1900 _054_ _058_ 0
C1901 _068_ _071_ 0
C1902 _097_ _299_/a_27_47# 0
C1903 net2 net31 0.00879f
C1904 net61 _269_/a_27_47# 0.00717f
C1905 _021_ genblk1\[2\].fa_inst.b 0
C1906 net28 _278_/a_1283_21# 0
C1907 _298_/a_543_47# net30 0.01677f
C1908 _289_/a_193_47# net24 0.00573f
C1909 _289_/a_27_47# _034_ -0
C1910 net48 net57 0.56138f
C1911 _283_/a_761_289# _042_ 0
C1912 _301_/a_1283_21# _300_/a_193_47# 0
C1913 _301_/a_543_47# _300_/a_761_289# 0.00108f
C1914 genblk1\[12\].fa_inst.b net60 0.33809f
C1915 _301_/a_1108_47# _300_/a_27_47# 0
C1916 net6 b[10] 0.04299f
C1917 clkbuf_2_3__f_clk_regs/a_110_47# _265_/a_761_289# 0
C1918 b[3] input27/a_75_212# 0
C1919 _027_ _297_/a_193_47# 0
C1920 _282_/a_193_47# _042_ 0
C1921 _284_/a_639_47# genblk1\[12\].fa_inst.a 0
C1922 genblk1\[0\].fa_inst.s genblk1\[1\].fa_inst.s 0.00154f
C1923 _264_/a_1462_47# net54 0
C1924 _197_/a_113_47# _110_ 0
C1925 _184_/a_129_47# _095_ 0.00284f
C1926 cin input23/a_75_212# 0.00367f
C1927 input33/a_27_47# b[15] 0
C1928 _035_ net36 0.02412f
C1929 _062_ _061_ 0.38978f
C1930 genblk1\[9\].fa_inst.b _297_/a_1283_21# 0.00127f
C1931 _054_ hold1/a_391_47# 0.06876f
C1932 a[13] a[14] 0.06434f
C1933 genblk1\[15\].fa_inst.b VPWR 0.63825f
C1934 genblk1\[4\].fa_inst.a genblk1\[3\].fa_inst.b 0.15492f
C1935 _283_/a_1108_47# genblk1\[10\].fa_inst.b 0
C1936 net58 net59 0.00254f
C1937 _096_ _089_ 0.15906f
C1938 _271_/a_193_47# net62 0.00431f
C1939 _271_/a_448_47# net44 0.01615f
C1940 _300_/a_761_289# genblk1\[14\].fa_inst.a 0
C1941 _276_/a_543_47# _291_/a_543_47# 0.00121f
C1942 net39 pmu_inst/dc_inst.x5.x14/a_27_47# 0.00242f
C1943 _131_/a_68_297# VPWR 0.02308f
C1944 _083_ genblk1\[8\].fa_inst.s 0.00977f
C1945 genblk1\[10\].fa_inst.a _176_/a_113_47# 0
C1946 net49 _259_/a_761_289# 0
C1947 _292_/a_27_47# clknet_2_1__leaf_clk_regs 0.00362f
C1948 _261_/a_27_47# genblk1\[6\].fa_inst.s 0.04053f
C1949 _283_/a_448_47# net59 0
C1950 _284_/a_193_47# net31 0.02207f
C1951 net34 net51 0.02399f
C1952 _256_/a_651_413# _255_/a_193_47# 0
C1953 _256_/a_543_47# _255_/a_1108_47# 0.00983f
C1954 net27 _295_/a_1108_47# 0.00335f
C1955 genblk1\[7\].fa_inst.b _077_ 0.32134f
C1956 net58 fanout58/a_27_47# 0.01068f
C1957 _282_/a_1108_47# net59 0.02591f
C1958 _286_/a_193_47# _286_/a_448_47# -0.00297f
C1959 net28 net17 1.58183f
C1960 _079_ _078_ 0.01583f
C1961 net28 clknet_2_2__leaf_clk_regs 0.04597f
C1962 VPWR _265_/a_27_47# 0.05811f
C1963 net4 net6 0
C1964 _274_/a_193_47# _019_ -0.00199f
C1965 _283_/a_193_47# _298_/a_1108_47# 0
C1966 _283_/a_27_47# _298_/a_448_47# 0
C1967 _283_/a_543_47# _298_/a_543_47# 0
C1968 _272_/a_1283_21# net56 0.08348f
C1969 _293_/a_193_47# genblk1\[5\].fa_inst.a 0
C1970 clk _262_/a_651_413# 0.00787f
C1971 VPWR _297_/a_193_47# 0.04051f
C1972 net47 pmu_inst/dc_inst.x3.x8/a_27_47# 0.00445f
C1973 VPWR pmu_inst/_16_/a_27_93# 0
C1974 genblk1\[2\].fa_inst.a _289_/a_543_47# 0
C1975 clknet_2_1__leaf_clk_regs net33 0.02241f
C1976 genblk1\[5\].fa_inst.a _038_ 0
C1977 _295_/a_27_47# _295_/a_761_289# -0.01264f
C1978 clk _264_/a_1270_413# 0
C1979 net46 pmu_inst/dc_inst.x2.net6 0
C1980 _049_ _135_/a_27_413# 0
C1981 _304_/a_651_413# _057_ 0
C1982 net27 _280_/a_193_47# 0.03131f
C1983 clk genblk1\[14\].fa_inst.s 0.0243f
C1984 net4 _284_/a_448_47# 0.00231f
C1985 _292_/a_1108_47# fanout56/a_27_47# 0
C1986 _292_/a_761_289# net58 0.01136f
C1987 net61 _269_/a_1217_47# 0
C1988 _099_ _098_ 0.01141f
C1989 clk _266_/a_448_47# 0.01349f
C1990 genblk1\[3\].fa_inst.a genblk1\[1\].fa_inst.a 0.07418f
C1991 _293_/a_27_47# genblk1\[6\].fa_inst.a 0.70548f
C1992 _023_ _279_/a_27_47# 0
C1993 _302_/a_448_47# clknet_2_3__leaf_clk_regs 0.00386f
C1994 _255_/a_651_413# VPWR 0
C1995 _289_/a_1270_413# genblk1\[1\].fa_inst.b 0
C1996 _302_/a_193_47# _287_/a_27_47# 0
C1997 _302_/a_27_47# _287_/a_193_47# 0
C1998 _301_/a_27_47# net20 0.03391f
C1999 net21 _300_/a_27_47# 0
C2000 _259_/a_1108_47# clknet_2_0__leaf_clk_regs 0
C2001 net3 _283_/a_651_413# 0.00879f
C2002 net2 net12 0
C2003 net3 _279_/a_27_47# 0.02349f
C2004 net7 _297_/a_651_413# 0.0026f
C2005 pmu_inst/dc_inst.x4.net14 net71 -0
C2006 genblk1\[3\].fa_inst.a _272_/a_193_47# 0
C2007 _259_/a_543_47# clkbuf_2_0__f_clk_regs/a_110_47# 0
C2008 _301_/a_651_413# genblk1\[13\].fa_inst.b 0
C2009 _301_/a_193_47# _286_/a_27_47# 0
C2010 _301_/a_27_47# _286_/a_193_47# 0
C2011 net39 pmu_inst/dc_inst.x4.x19/a_27_47# 0.00233f
C2012 _049_ _053_ 0.00219f
C2013 net33 _025_ 0
C2014 _302_/a_1270_413# net60 0
C2015 _300_/a_448_47# clknet_2_2__leaf_clk_regs 0
C2016 _275_/a_1283_21# VPWR 0.02452f
C2017 clknet_0_clk_regs _261_/a_543_47# 0
C2018 _010_ net62 0
C2019 net24 a[7] 0
C2020 _016_ net44 0.082f
C2021 net20 _031_ 0.04958f
C2022 _259_/a_27_47# genblk1\[4\].fa_inst.s 0.03685f
C2023 _028_ net59 0.04615f
C2024 genblk1\[14\].fa_inst.a genblk1\[13\].fa_inst.a 0
C2025 net20 b[12] 0.00473f
C2026 a[3] a[2] 0.07915f
C2027 _256_/a_543_47# genblk1\[0\].fa_inst.s 0.00106f
C2028 _256_/a_761_289# _000_ 0
C2029 _291_/a_639_47# VPWR 0
C2030 _277_/a_193_47# _291_/a_1283_21# 0.00117f
C2031 net27 net30 1.53029f
C2032 _286_/a_193_47# _031_ -0.00118f
C2033 _097_ net33 0
C2034 net58 net13 0
C2035 _054_ _129_/a_47_47# 0
C2036 _271_/a_448_47# VPWR -0.00357f
C2037 VPWR _299_/a_193_47# 0.07321f
C2038 _028_ _298_/a_27_47# 0
C2039 _283_/a_27_47# _043_ 0
C2040 b[3] net36 0
C2041 _275_/a_27_47# net8 0
C2042 clknet_2_0__leaf_clk_regs net56 0.75333f
C2043 _281_/a_761_289# _296_/a_543_47# 0
C2044 _281_/a_1283_21# _296_/a_193_47# 0
C2045 _281_/a_543_47# _296_/a_761_289# 0
C2046 VPWR _297_/a_1462_47# 0.00105f
C2047 _273_/a_27_47# _273_/a_193_47# -0.01782f
C2048 _274_/a_1283_21# net9 0
C2049 _257_/a_761_289# clknet_2_0__leaf_clk_regs 0
C2050 _078_ _073_ 0
C2051 _198_/a_215_297# net60 0
C2052 net52 _262_/a_1270_413# 0
C2053 _083_ _081_ 0.01445f
C2054 net46 pmu_inst/dc_inst.x2.net3 -0
C2055 _294_/a_27_47# genblk1\[7\].fa_inst.a 0
C2056 _184_/a_377_297# _096_ 0.00143f
C2057 _015_ cout_next 0
C2058 _257_/a_27_47# VPWR 0.04372f
C2059 _296_/a_27_47# net31 0.13938f
C2060 fanout59/a_27_47# net62 0.01549f
C2061 net28 _297_/a_27_47# 0
C2062 VPWR _268_/a_1283_21# 0.02299f
C2063 VPWR pmu_inst/dc_inst.x8/a_1290_413# 0
C2064 net4 _029_ 0
C2065 _051_ _056_ 0
C2066 net5 _296_/a_193_47# 0
C2067 clk _011_ 0.00532f
C2068 net46 pmu_inst_65/HI 0.0022f
C2069 net2 _297_/a_193_47# 0
C2070 _047_ clknet_2_3__leaf_clk_regs 0
C2071 clknet_2_0__leaf_clk_regs _304_/a_1270_413# 0
C2072 b[7] input31/a_75_212# 0
C2073 _046_ _300_/a_805_47# 0
C2074 _184_/a_47_47# net35 0
C2075 input30/a_75_212# b[8] 0
C2076 net58 _261_/a_193_47# 0.00121f
C2077 _090_ genblk1\[10\].fa_inst.b 0.21883f
C2078 net39 pmu_inst/dc_inst.x1.net11 0.0095f
C2079 cin_q net75 0.03243f
C2080 net3 _027_ 0.03022f
C2081 _303_/a_543_47# net23 0.00122f
C2082 VPWR pmu_inst/dc_inst.x1.x2/a_27_47# 0.00201f
C2083 _304_/a_448_47# VPWR 0
C2084 _280_/a_1108_47# _295_/a_1283_21# 0
C2085 _280_/a_1283_21# _295_/a_1108_47# 0
C2086 net27 _282_/a_761_289# 0.00971f
C2087 s[15] net45 0.09627f
C2088 a[12] net14 0
C2089 _020_ clknet_2_0__leaf_clk_regs 0.00529f
C2090 genblk1\[7\].fa_inst.s _262_/a_805_47# 0
C2091 _301_/a_651_413# _286_/a_1108_47# 0
C2092 _188_/a_27_413# net33 0
C2093 _148_/a_27_413# _058_ 0
C2094 _045_ clknet_2_2__leaf_clk_regs -0
C2095 _037_ genblk1\[5\].fa_inst.a 0
C2096 s[1] output39/a_27_47# 0
C2097 _130_/a_27_413# net75 0
C2098 input2/a_27_47# net15 0.01573f
C2099 net39 pmu_inst/dc_inst.x5.x1/a_27_47# 0.00296f
C2100 _302_/a_27_47# net35 0
C2101 net47 pmu_inst/_15_/a_788_316# 0
C2102 _286_/a_761_289# clknet_2_2__leaf_clk_regs 0.0179f
C2103 _290_/a_639_47# net11 0.0017f
C2104 _260_/a_761_289# net50 0
C2105 _260_/a_1108_47# _005_ 0.017f
C2106 _160_/a_68_297# _155_/a_68_297# 0
C2107 VPWR pmu_inst/dc_inst.x6.net16 0.01503f
C2108 genblk1\[3\].fa_inst.b VPWR 0.89921f
C2109 _160_/a_68_297# genblk1\[8\].fa_inst.a 0.0012f
C2110 _286_/a_1462_47# _031_ -0
C2111 _016_ VPWR 0.21401f
C2112 net60 _102_ 0
C2113 _051_ _057_ 0
C2114 VPWR pmu_inst/dc_inst.x1.x16/a_27_47# 0.00188f
C2115 clknet_2_1__leaf_clk_regs _261_/a_805_47# 0
C2116 VPWR _287_/a_761_289# 0.02313f
C2117 _289_/a_448_47# net12 0.01404f
C2118 VPWR _023_ 0.19831f
C2119 net29 _281_/a_639_47# 0.00162f
C2120 clknet_2_2__leaf_clk_regs _296_/a_193_47# 0.00368f
C2121 _281_/a_27_47# net31 0
C2122 _292_/a_543_47# clknet_2_0__leaf_clk_regs 0.03576f
C2123 _078_ VPWR 0.23661f
C2124 _099_ VPWR 0.07865f
C2125 _038_ _024_ 0.00209f
C2126 net5 _281_/a_193_47# 0
C2127 VPWR _267_/a_1283_21# 0.02225f
C2128 _100_ _099_ 0.08959f
C2129 _183_/a_215_297# VPWR -0.00435f
C2130 net39 pmu_inst/dc_inst.x2.x3/a_27_47# 0
C2131 VPWR _126_/a_150_297# 0
C2132 VPWR pmu_inst/dc_inst.x1.net18 0.0017f
C2133 clknet_2_1__leaf_clk_regs _295_/a_543_47# 0
C2134 VPWR net3 2.99887f
C2135 delay_sel[0] net36 0.00101f
C2136 _188_/a_215_297# _096_ 0.01317f
C2137 _292_/a_193_47# VPWR 0.01809f
C2138 _296_/a_1217_47# net31 0
C2139 net28 _297_/a_1217_47# 0
C2140 clknet_2_0__leaf_clk_regs _055_ 0
C2141 genblk1\[7\].fa_inst.s net52 0
C2142 clkbuf_2_2__f_clk_regs/a_110_47# _179_/a_47_47# 0.01088f
C2143 clkload1/Y _088_ 0
C2144 _177_/a_113_47# _089_ 0
C2145 net39 pmu_inst/dc_inst.x1.x20/a_27_47# 0
C2146 net46 pmu_inst/_19_/a_465_47# 0
C2147 _276_/a_543_47# _290_/a_1283_21# 0.00129f
C2148 _083_ genblk1\[8\].fa_inst.a 0
C2149 _188_/a_27_413# net35 0.03222f
C2150 _096_ genblk1\[11\].fa_inst.a 0
C2151 _270_/a_27_47# _270_/a_543_47# -0.00454f
C2152 _270_/a_193_47# _270_/a_761_289# -0.0105f
C2153 genblk1\[4\].fa_inst.a _276_/a_1283_21# 0.00185f
C2154 _049_ VPWR -0.02647f
C2155 _280_/a_543_47# _040_ 0
C2156 _025_ _295_/a_543_47# 0
C2157 clknet_2_2__leaf_clk_regs _263_/a_27_47# 0.01916f
C2158 _138_/a_113_47# _060_ 0
C2159 _277_/a_1283_21# clknet_2_0__leaf_clk_regs 0
C2160 _259_/a_448_47# genblk1\[4\].fa_inst.s 0.0056f
C2161 net27 _279_/a_651_413# 0
C2162 _301_/a_543_47# genblk1\[14\].fa_inst.a 0
C2163 _294_/a_1283_21# net17 0.01469f
C2164 net58 _295_/a_1108_47# 0.00168f
C2165 net33 _086_ 0
C2166 VPWR _298_/a_805_47# 0
C2167 clk _263_/a_805_47# 0
C2168 clk _204_/a_225_47# 0
C2169 clkload0/a_361_47# _260_/a_543_47# 0
C2170 net4 net31 0.20967f
C2171 genblk1\[8\].fa_inst.b net30 0
C2172 _281_/a_193_47# clknet_2_2__leaf_clk_regs 0.01753f
C2173 VPWR a[6] 0.2364f
C2174 clknet_2_1__leaf_clk_regs _262_/a_1217_47# 0
C2175 net17 _281_/a_193_47# 0
C2176 _288_/a_193_47# _033_ -0
C2177 _288_/a_761_289# net17 0
C2178 cin_q genblk1\[1\].fa_inst.b 0
C2179 _300_/a_193_47# clknet_2_3__leaf_clk_regs 0
C2180 _300_/a_1283_21# _299_/a_761_289# 0
C2181 _300_/a_1108_47# _299_/a_193_47# 0
C2182 pmu_inst/_06_ cout_next 0.02358f
C2183 genblk1\[8\].fa_inst.b _088_ 0.02706f
C2184 net47 pmu_inst/shadow_q 0.03338f
C2185 _285_/a_1270_413# clknet_2_3__leaf_clk_regs 0
C2186 net46 pmu_inst/dc_inst.x6.x17/a_27_47# 0.00145f
C2187 net46 pmu_inst/dc_inst.x1.net2 0.00409f
C2188 _276_/a_27_47# _291_/a_761_289# 0
C2189 net58 _280_/a_193_47# 0.00627f
C2190 net29 genblk1\[9\].fa_inst.a 0
C2191 VPWR pmu_inst/dc_inst.x6.net14 0.01013f
C2192 _034_ net12 0.00114f
C2193 VPWR net74 0.35941f
C2194 _294_/a_543_47# _280_/a_193_47# 0
C2195 _271_/a_1270_413# cout_next 0
C2196 _273_/a_543_47# genblk1\[1\].fa_inst.a 0.00121f
C2197 net7 net18 0.50762f
C2198 VPWR _205_/a_129_47# -0
C2199 _300_/a_543_47# net60 0.00121f
C2200 _292_/a_651_413# _277_/a_193_47# 0
C2201 _292_/a_1462_47# VPWR 0
C2202 net60 _190_/a_68_297# 0
C2203 net47 pmu_inst/dc_inst.x7.net3 0.0049f
C2204 genblk1\[4\].fa_inst.b _153_/a_215_297# 0
C2205 _169_/a_47_47# VPWR 0.11209f
C2206 _301_/a_27_47# _046_ 0.01076f
C2207 _301_/a_193_47# net21 0.00572f
C2208 _273_/a_1283_21# _272_/a_27_47# 0
C2209 VPWR _261_/a_27_47# 0.0776f
C2210 _275_/a_761_289# _274_/a_543_47# 0.00267f
C2211 _275_/a_543_47# _274_/a_761_289# 0
C2212 _275_/a_193_47# _274_/a_1283_21# 0.00149f
C2213 _275_/a_27_47# _274_/a_1108_47# 0
C2214 _050_ hold1/a_49_47# 0.00427f
C2215 net2 _023_ 0
C2216 _263_/a_1108_47# net53 0.00143f
C2217 _284_/a_27_47# net59 0
C2218 net46 pmu_inst/dc_inst.x1.net15 0.00641f
C2219 genblk1\[2\].fa_inst.s hold1/a_285_47# 0
C2220 _047_ _032_ 0.0018f
C2221 _266_/a_761_289# clknet_2_3__leaf_clk_regs 0
C2222 b[8] net36 0
C2223 net47 pmu_inst/dc_inst.x3.x2/a_27_47# 0.0015f
C2224 _276_/a_27_47# a[8] 0
C2225 net2 net3 0.11678f
C2226 _290_/a_805_47# VPWR 0
C2227 _292_/a_193_47# net2 0.02666f
C2228 _164_/a_47_47# genblk1\[7\].fa_inst.s 0.00112f
C2229 _284_/a_27_47# _298_/a_27_47# 0
C2230 clkload2/X clk 0.0201f
C2231 net39 cout_next 0.03974f
C2232 _258_/a_448_47# net36 0.00364f
C2233 _143_/a_215_297# _057_ 0.04175f
C2234 _046_ _031_ 0.08995f
C2235 net46 net55 0.02461f
C2236 _277_/a_1108_47# clknet_2_1__leaf_clk_regs 0
C2237 net28 net33 0.24168f
C2238 _300_/a_193_47# net19 0.04232f
C2239 _045_ _299_/a_27_47# 0
C2240 _134_/a_47_47# genblk1\[1\].fa_inst.s 0.00112f
C2241 _131_/a_68_297# _288_/a_193_47# 0
C2242 _134_/a_285_47# _056_ 0.0097f
C2243 _134_/a_129_47# _053_ 0.00223f
C2244 genblk1\[3\].fa_inst.s _064_ 0.00407f
C2245 clknet_0_clk_regs clkbuf_0_clk_regs/a_110_47# 0.00187f
C2246 _282_/a_1108_47# net30 0.01174f
C2247 net39 pmu_inst/dc_inst.x7.x8/a_27_47# 0
C2248 net39 pmu_inst/dc_inst.x4.net5 0.00424f
C2249 genblk1\[13\].fa_inst.a _299_/a_1283_21# 0
C2250 _285_/a_1270_413# net19 0
C2251 net25 net7 0.02302f
C2252 net39 pmu_inst/dc_inst.x2.x4/a_27_47# 0.00698f
C2253 genblk1\[0\].fa_inst.s _052_ 0
C2254 _289_/a_1283_21# net56 0.01838f
C2255 net58 _280_/a_1462_47# 0
C2256 fanout56/a_27_47# net58 0.07979f
C2257 genblk1\[4\].fa_inst.a genblk1\[5\].fa_inst.a 0.13062f
C2258 _108_ _112_ 0
C2259 net39 pmu_inst/dc_inst.x1.net8 0.00118f
C2260 genblk1\[12\].fa_inst.s clk 0.03913f
C2261 clkload0/a_361_47# net57 0
C2262 VPWR _197_/a_113_47# -0
C2263 net29 _294_/a_448_47# 0.01539f
C2264 genblk1\[7\].fa_inst.b genblk1\[7\].fa_inst.a 0.24167f
C2265 net39 pmu_inst/dc_inst.x5.net18 0.00177f
C2266 _277_/a_761_289# _291_/a_651_413# 0
C2267 net17 _278_/a_1462_47# 0
C2268 output55/a_27_47# net39 0.00254f
C2269 _301_/a_1217_47# _046_ 0
C2270 _273_/a_27_47# clknet_2_0__leaf_clk_regs 0
C2271 output44/a_27_47# s[14] 0.00968f
C2272 VPWR _175_/a_68_297# 0.03136f
C2273 _269_/a_651_413# _014_ 0.00151f
C2274 _269_/a_1283_21# net44 0.00198f
C2275 _277_/a_193_47# net25 0
C2276 VPWR _295_/a_1283_21# 0.08829f
C2277 _270_/a_1108_47# net45 0
C2278 _270_/a_1270_413# _015_ -0
C2279 _185_/a_68_297# _097_ 0.00112f
C2280 _303_/a_1283_21# genblk1\[15\].fa_inst.b 0.00291f
C2281 _199_/a_47_47# _205_/a_47_47# 0
C2282 net14 a[8] 0
C2283 _128_/a_113_47# net56 0
C2284 _003_ net36 0.01559f
C2285 input12/a_75_212# a[5] 0.01461f
C2286 _130_/a_382_47# VPWR 0
C2287 VPWR pmu_inst/dc_inst.x7.net5 0.00323f
C2288 clkbuf_2_3__f_clk_regs/a_110_47# clknet_0_clk_regs 0.02719f
C2289 _285_/a_448_47# net18 0.00654f
C2290 _275_/a_1108_47# _288_/a_27_47# 0
C2291 _275_/a_1283_21# _288_/a_193_47# 0
C2292 _276_/a_1283_21# VPWR 0.03981f
C2293 net4 _297_/a_193_47# 0.02721f
C2294 genblk1\[12\].fa_inst.a _299_/a_1283_21# 0.00136f
C2295 clknet_2_1__leaf_clk_regs _279_/a_1108_47# 0
C2296 VPWR _280_/a_27_47# 0.06012f
C2297 _028_ net30 0.03415f
C2298 output44/a_27_47# net44 0.12466f
C2299 _300_/a_1462_47# net19 0
C2300 VPWR pmu_inst/dc_inst.net6 0.01938f
C2301 VPWR _143_/a_27_413# 0.06516f
C2302 _294_/a_193_47# genblk1\[6\].fa_inst.b 0
C2303 _259_/a_193_47# _258_/a_448_47# 0
C2304 clknet_2_0__leaf_clk_regs clknet_0_clk_regs 0.00308f
C2305 clk _265_/a_448_47# 0.01203f
C2306 net61 _266_/a_1270_413# 0
C2307 VPWR pmu_inst/dc_inst.x3.net1 0
C2308 _276_/a_193_47# net17 0
C2309 _022_ net13 0
C2310 input4/a_27_47# net15 0.01573f
C2311 _148_/a_27_413# _061_ 0.04524f
C2312 net6 net18 0.01786f
C2313 net29 clknet_2_3__leaf_clk_regs 0
C2314 clknet_2_0__leaf_clk_regs _071_ 0
C2315 clknet_2_1__leaf_clk_regs net62 0.02123f
C2316 _284_/a_761_289# net35 0.01843f
C2317 _277_/a_27_47# net16 0.03559f
C2318 _189_/a_285_47# genblk1\[12\].fa_inst.s 0.00392f
C2319 genblk1\[3\].fa_inst.b _140_/a_68_297# 0.03449f
C2320 _275_/a_651_413# genblk1\[2\].fa_inst.a 0
C2321 _290_/a_1108_47# _289_/a_27_47# 0
C2322 _290_/a_27_47# _289_/a_1108_47# 0
C2323 net29 net32 0.0317f
C2324 _304_/a_543_47# genblk1\[1\].fa_inst.b 0.01087f
C2325 _137_/a_113_47# _058_ 0
C2326 genblk1\[4\].fa_inst.a _276_/a_543_47# 0
C2327 net3 _296_/a_27_47# 0.02079f
C2328 output45/a_27_47# cout 0
C2329 _273_/a_639_47# VPWR 0
C2330 _277_/a_651_413# _292_/a_193_47# 0
C2331 VPWR s[5] 0.40342f
C2332 _283_/a_27_47# genblk1\[11\].fa_inst.a 0
C2333 net33 _045_ 0.00202f
C2334 _272_/a_193_47# _272_/a_448_47# -0.00482f
C2335 _282_/a_193_47# _027_ 0.00143f
C2336 _284_/a_1108_47# _043_ 0
C2337 _284_/a_448_47# net18 0.01182f
C2338 net49 output49/a_27_47# 0.01331f
C2339 VPWR _269_/a_1283_21# 0.03303f
C2340 _304_/a_448_47# _288_/a_193_47# 0
C2341 _276_/a_27_47# _290_/a_543_47# 0.001f
C2342 _025_ net62 0.00971f
C2343 clkload2/X _265_/a_27_47# 0
C2344 _268_/a_1108_47# genblk1\[13\].fa_inst.s 0
C2345 _289_/a_448_47# a[6] 0
C2346 _164_/a_129_47# VPWR -0
C2347 _282_/a_1283_21# genblk1\[9\].fa_inst.b 0
C2348 net28 _295_/a_543_47# 0
C2349 _200_/a_145_75# VPWR -0
C2350 _301_/a_761_289# clknet_2_3__leaf_clk_regs 0
C2351 _030_ net18 0.00831f
C2352 _273_/a_1108_47# net8 0.00104f
C2353 _275_/a_27_47# net17 0
C2354 VPWR pmu_inst/dc_inst.x6.net13 0.00339f
C2355 VPWR _144_/a_285_47# -0
C2356 _163_/a_298_297# _080_ 0.00465f
C2357 net33 _296_/a_193_47# 0
C2358 _129_/a_285_47# _051_ 0
C2359 VPWR _134_/a_129_47# -0
C2360 VPWR _280_/a_1217_47# 0
C2361 _303_/a_27_47# clknet_2_3__leaf_clk_regs 0.38206f
C2362 _291_/a_193_47# net16 0
C2363 net62 _279_/a_193_47# 0.00177f
C2364 clknet_2_1__leaf_clk_regs net7 0.02275f
C2365 net33 _140_/a_150_297# 0
C2366 _301_/a_1283_21# net60 0.01643f
C2367 net46 pmu_inst/dc_inst.x2.net10 0
C2368 VPWR pmu_inst/dc_inst.x7.x9/a_27_47# 0.00257f
C2369 _259_/a_193_47# _003_ 0
C2370 net29 genblk1\[6\].fa_inst.b 0
C2371 net25 net6 0.0163f
C2372 clk _010_ 0.00481f
C2373 output44/a_27_47# VPWR 0.0417f
C2374 VPWR _283_/a_761_289# 0.01401f
C2375 _303_/a_761_289# net60 0
C2376 VPWR _282_/a_193_47# 0.02449f
C2377 _185_/a_150_297# VPWR 0
C2378 VPWR pmu_inst/dc_inst.x6.net12 0.004f
C2379 net2 _280_/a_27_47# 0.02216f
C2380 net3 _281_/a_27_47# 0.02006f
C2381 _257_/a_27_47# net57 0.04013f
C2382 genblk1\[7\].fa_inst.s _262_/a_1283_21# 0
C2383 _256_/a_1108_47# genblk1\[1\].fa_inst.s 0
C2384 genblk1\[5\].fa_inst.a VPWR 0.83656f
C2385 net26 net5 0.03724f
C2386 _270_/a_448_47# clknet_2_3__leaf_clk_regs 0.01405f
C2387 net7 _025_ 0.02638f
C2388 net25 _289_/a_27_47# 0
C2389 _290_/a_27_47# net24 0.01884f
C2390 net27 _294_/a_193_47# 0.02571f
C2391 VPWR pmu_inst/dc_inst.x5.net17 0
C2392 net24 input24/a_27_47# 0.00213f
C2393 genblk1\[1\].fa_inst.a VPWR 1.08659f
C2394 _277_/a_193_47# clknet_2_1__leaf_clk_regs 0.00291f
C2395 output53/a_27_47# net54 0
C2396 _023_ _278_/a_27_47# 0.00224f
C2397 _272_/a_193_47# _017_ -0.00156f
C2398 _272_/a_543_47# clknet_2_0__leaf_clk_regs 0.0321f
C2399 _277_/a_27_47# _291_/a_193_47# 0
C2400 _279_/a_27_47# _024_ 0.00105f
C2401 _282_/a_639_47# genblk1\[10\].fa_inst.a 0
C2402 _029_ net18 0
C2403 net3 _278_/a_27_47# 0.0234f
C2404 net7 _282_/a_651_413# 0.00452f
C2405 net24 net13 0.02421f
C2406 _272_/a_761_289# net1 0.00189f
C2407 _272_/a_193_47# VPWR -0.27732f
C2408 _290_/a_543_47# net14 0
C2409 net52 _262_/a_193_47# 0
C2410 clk fanout59/a_27_47# 0
C2411 hold1/a_49_47# _135_/a_215_297# 0
C2412 _302_/a_27_47# net7 0.02806f
C2413 _301_/a_761_289# net19 0
C2414 b[7] b[6] 0.10601f
C2415 net54 net35 0.02399f
C2416 net4 _023_ 0.00611f
C2417 _054_ net56 0.05837f
C2418 cin_q _304_/a_1283_21# 0.00295f
C2419 net58 _262_/a_27_47# 0
C2420 _303_/a_1217_47# clknet_2_3__leaf_clk_regs 0
C2421 net39 pmu_inst/dc_inst.x2.net13 0.01474f
C2422 net62 _279_/a_1462_47# 0
C2423 genblk1\[7\].fa_inst.s _262_/a_448_47# 0.00652f
C2424 net3 net4 0.29994f
C2425 _303_/a_1283_21# _287_/a_761_289# 0
C2426 _303_/a_27_47# _287_/a_448_47# 0
C2427 _270_/a_193_47# net61 0.00815f
C2428 _303_/a_1108_47# _287_/a_193_47# 0
C2429 net26 clknet_2_2__leaf_clk_regs 0.61807f
C2430 _286_/a_543_47# net36 0.00833f
C2431 net26 net17 0.02687f
C2432 hold1/a_391_47# _056_ 0
C2433 hold1/a_285_47# _053_ 0.00162f
C2434 _193_/a_215_297# _104_ 0.01888f
C2435 _291_/a_27_47# _291_/a_761_289# -0
C2436 _277_/a_761_289# net36 0
C2437 _293_/a_27_47# net58 0
C2438 VPWR _279_/a_448_47# 0
C2439 VPWR _282_/a_1462_47# 0
C2440 _265_/a_27_47# _265_/a_448_47# -0.00373f
C2441 _188_/a_382_47# genblk1\[11\].fa_inst.a 0
C2442 net39 pmu_inst/dc_inst.x4.x7/a_27_47# 0.00737f
C2443 _257_/a_1217_47# net57 0
C2444 _110_ _201_/a_479_47# 0
C2445 _302_/a_1108_47# VPWR 0.02841f
C2446 clk _267_/a_805_47# 0
C2447 clknet_2_2__leaf_clk_regs _178_/a_215_297# 0.00482f
C2448 net28 _283_/a_193_47# 0
C2449 _015_ clknet_2_3__leaf_clk_regs 0.17015f
C2450 _051_ _288_/a_27_47# 0
C2451 net28 _282_/a_27_47# 0
C2452 _258_/a_193_47# clknet_2_0__leaf_clk_regs 0.01018f
C2453 net27 net14 0
C2454 net53 net59 0.10505f
C2455 _284_/a_27_47# net30 0
C2456 genblk1\[15\].fa_inst.a genblk1\[14\].fa_inst.b 0
C2457 _090_ genblk1\[9\].fa_inst.b 0
C2458 _058_ _057_ 0.18983f
C2459 net27 _296_/a_651_413# 0.00453f
C2460 net2 _282_/a_193_47# 0.05722f
C2461 net48 genblk1\[3\].fa_inst.s 0.00148f
C2462 _023_ _278_/a_1217_47# -0
C2463 net27 net29 0.01917f
C2464 _106_ _110_ 0
C2465 _272_/a_639_47# genblk1\[0\].fa_inst.a 0
C2466 _272_/a_1462_47# _017_ -0
C2467 _279_/a_1217_47# _024_ 0
C2468 _272_/a_1462_47# VPWR 0
C2469 _276_/a_543_47# VPWR 0.01228f
C2470 hold1/a_391_47# _057_ 0
C2471 clknet_2_2__leaf_clk_regs _298_/a_448_47# 0
C2472 clknet_0_clk_regs _266_/a_1283_21# 0.01534f
C2473 _031_ net18 0
C2474 input1/a_75_212# VPWR 0.06704f
C2475 _046_ _287_/a_761_289# 0
C2476 net46 pmu_inst/_15_/a_27_47# 0
C2477 _277_/a_805_47# net16 0
C2478 _067_ _147_/a_113_47# 0
C2479 _164_/a_47_47# _262_/a_193_47# 0
C2480 _048_ _287_/a_27_47# 0
C2481 _270_/a_1462_47# net61 0
C2482 net58 _262_/a_543_47# 0
C2483 genblk1\[12\].fa_inst.b _300_/a_761_289# 0
C2484 net18 net31 0.618f
C2485 clknet_2_1__leaf_clk_regs net6 0
C2486 _269_/a_1283_21# genblk1\[14\].fa_inst.s 0
C2487 _094_ _180_/a_68_297# 0.03203f
C2488 _294_/a_448_47# _294_/a_27_47# -0.00501f
C2489 _294_/a_193_47# _280_/a_1283_21# 0
C2490 input1/a_75_212# input8/a_75_212# 0
C2491 _274_/a_543_47# _273_/a_651_413# 0
C2492 _274_/a_1108_47# _273_/a_1108_47# 0
C2493 _293_/a_651_413# net17 0.00166f
C2494 _054_ _055_ 0.99417f
C2495 input15/a_75_212# net15 0.00325f
C2496 _255_/a_543_47# _000_ 0
C2497 _255_/a_27_47# net39 0
C2498 _255_/a_1283_21# genblk1\[0\].fa_inst.s 0.00112f
C2499 VPWR _024_ 0.04392f
C2500 genblk1\[8\].fa_inst.s _263_/a_193_47# 0.01558f
C2501 _265_/a_761_289# clknet_2_3__leaf_clk_regs 0
C2502 _265_/a_27_47# _010_ 0
C2503 _271_/a_193_47# _271_/a_448_47# -0.00482f
C2504 net34 _111_ 0
C2505 a[13] net36 0
C2506 _050_ _033_ 0
C2507 _256_/a_651_413# VPWR 0.00127f
C2508 net27 _281_/a_651_413# 0
C2509 net22 VPWR 0.50781f
C2510 _022_ fanout56/a_27_47# 0.00401f
C2511 _292_/a_1270_413# net17 0
C2512 genblk1\[9\].fa_inst.a _085_ 0.16986f
C2513 _303_/a_1270_413# net34 0
C2514 clknet_2_1__leaf_clk_regs _289_/a_27_47# 0.05031f
C2515 _051_ _288_/a_1217_47# 0
C2516 _291_/a_761_289# net56 0.00281f
C2517 _094_ genblk1\[11\].fa_inst.b 0.1069f
C2518 _052_ _134_/a_47_47# 0
C2519 _129_/a_47_47# _056_ 0
C2520 _258_/a_1462_47# clknet_2_0__leaf_clk_regs 0
C2521 genblk1\[12\].fa_inst.s _267_/a_1283_21# 0
C2522 genblk1\[12\].fa_inst.s _099_ 0.00133f
C2523 _184_/a_47_47# _266_/a_27_47# 0
C2524 net33 _170_/a_150_297# 0
C2525 _106_ _105_ 0.59466f
C2526 _198_/a_27_413# _102_ 0.0465f
C2527 net2 _279_/a_448_47# 0.01244f
C2528 _297_/a_543_47# net32 0
C2529 _297_/a_761_289# _042_ -0.0067f
C2530 _281_/a_1283_21# _295_/a_27_47# 0
C2531 _281_/a_761_289# _295_/a_761_289# 0
C2532 _281_/a_193_47# _295_/a_543_47# 0
C2533 _281_/a_543_47# _295_/a_193_47# 0
C2534 b[3] b[4] 0.07915f
C2535 s[14] s[15] 0
C2536 _270_/a_543_47# genblk1\[15\].fa_inst.s 0.00284f
C2537 net71 pmu_inst/dc_inst.x5.net17 0
C2538 clknet_0_clk_regs _009_ 0
C2539 _198_/a_298_297# _108_ 0.00226f
C2540 net36 b[11] 0
C2541 net27 _278_/a_651_413# 0
C2542 _014_ cout_next 0
C2543 net28 net62 0.02616f
C2544 _256_/a_761_289# _001_ 0.01435f
C2545 VPWR pmu_inst/dc_inst.x3.net16 0
C2546 net24 _280_/a_193_47# 0
C2547 clknet_2_2__leaf_clk_regs _043_ -0
C2548 _276_/a_639_47# VPWR 0
C2549 clkbuf_2_0__f_clk_regs/a_110_47# _260_/a_1283_21# 0
C2550 clknet_0_clk_regs _260_/a_193_47# 0
C2551 _303_/a_448_47# net36 0.01154f
C2552 _292_/a_761_289# _277_/a_543_47# 0
C2553 genblk1\[15\].fa_inst.a _111_ 0.1112f
C2554 genblk1\[11\].fa_inst.b _299_/a_448_47# 0
C2555 clknet_2_1__leaf_clk_regs net10 0.13589f
C2556 b[13] clknet_2_3__leaf_clk_regs 0
C2557 net39 net70 0.04722f
C2558 net59 _297_/a_448_47# 0
C2559 _004_ net36 0.00475f
C2560 net39 pmu_inst/dc_inst.x1.net16 0
C2561 _289_/a_27_47# net11 0.03086f
C2562 VPWR hold1/a_285_47# 0.03207f
C2563 genblk1\[5\].fa_inst.a _069_ 0.25474f
C2564 genblk1\[15\].fa_inst.s _111_ 0
C2565 _187_/a_113_47# genblk1\[11\].fa_inst.b 0
C2566 net47 pmu_inst/dc_inst.x7.x15/a_27_47# 0.00218f
C2567 VPWR _262_/a_1108_47# 0.00653f
C2568 _274_/a_448_47# clknet_2_1__leaf_clk_regs 0.00339f
C2569 _019_ _273_/a_1283_21# 0
C2570 _274_/a_1283_21# _018_ 0.00626f
C2571 _274_/a_193_47# genblk1\[1\].fa_inst.a 0.00124f
C2572 pmu_inst/dc_inst.x7.net14 net34 0
C2573 _294_/a_193_47# net58 0.02701f
C2574 genblk1\[12\].fa_inst.b genblk1\[13\].fa_inst.a 0.12785f
C2575 _291_/a_1283_21# genblk1\[3\].fa_inst.b 0.00211f
C2576 VPWR input2/a_27_47# 0.0923f
C2577 clknet_2_3__leaf_clk_regs _299_/a_543_47# 0
C2578 _258_/a_1108_47# net48 0.00491f
C2579 _258_/a_1270_413# _003_ 0
C2580 _271_/a_193_47# _016_ 0.01396f
C2581 _097_ _101_ 0
C2582 genblk1\[4\].fa_inst.b _145_/a_68_297# 0.05136f
C2583 _263_/a_1462_47# net52 0
C2584 delay_sel[1] delay_sel[2] 0.43161f
C2585 _285_/a_761_289# net7 0.01221f
C2586 net46 pmu_inst/dc_inst.x1.net11 0.01716f
C2587 genblk1\[8\].fa_inst.b _296_/a_651_413# 0
C2588 _299_/a_543_47# net32 0
C2589 net24 net30 0
C2590 net29 genblk1\[8\].fa_inst.b 0
C2591 genblk1\[1\].fa_inst.b genblk1\[2\].fa_inst.b 0
C2592 _083_ clknet_2_2__leaf_clk_regs 0
C2593 VPWR pmu_inst/dc_inst.x6.net10 0
C2594 _304_/a_193_47# _304_/a_448_47# -0.00297f
C2595 _168_/a_298_297# _077_ 0.00776f
C2596 net60 clknet_2_3__leaf_clk_regs 0.08437f
C2597 _044_ _299_/a_543_47# 0.00661f
C2598 net60 _299_/a_1108_47# 0.01592f
C2599 genblk1\[11\].fa_inst.s _266_/a_761_289# 0
C2600 net28 net7 0.02161f
C2601 _293_/a_1462_47# genblk1\[6\].fa_inst.a 0
C2602 _282_/a_27_47# _296_/a_193_47# 0.00112f
C2603 _282_/a_193_47# _296_/a_27_47# 0
C2604 _293_/a_639_47# clknet_2_1__leaf_clk_regs 0.00432f
C2605 net2 _024_ 0
C2606 _179_/a_47_47# _092_ 0.02797f
C2607 _268_/a_448_47# clknet_2_3__leaf_clk_regs 0.0072f
C2608 net25 a[9] 0
C2609 VPWR pmu_inst/dc_inst.x2.x17/a_27_47# 0.00232f
C2610 clknet_2_2__leaf_clk_regs _295_/a_27_47# 0
C2611 net3 _297_/a_651_413# 0.00753f
C2612 net60 net32 0
C2613 clknet_2_3__leaf_clk_regs genblk1\[10\].fa_inst.b 0
C2614 net10 net11 0.00224f
C2615 net17 _295_/a_27_47# 0
C2616 _035_ net17 0
C2617 net4 _280_/a_27_47# 0.03085f
C2618 net60 _044_ 0.22408f
C2619 _275_/a_1108_47# genblk1\[3\].fa_inst.a 0
C2620 _256_/a_805_47# net46 0
C2621 _291_/a_543_47# _290_/a_27_47# 0
C2622 _300_/a_27_47# VPWR 0.06619f
C2623 b[14] clknet_2_3__leaf_clk_regs 0
C2624 clknet_0_clk_regs _260_/a_1462_47# 0
C2625 a[14] a[15] 0.07915f
C2626 _048_ net36 0
C2627 clkbuf_2_3__f_clk_regs/a_110_47# _266_/a_543_47# 0.01157f
C2628 net47 pmu_inst/_24_/a_761_289# 0.00405f
C2629 VPWR _285_/a_651_413# 0.00117f
C2630 _099_ _093_ 0
C2631 net39 pmu_inst/dc_inst.x1.net13 0
C2632 _143_/a_27_413# _060_ 0
C2633 _183_/a_215_297# _093_ 0
C2634 genblk1\[7\].fa_inst.b genblk1\[9\].fa_inst.a 0
C2635 _021_ _291_/a_651_413# 0
C2636 _294_/a_27_47# genblk1\[6\].fa_inst.b 0
C2637 net39 pmu_inst/dc_inst.x6.x5/a_27_47# 0
C2638 genblk1\[4\].fa_inst.a _276_/a_448_47# 0
C2639 net59 _042_ 0.28056f
C2640 genblk1\[12\].fa_inst.b genblk1\[12\].fa_inst.a 0.2238f
C2641 net15 input16/a_75_212# 0.01453f
C2642 _304_/a_805_47# net56 0
C2643 _289_/a_1217_47# net11 0
C2644 net25 net12 0.01095f
C2645 net58 _007_ 0.03356f
C2646 _298_/a_193_47# net32 0.00711f
C2647 genblk1\[2\].fa_inst.a _273_/a_1462_47# 0
C2648 _019_ clknet_2_1__leaf_clk_regs 0
C2649 _274_/a_1462_47# genblk1\[1\].fa_inst.a 0
C2650 net61 _268_/a_193_47# 0.00274f
C2651 _108_ _104_ 0.02534f
C2652 net7 _284_/a_761_289# 0.00753f
C2653 VPWR _264_/a_543_47# 0.01199f
C2654 _300_/a_448_47# net7 0.01382f
C2655 _299_/a_543_47# net19 0.00106f
C2656 net46 pmu_inst/dc_inst.x1.x20/a_27_47# 0
C2657 _063_ _061_ 0.01468f
C2658 net29 net58 0
C2659 _168_/a_215_297# _173_/a_298_297# 0
C2660 output54/a_27_47# VPWR 0.07863f
C2661 _271_/a_639_47# net38 0
C2662 net23 input36/a_27_47# 0
C2663 s[15] VPWR 0.41054f
C2664 net39 pmu_inst/dc_inst.x4.x20/a_27_47# 0.00984f
C2665 net29 _294_/a_543_47# 0.00359f
C2666 genblk1\[10\].fa_inst.b _298_/a_543_47# 0
C2667 cin delay_sel[2] 0.01234f
C2668 VPWR _266_/a_193_47# 0.01092f
C2669 genblk1\[7\].fa_inst.b genblk1\[6\].fa_inst.a 0
C2670 VPWR pmu_inst/dc_inst.x4.x5/a_27_47# 0
C2671 _302_/a_193_47# _286_/a_1108_47# 0
C2672 _267_/a_448_47# clknet_2_3__leaf_clk_regs 0.01563f
C2673 net5 b[3] 0
C2674 genblk1\[12\].fa_inst.b _103_ 0
C2675 _304_/a_761_289# net33 0
C2676 _304_/a_193_47# _049_ -0.00188f
C2677 _259_/a_1283_21# genblk1\[4\].fa_inst.s 0
C2678 _292_/a_27_47# net26 0.02277f
C2679 net29 _283_/a_448_47# 0.01251f
C2680 _096_ _091_ 0.09685f
C2681 net60 net19 0.07872f
C2682 input2/a_27_47# net2 0.00199f
C2683 _004_ _259_/a_193_47# 0
C2684 _287_/a_448_47# net60 0
C2685 cout_next net66 0.07348f
C2686 net13 net15 1.93723f
C2687 net59 _298_/a_1283_21# 0.02987f
C2688 _013_ clknet_2_3__leaf_clk_regs 0.02485f
C2689 genblk1\[1\].fa_inst.a _288_/a_193_47# 0
C2690 _072_ _150_/a_150_297# 0
C2691 _264_/a_1108_47# genblk1\[9\].fa_inst.s 0
C2692 net27 _297_/a_543_47# 0
C2693 net33 _148_/a_382_47# 0
C2694 _067_ _068_ 0.08695f
C2695 input3/a_27_47# net3 0.00198f
C2696 clknet_2_1__leaf_clk_regs clk 0
C2697 _302_/a_193_47# genblk1\[14\].fa_inst.b 0
C2698 VPWR _289_/a_193_47# 0.03181f
C2699 _074_ genblk1\[7\].fa_inst.a 0
C2700 VPWR _284_/a_651_413# -0.00856f
C2701 genblk1\[9\].fa_inst.a _173_/a_27_413# 0
C2702 _272_/a_27_47# _288_/a_761_289# 0
C2703 _272_/a_193_47# _288_/a_193_47# 0
C2704 _257_/a_193_47# genblk1\[2\].fa_inst.s 0.08049f
C2705 _257_/a_27_47# _002_ 0.00834f
C2706 _300_/a_1217_47# VPWR 0
C2707 genblk1\[13\].fa_inst.a _198_/a_215_297# 0
C2708 _300_/a_27_47# _285_/a_193_47# 0.00117f
C2709 _300_/a_193_47# _285_/a_27_47# 0
C2710 _019_ net11 0
C2711 net47 pmu_inst/_25_/a_543_47# 0.00661f
C2712 _293_/a_1270_413# net33 0
C2713 VPWR pmu_inst/dc_inst.x1.x8/a_27_47# 0.0064f
C2714 net33 _299_/a_1270_413# 0
C2715 net47 pmu_inst/dc_inst.x8/a_923_363# 0
C2716 pmu_inst/dc_inst.x3.net17 cout_next 0
C2717 _039_ _279_/a_1283_21# 0
C2718 _268_/a_1108_47# net43 0
C2719 _268_/a_1270_413# _013_ -0
C2720 _096_ _095_ 0.08801f
C2721 _281_/a_1108_47# _025_ 0
C2722 net4 _282_/a_193_47# 0.02256f
C2723 _299_/a_193_47# net18 0
C2724 net54 net62 0.05627f
C2725 clknet_2_1__leaf_clk_regs _278_/a_1108_47# 0.04661f
C2726 net61 _267_/a_193_47# 0.00208f
C2727 _290_/a_543_47# net56 0
C2728 clknet_2_2__leaf_clk_regs b[3] 0
C2729 _302_/a_27_47# _301_/a_27_47# 0
C2730 net39 pmu_inst/dc_inst.x6.net8 0.00989f
C2731 _291_/a_448_47# net36 0.0027f
C2732 _294_/a_1283_21# _279_/a_1108_47# 0
C2733 cin_q _134_/a_47_47# 0.00279f
C2734 net33 _178_/a_215_297# 0
C2735 net61 _268_/a_1462_47# 0
C2736 genblk1\[12\].fa_inst.b genblk1\[14\].fa_inst.a 0
C2737 _130_/a_215_297# _056_ 0.01678f
C2738 net22 net20 0.00188f
C2739 _045_ net7 0
C2740 VPWR pmu_inst/dc_inst.x7.net7 0.0104f
C2741 VPWR pmu_inst/dc_inst.x5.net19 0.02752f
C2742 _168_/a_27_413# _079_ 0.00111f
C2743 clknet_2_0__leaf_clk_regs _260_/a_27_47# 0.03269f
C2744 _262_/a_193_47# _262_/a_448_47# -0.00534f
C2745 _130_/a_27_413# _134_/a_47_47# 0
C2746 net27 _294_/a_27_47# 0.02057f
C2747 net22 _286_/a_193_47# 0
C2748 _302_/a_27_47# _031_ 0
C2749 _012_ clknet_2_3__leaf_clk_regs 0
C2750 s[0] VPWR 0.38073f
C2751 net46 cout_next 0.03793f
C2752 _263_/a_27_47# net62 0
C2753 _274_/a_651_413# VPWR 0.00156f
C2754 _294_/a_1283_21# net62 0.00922f
C2755 net29 _028_ 0
C2756 clknet_2_1__leaf_clk_regs a[9] 0
C2757 _294_/a_1462_47# net17 0
C2758 _282_/a_651_413# net31 0
C2759 _032_ net60 0.26845f
C2760 net28 net6 0.0162f
C2761 net39 pmu_inst/dc_inst.x5.x8/a_27_47# 0.00169f
C2762 net7 _296_/a_193_47# 0.03754f
C2763 genblk1\[13\].fa_inst.a _102_ 0.01117f
C2764 _183_/a_298_297# _092_ 0.00557f
C2765 _302_/a_1462_47# genblk1\[14\].fa_inst.b 0
C2766 VPWR _289_/a_1462_47# 0
C2767 _149_/a_377_297# net36 0
C2768 _292_/a_651_413# net3 0
C2769 _279_/a_448_47# _278_/a_27_47# 0
C2770 _279_/a_1108_47# _278_/a_193_47# 0
C2771 _293_/a_27_47# genblk1\[5\].fa_inst.b 0
C2772 _279_/a_27_47# _278_/a_448_47# 0
C2773 _279_/a_543_47# _278_/a_543_47# 0.00202f
C2774 _279_/a_193_47# _278_/a_1108_47# 0
C2775 VPWR net23 0.02581f
C2776 _274_/a_543_47# net8 0.00244f
C2777 net46 pmu_inst/dc_inst.x7.x8/a_27_47# 0.00131f
C2778 genblk1\[4\].fa_inst.s net58 0.11369f
C2779 net58 _008_ 0
C2780 net39 pmu_inst/dc_inst.x6.x6/a_27_47# 0.00253f
C2781 net46 pmu_inst/dc_inst.x4.net5 0.01988f
C2782 _258_/a_27_47# net36 0.01659f
C2783 net46 pmu_inst/dc_inst.x2.x4/a_27_47# 0
C2784 _130_/a_215_297# _057_ 0.00116f
C2785 _293_/a_651_413# net33 0.00327f
C2786 VPWR _286_/a_651_413# 0
C2787 net46 pmu_inst/dc_inst.x1.net8 0.01487f
C2788 net47 pmu_inst/dc_inst.x9/a_1478_413# 0.00198f
C2789 net4 _279_/a_448_47# 0.01076f
C2790 VPWR _201_/a_479_47# -0
C2791 pmu_inst/dc_inst.x3.net11 cout_next 0
C2792 VPWR a[7] 0.23679f
C2793 clknet_2_1__leaf_clk_regs net12 0.39444f
C2794 _270_/a_27_47# net62 0
C2795 net61 _267_/a_1462_47# 0
C2796 _291_/a_1283_21# _276_/a_1283_21# 0.00192f
C2797 net62 _278_/a_193_47# 0
C2798 net46 pmu_inst/dc_inst.x5.net18 0.01101f
C2799 _036_ net36 0.00833f
C2800 VPWR _296_/a_448_47# 0.00193f
C2801 _198_/a_215_297# _103_ 0.00148f
C2802 _292_/a_1108_47# _277_/a_1283_21# 0
C2803 genblk1\[5\].fa_inst.a _070_ 0.00238f
C2804 _083_ _167_/a_113_47# 0
C2805 VPWR _106_ 0.13369f
C2806 _276_/a_448_47# VPWR 0.00188f
C2807 _164_/a_377_297# _080_ 0
C2808 net33 net34 0.06772f
C2809 net39 pmu_inst/dc_inst.x2.net14 0.00809f
C2810 _287_/a_193_47# genblk1\[15\].fa_inst.a 0
C2811 _287_/a_1283_21# _032_ 0.00785f
C2812 _302_/a_193_47# clknet_2_2__leaf_clk_regs 0.16213f
C2813 net39 pmu_inst/dc_inst.x5.net12 0.0172f
C2814 genblk1\[2\].fa_inst.a clknet_2_0__leaf_clk_regs 0.04513f
C2815 net7 _281_/a_193_47# 0.02638f
C2816 _290_/a_27_47# _290_/a_1283_21# -0
C2817 _027_ _041_ 0
C2818 clknet_0_clk_regs _265_/a_1283_21# 0.01746f
C2819 _275_/a_651_413# _273_/a_193_47# 0
C2820 _275_/a_1283_21# _273_/a_1283_21# 0
C2821 net33 _043_ 0
C2822 _267_/a_1108_47# net42 0.00182f
C2823 VPWR input4/a_27_47# 0.0923f
C2824 _280_/a_193_47# net15 0.0156f
C2825 _284_/a_193_47# _284_/a_651_413# -0.00701f
C2826 VPWR pmu_inst/dc_inst.x2.net16 0.00245f
C2827 net11 net12 0.2983f
C2828 _301_/a_193_47# VPWR 0.02215f
C2829 genblk1\[5\].fa_inst.a _066_ 0
C2830 VPWR _263_/a_1108_47# 0.01557f
C2831 output54/a_27_47# s[9] 0.00932f
C2832 _300_/a_27_47# net20 0.0407f
C2833 _294_/a_1108_47# VPWR 0.04629f
C2834 _292_/a_543_47# net27 0.04161f
C2835 _292_/a_761_289# _037_ -0.00655f
C2836 net33 _160_/a_68_297# 0.00645f
C2837 _051_ genblk1\[0\].fa_inst.b 0.08335f
C2838 net20 _285_/a_651_413# 0
C2839 _300_/a_448_47# _030_ 0
C2840 _300_/a_27_47# _286_/a_193_47# 0.00174f
C2841 net5 b[8] 0
C2842 _021_ net36 0.05206f
C2843 VPWR _281_/a_448_47# 0
C2844 VPWR _288_/a_651_413# 0
C2845 VPWR pmu_inst/dc_inst.net5 0.01715f
C2846 net33 genblk1\[15\].fa_inst.a 0.06419f
C2847 _285_/a_805_47# genblk1\[13\].fa_inst.a 0
C2848 _273_/a_761_289# net56 0
C2849 net47 pmu_inst/dc_inst.net7 0.00519f
C2850 net4 _024_ 0.00348f
C2851 genblk1\[6\].fa_inst.b genblk1\[7\].fa_inst.b 0.00206f
C2852 _103_ _102_ 0.04503f
C2853 genblk1\[13\].fa_inst.a _190_/a_68_297# 0.06298f
C2854 net25 net3 0.02256f
C2855 _259_/a_761_289# net36 0.00227f
C2856 _294_/a_27_47# _280_/a_1283_21# 0
C2857 net39 pmu_inst/dc_inst.x2.x8/a_27_47# 0.00236f
C2858 _292_/a_193_47# net25 0
C2859 _293_/a_639_47# net28 0
C2860 net34 net35 8.01849f
C2861 _047_ _301_/a_1108_47# 0
C2862 _302_/a_1108_47# _046_ 0.00307f
C2863 _302_/a_448_47# net21 0.00903f
C2864 _301_/a_651_413# net7 0.00369f
C2865 net39 pmu_inst/dc_inst.x5.x10/a_27_47# 0.00219f
C2866 VPWR _041_ 0.06356f
C2867 _108_ genblk1\[13\].fa_inst.s 0
C2868 genblk1\[11\].fa_inst.a clknet_2_2__leaf_clk_regs 0
C2869 _269_/a_193_47# _268_/a_761_289# 0
C2870 _269_/a_543_47# _268_/a_27_47# 0
C2871 _269_/a_761_289# _268_/a_193_47# 0
C2872 net15 net30 0
C2873 _270_/a_1108_47# VPWR 0.01115f
C2874 _303_/a_1108_47# net7 0
C2875 VPWR _278_/a_448_47# 0
C2876 net28 _296_/a_1108_47# 0.00368f
C2877 _287_/a_1462_47# genblk1\[15\].fa_inst.a 0
C2878 _199_/a_47_47# _201_/a_61_47# 0
C2879 VPWR net50 10.45384f
C2880 net33 _295_/a_27_47# 0
C2881 _168_/a_27_413# VPWR 0.0549f
C2882 genblk1\[9\].fa_inst.a genblk1\[9\].fa_inst.b 0.26335f
C2883 net35 _043_ 0
C2884 net2 _296_/a_448_47# 0
C2885 _286_/a_761_289# net6 0
C2886 clknet_0_clk_regs clknet_2_3__leaf_clk_regs 0.00643f
C2887 b[8] clknet_2_2__leaf_clk_regs 0
C2888 _275_/a_1283_21# clknet_2_1__leaf_clk_regs 0
C2889 _275_/a_761_289# _018_ 0
C2890 _259_/a_1462_47# clknet_2_0__leaf_clk_regs 0
C2891 clkload2/a_27_47# VPWR 0.10229f
C2892 _282_/a_1283_21# _297_/a_1283_21# 0
C2893 _282_/a_1108_47# _297_/a_543_47# 0
C2894 _283_/a_651_413# _297_/a_761_289# 0
C2895 _283_/a_1108_47# _297_/a_1283_21# 0
C2896 _283_/a_1283_21# _297_/a_1108_47# 0
C2897 input32/a_75_212# clknet_2_3__leaf_clk_regs 0
C2898 _264_/a_761_289# net54 0
C2899 _264_/a_1108_47# _009_ 0.00621f
C2900 _205_/a_285_47# _110_ 0.03004f
C2901 _205_/a_377_297# genblk1\[15\].fa_inst.s 0
C2902 _108_ _204_/a_561_297# 0
C2903 net6 _296_/a_193_47# 0
C2904 _199_/a_47_47# genblk1\[14\].fa_inst.b 0
C2905 _301_/a_1462_47# VPWR 0
C2906 input10/a_75_212# net10 0.00325f
C2907 cin delay_sel[1] 0
C2908 genblk1\[14\].fa_inst.a _102_ 0
C2909 _290_/a_651_413# net36 0.00118f
C2910 clknet_2_0__leaf_clk_regs net16 0.02438f
C2911 input32/a_75_212# net32 0.00211f
C2912 _149_/a_47_47# _064_ 0
C2913 _303_/a_805_47# VPWR 0
C2914 _045_ _030_ 0
C2915 _259_/a_1108_47# net58 0
C2916 _183_/a_27_413# _089_ 0.04934f
C2917 _269_/a_448_47# clknet_2_3__leaf_clk_regs 0.00203f
C2918 _274_/a_761_289# net10 0
C2919 _274_/a_543_47# a[3] 0
C2920 VPWR _026_ 0.05494f
C2921 _266_/a_193_47# _011_ 0
C2922 net8 net9 0.07315f
C2923 _042_ net30 0.02926f
C2924 _092_ _175_/a_150_297# 0
C2925 _031_ _285_/a_761_289# 0
C2926 _148_/a_382_47# _064_ 0
C2927 _259_/a_1217_47# net36 0
C2928 net3 _295_/a_805_47# 0
C2929 _098_ genblk1\[11\].fa_inst.b 0.00165f
C2930 VPWR pmu_inst/_04_ 0.01769f
C2931 net28 _281_/a_1108_47# 0.00133f
C2932 _294_/a_27_47# net58 0.02515f
C2933 clkload1/Y _085_ 0.00105f
C2934 _047_ net21 0.0107f
C2935 _130_/a_382_47# _050_ 0.00118f
C2936 _080_ net62 0.09196f
C2937 _285_/a_761_289# net31 0
C2938 net16 genblk1\[7\].fa_inst.a 0
C2939 net2 _281_/a_448_47# 0.01244f
C2940 net47 s[2] 0.00522f
C2941 net5 _285_/a_543_47# 0
C2942 net28 net31 0.01913f
C2943 net56 _056_ 0
C2944 _277_/a_27_47# clknet_2_0__leaf_clk_regs 0
C2945 genblk1\[1\].fa_inst.a _304_/a_193_47# 0.00727f
C2946 _022_ net14 0
C2947 net58 net56 0.26508f
C2948 net27 genblk1\[7\].fa_inst.b 0
C2949 net6 _281_/a_193_47# 0
C2950 net26 _282_/a_27_47# 0.00108f
C2951 _097_ _299_/a_193_47# 0.00152f
C2952 net2 _041_ 0
C2953 net61 _269_/a_193_47# 0.00623f
C2954 _298_/a_1283_21# net30 0.00451f
C2955 net28 _278_/a_1108_47# 0.00118f
C2956 _301_/a_543_47# _300_/a_543_47# 0
C2957 _301_/a_1283_21# _300_/a_761_289# 0
C2958 _301_/a_1108_47# _300_/a_193_47# 0
C2959 clkbuf_2_3__f_clk_regs/a_110_47# _265_/a_543_47# 0
C2960 _289_/a_761_289# net24 0
C2961 _289_/a_193_47# _034_ 0
C2962 _027_ _297_/a_761_289# 0
C2963 _282_/a_761_289# _042_ 0
C2964 _283_/a_543_47# _042_ 0
C2965 _284_/a_805_47# genblk1\[12\].fa_inst.a 0
C2966 _000_ genblk1\[1\].fa_inst.s 0.0034f
C2967 net2 _278_/a_448_47# 0.01121f
C2968 _184_/a_285_47# _095_ 0.00422f
C2969 genblk1\[14\].fa_inst.s _106_ 0
C2970 net36 _295_/a_193_47# 0
C2971 genblk1\[9\].fa_inst.b _297_/a_1108_47# 0
C2972 net46 pmu_inst/dc_inst.x2.net13 0
C2973 _276_/a_27_47# net24 0
C2974 net39 pmu_inst/dc_inst.x5.net16 0.0193f
C2975 net47 pmu_inst/clknet_1_0__leaf_clk 0.0611f
C2976 clknet_2_1__leaf_clk_regs _023_ 0.42582f
C2977 _294_/a_193_47# net24 0
C2978 _271_/a_761_289# net62 0
C2979 _014_ clknet_2_3__leaf_clk_regs 0.00402f
C2980 _300_/a_448_47# _031_ 0.00103f
C2981 _271_/a_651_413# net44 0.02637f
C2982 _285_/a_543_47# clknet_2_2__leaf_clk_regs 0.00251f
C2983 net56 _057_ 0.03622f
C2984 _260_/a_27_47# _260_/a_193_47# -0
C2985 _261_/a_193_47# genblk1\[6\].fa_inst.s 0.06421f
C2986 _261_/a_27_47# _006_ 0
C2987 clknet_2_1__leaf_clk_regs net3 0.04209f
C2988 _256_/a_1108_47# _255_/a_1283_21# 0
C2989 _256_/a_448_47# _255_/a_543_47# 0
C2990 _292_/a_193_47# clknet_2_1__leaf_clk_regs 0
C2991 genblk1\[14\].fa_inst.a _190_/a_68_297# 0
C2992 net46 pmu_inst/dc_inst.x4.x7/a_27_47# 0
C2993 VPWR _265_/a_193_47# 0.02877f
C2994 _199_/a_47_47# _111_ 0
C2995 VPWR _179_/a_47_47# 0.05475f
C2996 _283_/a_193_47# _298_/a_448_47# 0
C2997 a[10] net16 0
C2998 _272_/a_1108_47# net56 0.04093f
C2999 _268_/a_27_47# net62 0
C3000 net2 _026_ 0
C3001 _092_ _088_ 0.00379f
C3002 VPWR _297_/a_761_289# 0.01347f
C3003 net49 net73 0.05428f
C3004 VPWR pmu_inst/_16_/a_229_47# 0.00143f
C3005 genblk1\[2\].fa_inst.a _289_/a_1283_21# 0.01841f
C3006 pmu_inst/dc_inst.x7.x12/a_27_47# net34 0
C3007 _295_/a_193_47# _295_/a_761_289# -0.00839f
C3008 _295_/a_27_47# _295_/a_543_47# -0.00327f
C3009 genblk1\[14\].fa_inst.a _107_ 0
C3010 _050_ _134_/a_129_47# 0.00107f
C3011 _293_/a_761_289# net17 0.00163f
C3012 net3 _025_ 0.02565f
C3013 _296_/a_27_47# _296_/a_448_47# -0.00676f
C3014 clk _264_/a_639_47# 0.00158f
C3015 _304_/a_1270_413# _057_ 0
C3016 _259_/a_1108_47# _258_/a_543_47# 0
C3017 net27 _280_/a_761_289# 0.01558f
C3018 _180_/a_68_297# VPWR 0.02759f
C3019 net61 _269_/a_1462_47# 0.00103f
C3020 _100_ _180_/a_68_297# 0
C3021 _292_/a_543_47# net58 0.00425f
C3022 clk _266_/a_651_413# 0.00353f
C3023 VPWR input15/a_75_212# 0.09154f
C3024 _004_ fanout57/a_27_47# 0
C3025 _023_ _279_/a_193_47# 0
C3026 _301_/a_193_47# net20 0.03891f
C3027 _301_/a_27_47# _045_ 0
C3028 _046_ _300_/a_27_47# 0
C3029 _255_/a_1270_413# VPWR 0
C3030 _302_/a_193_47# _287_/a_193_47# 0
C3031 _302_/a_27_47# _287_/a_761_289# 0
C3032 _302_/a_761_289# _287_/a_27_47# 0
C3033 _099_ _097_ 0.11326f
C3034 _056_ _055_ 0.06227f
C3035 clknet_2_1__leaf_clk_regs a[6] 0.02195f
C3036 net3 _279_/a_193_47# 0.02683f
C3037 net3 _282_/a_651_413# 0.00692f
C3038 net36 genblk1\[2\].fa_inst.b 0.00282f
C3039 _301_/a_1270_413# genblk1\[13\].fa_inst.b 0
C3040 _301_/a_193_47# _286_/a_193_47# 0
C3041 _301_/a_27_47# _286_/a_761_289# 0
C3042 genblk1\[3\].fa_inst.a _272_/a_761_289# 0
C3043 net25 _280_/a_27_47# 0
C3044 genblk1\[9\].fa_inst.b net32 0
C3045 genblk1\[11\].fa_inst.b VPWR 0.40838f
C3046 _277_/a_27_47# a[10] 0
C3047 _100_ genblk1\[11\].fa_inst.b 0.04307f
C3048 net26 net62 0
C3049 net55 pmu_inst/dc_inst.x5.x14/a_27_47# 0
C3050 _077_ _173_/a_215_297# 0
C3051 _028_ genblk1\[10\].fa_inst.b 0.00163f
C3052 net24 net14 0.02368f
C3053 _275_/a_1108_47# VPWR 0.02549f
C3054 clknet_0_clk_regs _261_/a_1283_21# 0.00121f
C3055 net70 net66 0
C3056 net29 net24 0
C3057 _144_/a_47_47# net36 0.00982f
C3058 _277_/a_1283_21# net58 0.02437f
C3059 a[3] net9 0
C3060 _256_/a_1283_21# genblk1\[0\].fa_inst.s 0
C3061 _256_/a_543_47# _000_ 0
C3062 _256_/a_27_47# net39 0
C3063 net46 _255_/a_27_47# 0
C3064 net49 net36 0.01501f
C3065 _277_/a_193_47# _291_/a_1108_47# 0
C3066 _286_/a_761_289# _031_ -0.00669f
C3067 _291_/a_805_47# VPWR 0
C3068 genblk1\[7\].fa_inst.b _280_/a_1283_21# 0
C3069 net27 _040_ 0.0298f
C3070 net59 _174_/a_47_47# 0.02787f
C3071 _027_ net59 0.2432f
C3072 VPWR _299_/a_761_289# 0.02588f
C3073 _271_/a_651_413# VPWR -0.00948f
C3074 _275_/a_193_47# net8 0.00108f
C3075 clknet_2_1__leaf_clk_regs _261_/a_27_47# 0.04831f
C3076 _281_/a_543_47# _296_/a_543_47# 0
C3077 _281_/a_1108_47# _296_/a_193_47# 0
C3078 _028_ _298_/a_193_47# 0
C3079 _283_/a_193_47# _043_ 0
C3080 _257_/a_543_47# clknet_2_0__leaf_clk_regs 0.0015f
C3081 net11 a[6] 0
C3082 _274_/a_1108_47# net9 0
C3083 net1 net56 0.01987f
C3084 _057_ _055_ 0.0611f
C3085 genblk1\[8\].fa_inst.s _082_ 0
C3086 net5 _286_/a_543_47# 0
C3087 _257_/a_193_47# VPWR -0.01611f
C3088 _184_/a_129_47# _096_ 0.00106f
C3089 _293_/a_543_47# net17 0.00363f
C3090 input5/a_27_47# net14 0
C3091 _296_/a_193_47# net31 0.00725f
C3092 _296_/a_27_47# _041_ 0.00108f
C3093 clk net54 0
C3094 VPWR _268_/a_1108_47# 0.01412f
C3095 net28 _297_/a_193_47# 0
C3096 genblk1\[0\].fa_inst.a genblk1\[0\].fa_inst.s 0
C3097 VPWR pmu_inst/dc_inst.x6.x15/a_27_47# 0.00536f
C3098 _037_ fanout56/a_27_47# 0
C3099 _051_ _053_ 0.01984f
C3100 net26 net7 0.02507f
C3101 pmu_inst/dc_inst.x7.net1 net34 0
C3102 genblk1\[0\].fa_inst.a _304_/a_1283_21# 0
C3103 net58 _261_/a_761_289# 0
C3104 VPWR input25/a_75_212# 0.09161f
C3105 _183_/a_27_413# genblk1\[11\].fa_inst.a 0
C3106 _303_/a_1283_21# net23 0
C3107 VPWR net59 5.48283f
C3108 _304_/a_651_413# VPWR 0
C3109 _280_/a_1108_47# _295_/a_1108_47# 0
C3110 _280_/a_543_47# _295_/a_651_413# 0
C3111 net27 _282_/a_543_47# 0.00729f
C3112 VPWR pmu_inst/dc_inst.x6.x4/a_27_47# 0.00278f
C3113 genblk1\[10\].fa_inst.a _178_/a_382_47# 0
C3114 clknet_2_0__leaf_clk_regs _068_ 0
C3115 genblk1\[1\].fa_inst.b _288_/a_1283_21# 0
C3116 net46 net70 0.02385f
C3117 net33 _153_/a_27_413# 0
C3118 _074_ genblk1\[6\].fa_inst.a 0.02892f
C3119 VPWR _298_/a_27_47# 0.06279f
C3120 _148_/a_215_297# _058_ 0
C3121 b[1] b[0] 0.07915f
C3122 clk _263_/a_27_47# 0.04217f
C3123 delay_sel[0] net35 0
C3124 net46 pmu_inst/dc_inst.x1.net16 0.01014f
C3125 net4 _296_/a_448_47# 0
C3126 VPWR fanout58/a_27_47# 0.08714f
C3127 VPWR b[7] 0.21183f
C3128 _260_/a_543_47# net50 0
C3129 _260_/a_448_47# _005_ 0
C3130 _286_/a_543_47# clknet_2_2__leaf_clk_regs 0.00998f
C3131 _256_/a_1217_47# net39 0
C3132 net46 _255_/a_1217_47# 0
C3133 _290_/a_805_47# net11 0
C3134 _277_/a_193_47# net26 0.03102f
C3135 net33 genblk1\[11\].fa_inst.a 0.96556f
C3136 VPWR pmu_inst/_10_ 0.00758f
C3137 _165_/a_68_297# _082_ 0
C3138 genblk1\[8\].fa_inst.b _173_/a_27_413# 0
C3139 net29 b[6] 0.00207f
C3140 VPWR _287_/a_543_47# 0.01623f
C3141 _289_/a_651_413# net12 0.00195f
C3142 _259_/a_1283_21# clknet_0_clk_regs 0
C3143 clknet_2_1__leaf_clk_regs _261_/a_1217_47# 0
C3144 clknet_2_2__leaf_clk_regs _296_/a_761_289# 0
C3145 _026_ _296_/a_27_47# 0.00166f
C3146 _281_/a_193_47# net31 0
C3147 _281_/a_27_47# _041_ 0
C3148 clk_regs net52 0.02897f
C3149 _292_/a_1283_21# clknet_2_0__leaf_clk_regs 0.06734f
C3150 VPWR _267_/a_1108_47# 0.00824f
C3151 net34 net62 0.02918f
C3152 output50/a_27_47# s[5] 0.02683f
C3153 net7 _298_/a_448_47# 0.01071f
C3154 _188_/a_298_297# _096_ 0.00991f
C3155 _183_/a_298_297# VPWR -0.00648f
C3156 input4/a_27_47# net4 0.00199f
C3157 _292_/a_761_289# VPWR 0.01466f
C3158 _270_/a_27_47# clk 0.00697f
C3159 _285_/a_27_47# net60 0
C3160 VPWR input16/a_75_212# 0.09161f
C3161 _296_/a_1217_47# _041_ 0
C3162 _296_/a_1462_47# net31 0
C3163 _022_ _291_/a_27_47# 0
C3164 net28 _297_/a_1462_47# 0
C3165 _276_/a_543_47# _290_/a_1108_47# 0.00268f
C3166 net49 _259_/a_193_47# 0
C3167 _294_/a_761_289# net62 0.01261f
C3168 delay_sel[2] net36 0.00444f
C3169 _047_ _287_/a_651_413# 0
C3170 _188_/a_215_297# net35 0.03051f
C3171 _276_/a_1283_21# clknet_2_1__leaf_clk_regs 0
C3172 a[13] net5 0.00225f
C3173 _039_ net17 0.03301f
C3174 _287_/a_639_47# net7 0
C3175 net4 _281_/a_448_47# 0.01071f
C3176 _173_/a_382_47# _088_ 0.00136f
C3177 _082_ _081_ 0.4212f
C3178 _096_ genblk1\[10\].fa_inst.a 0.00281f
C3179 _270_/a_193_47# _270_/a_543_47# -0.01017f
C3180 _290_/a_27_47# VPWR 0.04577f
C3181 clknet_2_1__leaf_clk_regs _280_/a_27_47# 0.01874f
C3182 VPWR input24/a_27_47# 0.0923f
C3183 _303_/a_193_47# _303_/a_761_289# -0.00517f
C3184 _303_/a_27_47# _303_/a_543_47# -0.00353f
C3185 net46 pmu_inst/dc_inst.x1.net13 0.00416f
C3186 _280_/a_1108_47# net30 0
C3187 _025_ _295_/a_1283_21# 0
C3188 _160_/a_68_297# net62 0
C3189 clknet_2_2__leaf_clk_regs _263_/a_193_47# 0.00748f
C3190 _092_ _087_ 0.10507f
C3191 _301_/a_651_413# _031_ 0.00726f
C3192 _301_/a_1283_21# genblk1\[14\].fa_inst.a 0
C3193 fanout60/a_27_47# genblk1\[13\].fa_inst.s 0
C3194 input29/a_75_212# b[6] 0.01625f
C3195 net60 _104_ 0.075f
C3196 net46 pmu_inst/dc_inst.x6.x5/a_27_47# 0.0022f
C3197 genblk1\[3\].fa_inst.a _058_ 0
C3198 _278_/a_27_47# _278_/a_448_47# -0.00346f
C3199 VPWR _298_/a_1217_47# 0
C3200 _277_/a_1217_47# genblk1\[5\].fa_inst.a 0
C3201 _293_/a_27_47# _293_/a_193_47# -0.32434f
C3202 clk _263_/a_1217_47# 0
C3203 genblk1\[11\].fa_inst.a net35 0.1695f
C3204 clkload0/a_27_47# _260_/a_1108_47# 0
C3205 clkload0/a_361_47# _260_/a_1283_21# 0.01324f
C3206 net4 _041_ 0
C3207 VPWR net13 1.42993f
C3208 _281_/a_761_289# clknet_2_2__leaf_clk_regs 0
C3209 _281_/a_27_47# _026_ 0.00167f
C3210 _288_/a_761_289# _033_ -0.00125f
C3211 _288_/a_543_47# net17 0.00191f
C3212 net47 net68 0.1057f
C3213 _284_/a_543_47# _299_/a_27_47# 0
C3214 _071_ genblk1\[5\].fa_inst.s 0.05919f
C3215 _300_/a_1283_21# _299_/a_543_47# 0
C3216 net62 genblk1\[15\].fa_inst.s 0
C3217 net2 net59 0
C3218 net47 pmu_inst/dc_inst.x7.net18 0.00604f
C3219 net4 _278_/a_448_47# 0.01003f
C3220 _293_/a_27_47# _038_ 0
C3221 _280_/a_27_47# _025_ 0.00169f
C3222 net58 _280_/a_761_289# 0.00188f
C3223 b[8] net35 0
C3224 genblk1\[14\].fa_inst.a _109_ 0
C3225 net46 pmu_inst/dc_inst.x4.x20/a_27_47# 0
C3226 _276_/a_27_47# _291_/a_543_47# 0
C3227 genblk1\[7\].fa_inst.s _262_/a_1217_47# 0
C3228 _294_/a_543_47# _280_/a_761_289# 0
C3229 VPWR pmu_inst_74/HI 0.03398f
C3230 VPWR _205_/a_285_47# -0.00232f
C3231 _300_/a_1283_21# net60 0.03284f
C3232 _275_/a_27_47# net10 0.14983f
C3233 _273_/a_1283_21# genblk1\[1\].fa_inst.a 0.01334f
C3234 genblk1\[2\].fa_inst.s _058_ 0.00203f
C3235 _276_/a_1283_21# net11 0
C3236 net7 _043_ 0.00179f
C3237 net47 pmu_inst/dc_inst.x3.x17/a_27_47# 0.00258f
C3238 _065_ _061_ 0
C3239 _285_/a_1217_47# net60 0
C3240 genblk1\[4\].fa_inst.b _153_/a_298_297# 0
C3241 _294_/a_651_413# VPWR 0.00145f
C3242 _301_/a_193_47# _046_ 0.00524f
C3243 _301_/a_761_289# net21 0
C3244 a[15] net36 0
C3245 VPWR _051_ 0.25213f
C3246 VPWR _261_/a_193_47# 0.02262f
C3247 net28 net3 0.02411f
C3248 _273_/a_1283_21# _272_/a_193_47# 0
C3249 _275_/a_448_47# _274_/a_27_47# 0
C3250 _275_/a_543_47# _274_/a_543_47# 0
C3251 _275_/a_193_47# _274_/a_1108_47# 0
C3252 _275_/a_761_289# _274_/a_1283_21# 0
C3253 _273_/a_1108_47# _272_/a_27_47# 0
C3254 net58 clknet_0_clk_regs 0.58447f
C3255 _263_/a_448_47# net53 0
C3256 a[12] net16 0
C3257 _284_/a_193_47# net59 0.00101f
C3258 _161_/a_113_47# genblk1\[8\].fa_inst.a 0
C3259 net26 net6 0.01622f
C3260 genblk1\[15\].fa_inst.a net7 0
C3261 _266_/a_543_47# clknet_2_3__leaf_clk_regs 0.00102f
C3262 _022_ net56 0.00273f
C3263 net4 _026_ 0
C3264 VPWR pmu_inst/dc_inst.x5.x13/a_27_47# 0
C3265 net39 pmu_inst/dc_inst.x6.x2/a_27_47# 0
C3266 _139_/a_129_47# _058_ 0
C3267 _290_/a_1217_47# VPWR 0
C3268 _258_/a_651_413# net36 0.00177f
C3269 _292_/a_761_289# net2 0.002f
C3270 clknet_2_2__leaf_clk_regs b[11] 0
C3271 _284_/a_27_47# _298_/a_193_47# 0
C3272 _284_/a_193_47# _298_/a_27_47# 0
C3273 _294_/a_193_47# net15 0
C3274 _056_ _133_/a_113_47# 0
C3275 _143_/a_298_297# _057_ 0.00313f
C3276 net58 _040_ 0
C3277 genblk1\[8\].fa_inst.a _082_ 0.00411f
C3278 _274_/a_27_47# net56 0
C3279 net46 pmu_inst/dc_inst.x6.net8 0.00845f
C3280 _291_/a_27_47# net24 0
C3281 _281_/a_1217_47# _026_ 0
C3282 _283_/a_651_413# net30 0.00348f
C3283 _284_/a_639_47# clknet_2_3__leaf_clk_regs 0
C3284 _300_/a_761_289# net19 0.008f
C3285 _045_ _299_/a_193_47# 0
C3286 _098_ _193_/a_215_297# 0.01033f
C3287 net61 _264_/a_27_47# 0
C3288 _280_/a_1217_47# _025_ 0
C3289 genblk1\[5\].fa_inst.a clknet_2_1__leaf_clk_regs 0
C3290 genblk1\[0\].fa_inst.s net75 0.00343f
C3291 _289_/a_1108_47# net56 0
C3292 net7 _295_/a_27_47# 0.03089f
C3293 genblk1\[13\].fa_inst.a clknet_2_3__leaf_clk_regs 0
C3294 _293_/a_761_289# net33 0.01224f
C3295 _108_ _110_ 0.02217f
C3296 _276_/a_1217_47# net56 0
C3297 clkload2/a_27_47# clkload2/X -0
C3298 net38 cout_next 0
C3299 net48 net34 0.02804f
C3300 net2 net13 0.03342f
C3301 _277_/a_448_47# net58 0
C3302 _068_ _062_ 0.0286f
C3303 genblk1\[6\].fa_inst.b _074_ 0.07423f
C3304 _262_/a_1270_413# net62 0
C3305 _077_ genblk1\[7\].fa_inst.a 0.05664f
C3306 genblk1\[13\].fa_inst.a _044_ 0
C3307 _057_ _133_/a_113_47# 0
C3308 _301_/a_1462_47# _046_ 0
C3309 _259_/a_1283_21# _258_/a_193_47# 0
C3310 _273_/a_193_47# clknet_2_0__leaf_clk_regs 0
C3311 _275_/a_27_47# _019_ 0
C3312 net72 pmu_inst/dc_inst.x5.net19 0
C3313 net39 pmu_inst/_18_/a_76_199# 0.01007f
C3314 _008_ net53 0.1953f
C3315 net29 _297_/a_448_47# 0.01127f
C3316 VPWR _175_/a_150_297# 0
C3317 _269_/a_1108_47# net44 0.00112f
C3318 _269_/a_1270_413# _014_ 0
C3319 _039_ _294_/a_1217_47# 0
C3320 _273_/a_27_47# net1 0
C3321 net46 pmu_inst/dc_inst.x6.x6/a_27_47# 0
C3322 VPWR _295_/a_1108_47# 0.03686f
C3323 _270_/a_448_47# net45 0
C3324 _185_/a_150_297# _097_ 0
C3325 _022_ _292_/a_543_47# 0
C3326 genblk1\[8\].fa_inst.b genblk1\[9\].fa_inst.b 0.00203f
C3327 _303_/a_1270_413# _048_ -0
C3328 _303_/a_1108_47# genblk1\[15\].fa_inst.b 0
C3329 VPWR pmu_inst/dc_inst.x6.x3/a_27_47# 0.00277f
C3330 net14 net15 0.16017f
C3331 genblk1\[4\].fa_inst.s _065_ 0
C3332 _300_/a_27_47# net18 0
C3333 input12/a_75_212# net12 0.00212f
C3334 VPWR s[11] 0.37243f
C3335 _294_/a_27_47# net24 0
C3336 _129_/a_47_47# genblk1\[0\].fa_inst.b 0
C3337 net29 net15 0
C3338 _285_/a_651_413# net18 0.00464f
C3339 genblk1\[9\].fa_inst.a net16 0
C3340 _275_/a_27_47# _288_/a_448_47# 0
C3341 _275_/a_1108_47# _288_/a_193_47# 0
C3342 genblk1\[1\].fa_inst.a net11 0
C3343 clknet_2_1__leaf_clk_regs _279_/a_448_47# 0
C3344 net59 _296_/a_27_47# 0.04114f
C3345 genblk1\[12\].fa_inst.a _299_/a_1108_47# 0.00124f
C3346 _284_/a_639_47# net19 0
C3347 genblk1\[12\].fa_inst.a clknet_2_3__leaf_clk_regs 0.0013f
C3348 VPWR _280_/a_193_47# 0.03705f
C3349 _027_ net30 0.08906f
C3350 VPWR pmu_inst/dc_inst.x1.x12/a_27_47# 0.00254f
C3351 VPWR _143_/a_215_297# 0.02918f
C3352 net20 _287_/a_543_47# 0
C3353 _108_ _105_ 0.0454f
C3354 genblk1\[12\].fa_inst.a net32 0
C3355 net46 pmu_inst/dc_inst.x2.net14 0.00914f
C3356 net24 net56 0
C3357 _174_/a_285_47# _081_ 0
C3358 _174_/a_47_47# _088_ 0.0238f
C3359 genblk1\[13\].fa_inst.a net19 0.00178f
C3360 net39 pmu_inst/dc_inst.x5.x15/a_27_47# 0.00285f
C3361 net46 pmu_inst/dc_inst.x5.net12 0
C3362 _293_/a_543_47# net33 0.00726f
C3363 _286_/a_639_47# clknet_2_3__leaf_clk_regs 0.00144f
C3364 _022_ _277_/a_1283_21# 0.01499f
C3365 clk _265_/a_651_413# 0.00353f
C3366 genblk1\[12\].fa_inst.a _044_ 0.00693f
C3367 net61 _266_/a_639_47# 0
C3368 output55/a_27_47# net55 0.0058f
C3369 _276_/a_761_289# net56 0.00242f
C3370 _288_/a_27_47# net56 0.00604f
C3371 _148_/a_215_297# _061_ 0.06998f
C3372 _284_/a_543_47# net35 0.02959f
C3373 _141_/a_113_47# net36 0
C3374 _259_/a_651_413# genblk1\[4\].fa_inst.s 0.00211f
C3375 net58 _279_/a_1270_413# 0
C3376 net7 _280_/a_651_413# 0.00775f
C3377 fanout62/a_110_47# net37 0.00841f
C3378 a[14] net36 0
C3379 _275_/a_1270_413# genblk1\[2\].fa_inst.a 0
C3380 _276_/a_543_47# clknet_2_1__leaf_clk_regs 0.00136f
C3381 genblk1\[3\].fa_inst.b _140_/a_150_297# 0
C3382 net39 net64 0.25778f
C3383 _290_/a_1108_47# _289_/a_193_47# 0
C3384 _290_/a_193_47# _289_/a_1108_47# 0
C3385 _290_/a_543_47# _289_/a_543_47# 0
C3386 net29 _042_ 0
C3387 net45 fanout62/a_110_47# 0
C3388 clk _268_/a_27_47# 0.03256f
C3389 _304_/a_1283_21# genblk1\[1\].fa_inst.b 0.00124f
C3390 genblk1\[7\].fa_inst.s net62 0.22422f
C3391 net3 _296_/a_193_47# 0.0239f
C3392 _283_/a_193_47# genblk1\[11\].fa_inst.a 0
C3393 _283_/a_1283_21# _028_ 0.05464f
C3394 _099_ _194_/a_47_47# 0
C3395 _273_/a_805_47# VPWR 0
C3396 net47 pmu_inst/dc_inst.x3.net14 0.01111f
C3397 _015_ net45 0.00234f
C3398 _185_/a_68_297# genblk1\[11\].fa_inst.a 0
C3399 net41 net40 0.00175f
C3400 _292_/a_27_47# _277_/a_761_289# 0
C3401 _282_/a_761_289# _027_ 0
C3402 VPWR net30 2.67908f
C3403 _272_/a_193_47# _272_/a_651_413# -0.00701f
C3404 _276_/a_193_47# net12 0.00219f
C3405 net48 s[3] 0.00187f
C3406 VPWR _269_/a_1108_47# 0.01819f
C3407 net60 genblk1\[13\].fa_inst.s 0.10875f
C3408 _276_/a_1462_47# net56 0
C3409 _281_/a_27_47# net59 0.00295f
C3410 VPWR _193_/a_215_297# 0.01707f
C3411 VPWR output40/a_27_47# 0.07863f
C3412 _304_/a_543_47# _288_/a_1108_47# 0
C3413 _276_/a_27_47# _290_/a_1283_21# 0.00464f
C3414 VPWR _088_ 0.578f
C3415 _268_/a_448_47# genblk1\[13\].fa_inst.s 0.00196f
C3416 _100_ _193_/a_215_297# 0.01265f
C3417 net28 _295_/a_1283_21# 0.0113f
C3418 _164_/a_285_47# VPWR 0
C3419 _301_/a_543_47# clknet_2_3__leaf_clk_regs 0
C3420 _273_/a_448_47# net8 0.0056f
C3421 net58 _262_/a_639_47# 0
C3422 _020_ _288_/a_27_47# 0
C3423 VPWR _134_/a_285_47# 0.00204f
C3424 clknet_2_1__leaf_clk_regs _024_ 0
C3425 _084_ _080_ 0.00636f
C3426 net59 _296_/a_1217_47# 0
C3427 _303_/a_193_47# clknet_2_3__leaf_clk_regs 0.31302f
C3428 s[12] net42 0.01379f
C3429 genblk1\[4\].fa_inst.b _150_/a_68_297# 0
C3430 VPWR _280_/a_1462_47# 0
C3431 VPWR fanout56/a_27_47# 0.12972f
C3432 net39 pmu_inst/dc_inst.x2.net15 0.00237f
C3433 _301_/a_1108_47# net60 0.00678f
C3434 _276_/a_543_47# net11 0.00362f
C3435 net28 _280_/a_27_47# 0
C3436 _091_ clknet_2_2__leaf_clk_regs 0.01017f
C3437 _286_/a_639_47# net19 0.00434f
C3438 genblk1\[14\].fa_inst.a clknet_2_3__leaf_clk_regs 0
C3439 _303_/a_543_47# net60 0
C3440 net61 net41 0.08691f
C3441 clknet_2_2__leaf_clk_regs _297_/a_639_47# 0.00437f
C3442 VPWR _283_/a_543_47# 0.01841f
C3443 genblk1\[3\].fa_inst.a _061_ 0.15875f
C3444 VPWR _282_/a_761_289# 0.01492f
C3445 net26 net31 0
C3446 _288_/a_1217_47# net56 0
C3447 _275_/a_27_47# net12 0
C3448 _257_/a_193_47# net57 0.05732f
C3449 net2 _280_/a_193_47# 0.01976f
C3450 net3 _281_/a_193_47# 0.02212f
C3451 _039_ net33 0
C3452 _271_/a_27_47# fanout62/a_110_47# 0
C3453 clk _267_/a_27_47# 0.0383f
C3454 _283_/a_1108_47# _090_ 0
C3455 input23/a_75_212# net35 0.00457f
C3456 b[15] net34 0
C3457 net4 net59 0
C3458 _256_/a_448_47# genblk1\[1\].fa_inst.s 0.0056f
C3459 net47 pmu_inst/dc_inst.x3.x15/a_27_47# 0.00407f
C3460 _270_/a_651_413# clknet_2_3__leaf_clk_regs 0
C3461 _035_ _289_/a_27_47# 0
C3462 _058_ _135_/a_27_413# 0
C3463 _290_/a_27_47# _034_ 0
C3464 net25 _289_/a_193_47# 0
C3465 _290_/a_193_47# net24 0.02196f
C3466 genblk1\[5\].fa_inst.a _072_ 0
C3467 net4 _298_/a_27_47# 0.02923f
C3468 _276_/a_639_47# clknet_2_1__leaf_clk_regs 0
C3469 net21 b[13] 0.00161f
C3470 _023_ _278_/a_193_47# 0.0016f
C3471 _282_/a_805_47# genblk1\[10\].fa_inst.a 0
C3472 _272_/a_761_289# _017_ -0.00125f
C3473 _272_/a_1283_21# clknet_2_0__leaf_clk_regs 0.04394f
C3474 net46 pmu_inst/dc_inst.x4.net4 0
C3475 _279_/a_193_47# _024_ 0
C3476 _029_ _043_ 0
C3477 net7 _283_/a_639_47# 0.00176f
C3478 net3 _278_/a_193_47# 0.02671f
C3479 net7 _279_/a_761_289# 0
C3480 _013_ genblk1\[13\].fa_inst.s 0
C3481 _272_/a_543_47# net1 0.0028f
C3482 _272_/a_761_289# VPWR 0.00411f
C3483 _290_/a_1283_21# net14 0
C3484 genblk1\[10\].fa_inst.a _171_/a_113_47# 0
C3485 _302_/a_193_47# net7 0.03356f
C3486 _302_/a_27_47# net22 0.1552f
C3487 clknet_2_1__leaf_clk_regs _262_/a_1108_47# 0
C3488 _301_/a_543_47# net19 0
C3489 cin net36 0
C3490 _018_ net8 0
C3491 cin_q _304_/a_1108_47# 0
C3492 net2 net30 0.0081f
C3493 _303_/a_1462_47# clknet_2_3__leaf_clk_regs 0
C3494 _261_/a_1283_21# _260_/a_27_47# 0
C3495 _261_/a_761_289# _260_/a_761_289# 0
C3496 _303_/a_1283_21# _287_/a_543_47# 0
C3497 _303_/a_193_47# _287_/a_448_47# 0
C3498 net26 a[9] 0
C3499 _270_/a_761_289# net61 0.00548f
C3500 _298_/a_448_47# net31 0.0125f
C3501 net21 net60 0
C3502 _036_ net17 0
C3503 hold1/a_391_47# _053_ 0.0032f
C3504 genblk1\[14\].fa_inst.a net19 0.00496f
C3505 _274_/a_27_47# _273_/a_27_47# 0
C3506 VPWR _279_/a_651_413# 0.00132f
C3507 _265_/a_193_47# _265_/a_448_47# -0.00373f
C3508 _257_/a_1462_47# net57 0
C3509 _302_/a_448_47# VPWR 0.00144f
C3510 _110_ _201_/a_637_47# 0.00266f
C3511 clk _267_/a_1217_47# 0
C3512 net13 _278_/a_27_47# 0.14927f
C3513 net28 _283_/a_761_289# 0
C3514 _001_ genblk1\[1\].fa_inst.s 0.02915f
C3515 net28 _282_/a_193_47# 0
C3516 _051_ _288_/a_193_47# 0
C3517 _258_/a_761_289# clknet_2_0__leaf_clk_regs 0.00106f
C3518 _284_/a_193_47# net30 0
C3519 net26 net12 0.03452f
C3520 net59 _170_/a_68_297# 0
C3521 b[2] net16 0
C3522 _297_/a_27_47# _297_/a_639_47# -0.0015f
C3523 _301_/a_193_47# net18 0
C3524 clk net34 0.05543f
C3525 net2 _282_/a_761_289# 0
C3526 net39 pmu_inst/dc_inst.x2.net7 0.00325f
C3527 net46 pmu_inst/dc_inst.x5.net16 0
C3528 net4 net13 0.02595f
C3529 _023_ _278_/a_1462_47# -0
C3530 net6 b[3] 0.04299f
C3531 _174_/a_47_47# _087_ 0.00674f
C3532 clkbuf_2_2__f_clk_regs/a_110_47# clknet_0_clk_regs 0.00954f
C3533 _272_/a_805_47# genblk1\[0\].fa_inst.a 0
C3534 _130_/a_215_297# genblk1\[2\].fa_inst.s 0
C3535 _279_/a_639_47# genblk1\[7\].fa_inst.a 0
C3536 input20/a_75_212# net35 0.00505f
C3537 _256_/a_1283_21# _256_/a_1108_47# -0
C3538 net25 a[7] 0
C3539 clknet_0_clk_regs _266_/a_1108_47# 0.00325f
C3540 _021_ net17 0.37054f
C3541 _046_ _287_/a_543_47# 0
C3542 cin_q net33 0
C3543 _277_/a_543_47# net56 0.006f
C3544 fanout60/a_27_47# net43 0.1639f
C3545 _048_ _287_/a_193_47# 0
C3546 _043_ net31 0
C3547 _269_/a_1108_47# genblk1\[14\].fa_inst.s 0
C3548 genblk1\[12\].fa_inst.b _300_/a_543_47# 0
C3549 net47 pmu_inst/dc_inst.x3.x4/a_27_47# 0.00242f
C3550 _071_ genblk1\[5\].fa_inst.b 0
C3551 _294_/a_651_413# net4 0.00128f
C3552 _294_/a_193_47# _280_/a_1108_47# 0
C3553 output54/a_27_47# s[10] 0
C3554 _094_ _180_/a_150_297# 0
C3555 _093_ _180_/a_68_297# 0.00593f
C3556 VPWR pmu_inst/dc_inst.x5.net7 0
C3557 net47 pmu_inst/dc_inst.x7.x16/a_27_47# 0.00254f
C3558 genblk1\[12\].fa_inst.b _190_/a_68_297# 0
C3559 VPWR _087_ 0.18613f
C3560 _255_/a_193_47# net39 0
C3561 _255_/a_1108_47# genblk1\[0\].fa_inst.s 0.00114f
C3562 _255_/a_1283_21# _000_ 0.05579f
C3563 _265_/a_543_47# clknet_2_3__leaf_clk_regs 0
C3564 _265_/a_193_47# _010_ 0
C3565 _271_/a_193_47# _271_/a_651_413# -0.00701f
C3566 net35 b[11] 0.0071f
C3567 fanout61/a_27_47# cout_next 0
C3568 _047_ VPWR 0.06745f
C3569 _256_/a_1270_413# VPWR 0
C3570 a[5] input13/a_75_212# 0
C3571 input12/a_75_212# a[6] 0
C3572 _091_ genblk1\[10\].fa_inst.s 0.00531f
C3573 clk genblk1\[15\].fa_inst.s 0.0276f
C3574 _303_/a_448_47# net35 0.00381f
C3575 clknet_2_1__leaf_clk_regs _289_/a_193_47# 0.01142f
C3576 net28 _282_/a_1462_47# 0
C3577 _093_ genblk1\[11\].fa_inst.b 0.00396f
C3578 _051_ _288_/a_1462_47# 0
C3579 VPWR net67 0.30074f
C3580 _291_/a_543_47# net56 0.00443f
C3581 net75 _134_/a_47_47# 0.01971f
C3582 _022_ _277_/a_448_47# 0
C3583 genblk1\[12\].fa_inst.s _267_/a_1108_47# 0
C3584 _297_/a_1283_21# net32 0
C3585 _297_/a_543_47# _042_ -0
C3586 _198_/a_215_297# _102_ 0.04634f
C3587 pmu_inst/dc_inst.x7.x13/a_27_47# net34 0
C3588 cout_next pmu_inst/_15_/a_27_47# 0
C3589 net33 _048_ 0
C3590 _270_/a_1283_21# genblk1\[15\].fa_inst.s 0
C3591 b[1] net16 0
C3592 _294_/a_27_47# net15 0
C3593 _281_/a_1283_21# _295_/a_193_47# 0
C3594 _281_/a_1108_47# _295_/a_27_47# 0
C3595 _281_/a_543_47# _295_/a_761_289# 0
C3596 _281_/a_761_289# _295_/a_543_47# 0
C3597 _136_/a_68_297# _058_ 0.00145f
C3598 genblk1\[4\].fa_inst.a _276_/a_27_47# 0
C3599 _080_ _078_ 0.00243f
C3600 _256_/a_27_47# net46 0
C3601 _256_/a_543_47# _001_ 0.01f
C3602 VPWR _058_ 0.29412f
C3603 VPWR _108_ 0.70103f
C3604 VPWR _262_/a_27_47# 0.0611f
C3605 clkbuf_2_0__f_clk_regs/a_110_47# _260_/a_1108_47# 0
C3606 clknet_0_clk_regs _260_/a_761_289# 0
C3607 _296_/a_27_47# net30 0.02396f
C3608 _303_/a_651_413# net36 0.00269f
C3609 _268_/a_27_47# _268_/a_1283_21# -0
C3610 net15 net56 0
C3611 _292_/a_543_47# _277_/a_543_47# 0
C3612 _260_/a_27_47# genblk1\[5\].fa_inst.s 0.04768f
C3613 net5 _295_/a_193_47# 0
C3614 _304_/a_27_47# net56 0.0017f
C3615 _289_/a_193_47# net11 0.03663f
C3616 _290_/a_448_47# net12 0.01382f
C3617 _293_/a_27_47# VPWR 0.02649f
C3618 VPWR pmu_inst/dc_inst.x3.net3 0
C3619 VPWR hold1/a_391_47# 0.00926f
C3620 _274_/a_651_413# clknet_2_1__leaf_clk_regs 0.00166f
C3621 _274_/a_761_289# genblk1\[1\].fa_inst.a 0
C3622 _019_ _273_/a_1108_47# 0
C3623 _274_/a_1108_47# _018_ 0
C3624 _259_/a_639_47# clknet_2_0__leaf_clk_regs 0
C3625 genblk1\[2\].fa_inst.a _137_/a_113_47# 0
C3626 _291_/a_639_47# net26 0.00114f
C3627 _291_/a_1108_47# genblk1\[3\].fa_inst.b 0
C3628 _198_/a_27_413# _104_ 0.0011f
C3629 net27 net16 0.0081f
C3630 _265_/a_639_47# net40 0
C3631 _271_/a_639_47# clknet_2_3__leaf_clk_regs 0
C3632 _271_/a_761_289# _016_ 0.00555f
C3633 _258_/a_448_47# net48 0
C3634 genblk1\[4\].fa_inst.b net17 0.0349f
C3635 genblk1\[4\].fa_inst.b _145_/a_150_297# 0
C3636 _293_/a_1462_47# _076_ 0
C3637 _048_ net35 0
C3638 genblk1\[15\].fa_inst.b net34 0.25872f
C3639 _285_/a_543_47# net7 0.00751f
C3640 _294_/a_193_47# _279_/a_27_47# 0
C3641 genblk1\[8\].fa_inst.b _296_/a_1270_413# 0
C3642 net28 _024_ 0
C3643 net24 _040_ 0.0014f
C3644 _183_/a_27_413# _091_ 0
C3645 genblk1\[11\].fa_inst.s _266_/a_543_47# 0
C3646 a[1] net8 0.00259f
C3647 _168_/a_382_47# _077_ 0.00333f
C3648 _282_/a_27_47# _296_/a_761_289# 0
C3649 _282_/a_193_47# _296_/a_193_47# 0
C3650 net60 _299_/a_448_47# 0.00186f
C3651 _044_ _299_/a_1283_21# 0
C3652 net33 _181_/a_113_47# 0
C3653 _179_/a_377_297# _092_ 0
C3654 _268_/a_651_413# clknet_2_3__leaf_clk_regs 0.00166f
C3655 _281_/a_27_47# net30 0.02687f
C3656 net39 pmu_inst/dc_inst.x4.x11/a_27_47# 0.00283f
C3657 _067_ _148_/a_27_413# 0
C3658 net4 _280_/a_193_47# 0.02413f
C3659 net17 _295_/a_193_47# 0
C3660 clknet_2_1__leaf_clk_regs a[7] 0
C3661 clk _262_/a_1270_413# 0
C3662 clkbuf_2_2__f_clk_regs/a_110_47# genblk1\[9\].fa_inst.b 0
C3663 net47 pmu_inst/dc_inst.net1 0
C3664 _256_/a_1217_47# net46 0
C3665 clk _269_/a_27_47# 0.00411f
C3666 _300_/a_193_47# VPWR 0.01944f
C3667 net55 net70 1.15942f
C3668 _275_/a_448_47# genblk1\[3\].fa_inst.a 0
C3669 _291_/a_543_47# _290_/a_193_47# 0
C3670 _274_/a_651_413# net11 0
C3671 _262_/a_193_47# net62 0.19629f
C3672 _296_/a_1217_47# net30 0
C3673 clkbuf_2_3__f_clk_regs/a_110_47# _266_/a_1283_21# 0.01081f
C3674 net47 pmu_inst/_24_/a_543_47# 0.00192f
C3675 _148_/a_27_413# _068_ 0
C3676 _277_/a_27_47# net27 0.00153f
C3677 VPWR _262_/a_543_47# 0.01575f
C3678 _183_/a_298_297# _093_ 0
C3679 VPWR _285_/a_1270_413# 0
C3680 _143_/a_215_297# _060_ 0
C3681 _276_/a_448_47# clknet_2_1__leaf_clk_regs 0.00188f
C3682 _083_ _084_ 0.13961f
C3683 _021_ _291_/a_1270_413# 0
C3684 clknet_2_3__leaf_clk_regs _298_/a_761_289# 0
C3685 genblk1\[15\].fa_inst.b genblk1\[15\].fa_inst.a 0.182f
C3686 genblk1\[4\].fa_inst.a _061_ 0
C3687 net6 b[8] 0.04299f
C3688 cout_next pmu_inst/dc_inst.x1.net11 0
C3689 _304_/a_1217_47# net56 0
C3690 _289_/a_1462_47# net11 0
C3691 _035_ net12 0.00134f
C3692 _259_/a_27_47# clknet_2_0__leaf_clk_regs 0.18666f
C3693 net50 output50/a_27_47# 0.01331f
C3694 clknet_0_clk_regs _263_/a_639_47# 0
C3695 _178_/a_27_413# net59 0
C3696 net61 _268_/a_761_289# 0.00206f
C3697 s[1] s[2] 0
C3698 net7 _284_/a_543_47# 0.01757f
C3699 genblk1\[3\].fa_inst.a net56 0.09319f
C3700 VPWR _264_/a_1283_21# 0.03753f
C3701 _271_/a_805_47# net38 0
C3702 _299_/a_1283_21# net19 0
C3703 _003_ net48 0.01869f
C3704 _287_/a_1108_47# clknet_2_3__leaf_clk_regs 0
C3705 net26 _023_ 0
C3706 net4 net30 0.04557f
C3707 genblk1\[10\].fa_inst.b _298_/a_1283_21# 0.00128f
C3708 net39 pmu_inst/dc_inst.x1.net3 0
C3709 _004_ clkbuf_2_0__f_clk_regs/a_110_47# 0
C3710 _302_/a_543_47# _286_/a_1283_21# 0
C3711 _302_/a_761_289# _286_/a_1108_47# 0
C3712 VPWR _266_/a_761_289# 0.00687f
C3713 _131_/a_150_297# _054_ 0
C3714 _129_/a_47_47# VPWR 0.04017f
C3715 net14 _279_/a_27_47# 0.15489f
C3716 _077_ genblk1\[6\].fa_inst.a 0
C3717 _294_/a_1108_47# clknet_2_1__leaf_clk_regs 0
C3718 _267_/a_651_413# clknet_2_3__leaf_clk_regs 0.00272f
C3719 net26 net3 0.02164f
C3720 _293_/a_448_47# genblk1\[6\].fa_inst.a 0.01375f
C3721 fanout59/a_27_47# net59 0.00666f
C3722 VPWR pmu_inst/dc_inst.x1.net7 0.00301f
C3723 _304_/a_543_47# net33 0.00164f
C3724 _304_/a_761_289# _049_ 0
C3725 _292_/a_193_47# net26 0.00345f
C3726 net29 _282_/a_448_47# 0.01071f
C3727 net29 _279_/a_27_47# 0
C3728 _287_/a_651_413# net60 0.0034f
C3729 net59 _298_/a_1108_47# 0.00491f
C3730 s[12] VPWR 0.39886f
C3731 net17 genblk1\[2\].fa_inst.b 0.028f
C3732 genblk1\[1\].fa_inst.a _288_/a_761_289# 0
C3733 _276_/a_448_47# net11 0.0056f
C3734 _281_/a_1217_47# net30 0
C3735 _264_/a_448_47# genblk1\[9\].fa_inst.s 0.00158f
C3736 net39 pmu_inst/dc_inst.x4.x18/a_27_47# 0.00162f
C3737 genblk1\[0\].fa_inst.b net56 0.10687f
C3738 VPWR _289_/a_761_289# 0.01573f
C3739 _302_/a_761_289# genblk1\[14\].fa_inst.b 0
C3740 _102_ _190_/a_68_297# 0
C3741 clknet_2_2__leaf_clk_regs _082_ 0
C3742 genblk1\[2\].fa_inst.s net56 0
C3743 VPWR _284_/a_1270_413# -0
C3744 _272_/a_27_47# _288_/a_543_47# 0
C3745 _300_/a_1462_47# VPWR 0.00209f
C3746 _020_ genblk1\[3\].fa_inst.a 0.1871f
C3747 _257_/a_761_289# genblk1\[2\].fa_inst.s 0
C3748 _257_/a_193_47# _002_ 0.00997f
C3749 net61 net40 0.08053f
C3750 net43 net60 0.09756f
C3751 _300_/a_761_289# _285_/a_27_47# 0
C3752 _300_/a_193_47# _285_/a_193_47# 0
C3753 _300_/a_27_47# _285_/a_761_289# 0
C3754 net24 b[0] 0
C3755 net47 pmu_inst/_25_/a_1283_21# 0.009f
C3756 clk genblk1\[7\].fa_inst.s 0.00116f
C3757 net47 pmu_inst/dc_inst.x8/a_757_363# 0
C3758 _039_ _279_/a_1108_47# 0
C3759 _268_/a_448_47# net43 0
C3760 _268_/a_639_47# _013_ 0
C3761 _276_/a_27_47# VPWR 0.07973f
C3762 _092_ genblk1\[10\].fa_inst.b 0
C3763 _285_/a_1283_21# _285_/a_1108_47# 0
C3764 _290_/a_1283_21# net56 0.00536f
C3765 clknet_2_1__leaf_clk_regs _278_/a_448_47# 0.02543f
C3766 _294_/a_193_47# VPWR 0.03204f
C3767 net61 _267_/a_761_289# 0.00149f
C3768 _302_/a_27_47# _301_/a_193_47# 0
C3769 _302_/a_193_47# _301_/a_27_47# 0
C3770 _029_ genblk1\[11\].fa_inst.a 0.00152f
C3771 clknet_0_clk_regs net53 1.72743f
C3772 genblk1\[2\].fa_inst.s _304_/a_1270_413# 0
C3773 _291_/a_651_413# net36 0.00246f
C3774 genblk1\[14\].fa_inst.s _108_ 0.00331f
C3775 _095_ net35 0
C3776 _047_ net20 0.00157f
C3777 _130_/a_215_297# _053_ 0.04492f
C3778 input3/a_27_47# net13 0
C3779 clknet_2_0__leaf_clk_regs _260_/a_193_47# 0.01475f
C3780 _039_ net62 0.11749f
C3781 _168_/a_215_297# _079_ 0
C3782 _164_/a_285_47# _159_/a_47_47# 0
C3783 net22 _286_/a_761_289# 0
C3784 _302_/a_193_47# _031_ 0
C3785 net46 pmu_inst/dc_inst.x6.x2/a_27_47# 0.00278f
C3786 _065_ _071_ 0
C3787 _263_/a_193_47# net62 0
C3788 _274_/a_1270_413# VPWR 0
C3789 genblk1\[3\].fa_inst.a _055_ 0.00166f
C3790 net58 _278_/a_1270_413# 0
C3791 genblk1\[10\].fa_inst.a _296_/a_1283_21# 0
C3792 net29 _027_ 0
C3793 net7 _296_/a_761_289# 0
C3794 _088_ _170_/a_68_297# 0
C3795 net59 net18 0
C3796 _021_ net33 0
C3797 _052_ hold1/a_49_47# 0
C3798 clknet_0_clk_regs _076_ 0.00294f
C3799 _009_ genblk1\[9\].fa_inst.s 0
C3800 _264_/a_27_47# _264_/a_193_47# -0
C3801 genblk1\[13\].fa_inst.a _193_/a_382_47# 0
C3802 _298_/a_27_47# net18 0.03776f
C3803 net42 net60 0.03159f
C3804 _037_ net56 0
C3805 clkload0/Y clknet_0_clk_regs 0.06476f
C3806 _279_/a_193_47# _278_/a_448_47# 0
C3807 clkbuf_0_clk/a_110_47# net62 0.02873f
C3808 VPWR pmu_inst/_09_ 0
C3809 _292_/a_27_47# _292_/a_639_47# -0.0015f
C3810 _076_ _071_ 0.00192f
C3811 output45/a_27_47# s[15] 0.00932f
C3812 _257_/a_639_47# net47 0
C3813 _259_/a_448_47# clknet_2_0__leaf_clk_regs 0.00405f
C3814 _085_ _092_ 0.0428f
C3815 _013_ net43 -0
C3816 genblk1\[0\].fa_inst.b _055_ 0
C3817 net47 pmu_inst/dc_inst.x9/a_27_47# 0.00114f
C3818 VPWR _007_ -0.01024f
C3819 VPWR _286_/a_1270_413# 0
C3820 _285_/a_27_47# genblk1\[13\].fa_inst.a 0
C3821 net58 net16 0.05742f
C3822 net4 _279_/a_651_413# 0.00353f
C3823 _026_ _025_ 0
C3824 _270_/a_193_47# net62 0
C3825 VPWR _201_/a_637_47# -0.00126f
C3826 genblk1\[2\].fa_inst.s _055_ 0
C3827 _293_/a_1462_47# _038_ -0
C3828 VPWR net14 1.30943f
C3829 _039_ net7 0
C3830 _291_/a_1108_47# _276_/a_1283_21# 0
C3831 _198_/a_27_413# genblk1\[13\].fa_inst.s 0
C3832 _294_/a_1283_21# _024_ 0
C3833 VPWR _296_/a_651_413# 0.00145f
C3834 net29 VPWR 1.01264f
C3835 _294_/a_761_289# net3 0.00763f
C3836 _287_/a_27_47# net36 0
C3837 fanout60/a_27_47# net44 0
C3838 net46 pmu_inst/_18_/a_76_199# 0
C3839 VPWR _061_ 0.69789f
C3840 _164_/a_129_47# _080_ 0.00196f
C3841 _078_ _160_/a_68_297# 0
C3842 _282_/a_639_47# clknet_2_2__leaf_clk_regs 0
C3843 _282_/a_1283_21# genblk1\[9\].fa_inst.a 0
C3844 a[11] net36 0
C3845 net68 pmu_inst_68/HI 0.00734f
C3846 _294_/a_193_47# net2 0.0314f
C3847 net25 input25/a_75_212# 0.00214f
C3848 net7 _281_/a_761_289# 0.00903f
C3849 _287_/a_761_289# genblk1\[15\].fa_inst.a 0
C3850 _287_/a_1108_47# _032_ 0.00597f
C3851 _302_/a_761_289# clknet_2_2__leaf_clk_regs 0
C3852 genblk1\[13\].fa_inst.a _104_ 0
C3853 _290_/a_27_47# _290_/a_1108_47# -0
C3854 _107_ cout_next 0
C3855 clknet_0_clk_regs _265_/a_1108_47# 0.00839f
C3856 _275_/a_1283_21# _273_/a_1108_47# 0
C3857 _275_/a_1108_47# _273_/a_1283_21# 0
C3858 _267_/a_448_47# net42 0
C3859 a[0] input9/a_75_212# 0
C3860 input1/a_75_212# a[2] 0
C3861 _277_/a_27_47# net58 0.01143f
C3862 _301_/a_761_289# VPWR 0.0082f
C3863 VPWR pmu_inst/dc_inst.x7.x7/a_27_47# 0.00675f
C3864 net47 net73 0.00965f
C3865 net5 a[15] 0
C3866 VPWR _263_/a_448_47# 0
C3867 _300_/a_193_47# net20 0.00573f
C3868 _300_/a_27_47# _045_ -0
C3869 net33 _160_/a_150_297# 0
C3870 _303_/a_27_47# VPWR 0.0266f
C3871 _292_/a_27_47# genblk1\[4\].fa_inst.b 0
C3872 _292_/a_543_47# _037_ -0
C3873 _292_/a_1283_21# net27 0
C3874 VPWR input29/a_75_212# 0.09161f
C3875 b[8] net31 0.00149f
C3876 _051_ _050_ 0.05702f
C3877 _300_/a_1283_21# genblk1\[13\].fa_inst.a 0
C3878 net72 pmu_inst/dc_inst.x6.x3/a_27_47# -0
C3879 net46 pmu_inst/dc_inst.x5.x15/a_27_47# 0
C3880 VPWR _288_/a_1270_413# 0
C3881 VPWR pmu_inst/dc_inst.x6.x8/a_27_47# 0
C3882 VPWR _281_/a_651_413# 0.00128f
C3883 _273_/a_543_47# net56 0
C3884 _127_/a_113_47# _051_ 0
C3885 genblk1\[6\].fa_inst.b _077_ 0
C3886 _297_/a_651_413# net30 0.00348f
C3887 fanout62/a_110_47# net44 0.09163f
C3888 _285_/a_1217_47# genblk1\[13\].fa_inst.a 0
C3889 clknet_0_clk VPWR 0.05551f
C3890 _270_/a_1462_47# net62 0
C3891 genblk1\[13\].fa_inst.a _190_/a_150_297# 0
C3892 _015_ net44 0
C3893 _294_/a_27_47# _280_/a_1108_47# 0
C3894 net3 _295_/a_27_47# 0.01853f
C3895 _302_/a_651_413# net21 0.00455f
C3896 genblk1\[4\].fa_inst.b net33 0.10248f
C3897 _163_/a_27_413# net62 0
C3898 net26 _280_/a_27_47# 0.04003f
C3899 net55 pmu_inst/dc_inst.x5.net12 0.00841f
C3900 _130_/a_215_297# VPWR -0.00415f
C3901 _291_/a_1283_21# fanout56/a_27_47# 0.01298f
C3902 _269_/a_543_47# _268_/a_193_47# 0
C3903 _269_/a_27_47# _268_/a_1283_21# 0
C3904 _269_/a_193_47# _268_/a_543_47# 0
C3905 net46 net64 0.04736f
C3906 VPWR pmu_inst/dc_inst.x7.x5/a_27_47# 0.00247f
C3907 _270_/a_448_47# VPWR 0
C3908 _037_ _277_/a_1283_21# 0
C3909 genblk1\[10\].fa_inst.a clknet_2_2__leaf_clk_regs 0.02861f
C3910 clknet_2_2__leaf_clk_regs _174_/a_285_47# 0.01909f
C3911 _256_/a_1270_413# net57 0
C3912 VPWR _278_/a_651_413# 0.00132f
C3913 net2 net14 0.0328f
C3914 _290_/a_27_47# net25 0.11447f
C3915 _199_/a_47_47# _201_/a_217_297# 0.01353f
C3916 fanout60/a_27_47# VPWR 0.05381f
C3917 _054_ clknet_2_0__leaf_clk_regs 0
C3918 _304_/a_543_47# _059_ 0
C3919 net47 net36 0.02361f
C3920 net33 _295_/a_193_47# 0
C3921 _168_/a_215_297# VPWR 0.01662f
C3922 net29 net2 0.0104f
C3923 _286_/a_543_47# net6 0
C3924 _275_/a_1108_47# clknet_2_1__leaf_clk_regs 0.00127f
C3925 _275_/a_543_47# _018_ 0
C3926 _275_/a_27_47# genblk1\[1\].fa_inst.a 0
C3927 _293_/a_27_47# _278_/a_27_47# 0
C3928 _283_/a_1108_47# _297_/a_1108_47# 0.00103f
C3929 VPWR pmu_inst/dc_inst.x4.net15 0
C3930 _167_/a_113_47# _082_ 0
C3931 _282_/a_1283_21# _297_/a_1108_47# 0
C3932 _282_/a_1108_47# _297_/a_1283_21# 0
C3933 _282_/a_651_413# _297_/a_761_289# 0
C3934 _012_ net42 0.06155f
C3935 _284_/a_27_47# genblk1\[12\].fa_inst.a 0
C3936 _284_/a_543_47# _029_ -0
C3937 _255_/a_651_413# genblk1\[1\].fa_inst.s 0
C3938 genblk1\[0\].fa_inst.s _134_/a_47_47# 0
C3939 genblk1\[4\].fa_inst.s VPWR 1.8754f
C3940 _264_/a_543_47# net54 0
C3941 _264_/a_448_47# _009_ 0
C3942 net25 net13 0.02524f
C3943 output54/a_27_47# net54 0.0207f
C3944 _103_ _104_ 0.19294f
C3945 _060_ _058_ 0.1584f
C3946 _290_/a_1270_413# net36 0
C3947 VPWR _008_ 0.14312f
C3948 _303_/a_1217_47# VPWR 0
C3949 net46 pmu_inst/dc_inst.x2.net15 0.01288f
C3950 _183_/a_215_297# _089_ 0.10899f
C3951 _274_/a_543_47# net10 0
C3952 _169_/a_47_47# _083_ 0.02434f
C3953 net56 _135_/a_27_413# 0.01624f
C3954 _031_ _285_/a_543_47# 0
C3955 genblk1\[14\].fa_inst.a _285_/a_27_47# 0
C3956 output39/a_27_47# s[0] 0.00963f
C3957 genblk1\[4\].fa_inst.a net56 0.01806f
C3958 _047_ _046_ 0
C3959 _097_ genblk1\[11\].fa_inst.b 0.00799f
C3960 fanout62/a_110_47# VPWR 0.06883f
C3961 _275_/a_448_47# a[4] 0
C3962 net47 pmu_inst/dc_inst.x7.net4 0.00146f
C3963 _178_/a_27_413# _088_ 0.00278f
C3964 _015_ VPWR 0.24852f
C3965 _048_ net7 0
C3966 net5 _285_/a_1283_21# 0
C3967 cin_q hold1/a_49_47# 0.02781f
C3968 _277_/a_1108_47# _036_ 0
C3969 net28 _041_ 0.02797f
C3970 genblk1\[12\].fa_inst.b _299_/a_1108_47# 0
C3971 net56 _053_ 0.06521f
C3972 _259_/a_761_289# clkbuf_2_0__f_clk_regs/a_110_47# 0
C3973 _294_/a_27_47# _279_/a_27_47# 0
C3974 net3 _280_/a_651_413# 0.00348f
C3975 fanout61/a_27_47# clknet_2_3__leaf_clk_regs 0
C3976 clk _199_/a_47_47# 0
C3977 _257_/a_27_47# genblk1\[1\].fa_inst.s 0
C3978 pmu_inst/dc_inst.x1.net7 net65 0
C3979 net33 genblk1\[2\].fa_inst.b 0.45025f
C3980 clknet_2_0__leaf_clk_regs _255_/a_27_47# 0.01514f
C3981 net61 _269_/a_761_289# 0.00239f
C3982 _298_/a_1108_47# net30 0.0085f
C3983 _289_/a_543_47# net24 0
C3984 _289_/a_761_289# _034_ -0
C3985 net33 _082_ 0
C3986 _283_/a_1283_21# _042_ 0
C3987 clkbuf_2_3__f_clk_regs/a_110_47# _265_/a_1283_21# 0
C3988 _301_/a_1283_21# _300_/a_543_47# 0
C3989 _301_/a_651_413# _300_/a_27_47# 0
C3990 _098_ net60 0
C3991 net26 genblk1\[5\].fa_inst.a 0
C3992 _282_/a_543_47# _042_ 0
C3993 _027_ _297_/a_543_47# 0
C3994 net6 input20/a_75_212# 0
C3995 _284_/a_1217_47# genblk1\[12\].fa_inst.a 0
C3996 input23/a_75_212# b[15] 0.01461f
C3997 _004_ net48 0.00373f
C3998 net15 b[0] 0.00188f
C3999 net47 pmu_inst/dc_inst.x3.net10 0.00633f
C4000 net33 _144_/a_47_47# 0
C4001 _259_/a_1270_413# net57 0
C4002 genblk1\[7\].fa_inst.a genblk1\[6\].fa_inst.a 0
C4003 genblk1\[9\].fa_inst.b _297_/a_448_47# 0
C4004 net73 net51 0
C4005 net5 a[14] 0
C4006 _025_ net59 0
C4007 clknet_0_clk_regs _092_ 0
C4008 net46 output46/a_27_47# 0.0216f
C4009 _067_ net58 0
C4010 _188_/a_27_413# genblk1\[11\].fa_inst.b 0
C4011 _271_/a_543_47# net62 0
C4012 cout_next _204_/a_33_297# 0.00151f
C4013 _294_/a_761_289# _280_/a_27_47# 0
C4014 _271_/a_1270_413# net44 0
C4015 net20 _286_/a_1270_413# 0
C4016 _300_/a_1283_21# genblk1\[14\].fa_inst.a 0
C4017 _068_ _063_ 0.06914f
C4018 net35 pmu_inst/clknet_1_0__leaf_clk -0
C4019 _261_/a_761_289# genblk1\[6\].fa_inst.s 0.00213f
C4020 _261_/a_193_47# _006_ 0
C4021 _284_/a_543_47# net31 0.00272f
C4022 _068_ net58 0.03143f
C4023 _283_/a_1270_413# net59 0
C4024 _286_/a_27_47# _286_/a_639_47# -0.0015f
C4025 _291_/a_27_47# VPWR 0.06431f
C4026 net27 _295_/a_651_413# 0.00452f
C4027 net28 _026_ 0.00129f
C4028 VPWR _265_/a_761_289# 0.01419f
C4029 _274_/a_27_47# genblk1\[2\].fa_inst.a 0
C4030 _277_/a_805_47# net58 0
C4031 _107_ _204_/a_33_297# 0
C4032 _272_/a_448_47# net56 0.02496f
C4033 _268_/a_193_47# net62 0
C4034 net6 b[11] 0.19319f
C4035 _020_ a[4] 0
C4036 clk _262_/a_193_47# 0.26797f
C4037 cout_next _109_ 0.00681f
C4038 VPWR _297_/a_543_47# 0.01822f
C4039 _096_ _177_/a_113_47# 0
C4040 net39 pmu_inst/dc_inst.x2.net1 0.00307f
C4041 _135_/a_27_413# _055_ 0.02628f
C4042 clknet_2_2__leaf_clk_regs _264_/a_27_47# 0.03562f
C4043 _179_/a_285_47# _090_ 0
C4044 s[13] net43 0.09627f
C4045 genblk1\[12\].fa_inst.b net19 0
C4046 _050_ _134_/a_285_47# 0
C4047 genblk1\[2\].fa_inst.a _289_/a_1108_47# 0.00818f
C4048 _290_/a_27_47# clknet_2_1__leaf_clk_regs 0.04399f
C4049 _290_/a_639_47# genblk1\[2\].fa_inst.b 0
C4050 _295_/a_193_47# _295_/a_543_47# -0.009f
C4051 clk _264_/a_805_47# 0
C4052 net46 pmu_inst/dc_inst.x2.net7 0
C4053 net29 _296_/a_27_47# 0.02466f
C4054 net27 _280_/a_543_47# 0.00529f
C4055 _180_/a_150_297# VPWR -0
C4056 _292_/a_1283_21# net58 0.0178f
C4057 _293_/a_1108_47# _150_/a_68_297# 0
C4058 _107_ _109_ 0
C4059 net18 net30 0.01539f
C4060 clk _266_/a_1270_413# 0
C4061 net49 net35 0.02825f
C4062 _259_/a_193_47# net36 0.00332f
C4063 _023_ _279_/a_761_289# 0
C4064 _302_/a_761_289# _287_/a_193_47# 0
C4065 _302_/a_193_47# _287_/a_761_289# 0
C4066 _302_/a_543_47# _287_/a_27_47# 0
C4067 _301_/a_193_47# _045_ 0
C4068 _046_ _300_/a_193_47# 0
C4069 _182_/a_113_47# VPWR -0
C4070 clkbuf_2_3__f_clk_regs/a_110_47# clknet_2_3__leaf_clk_regs 0.05722f
C4071 _255_/a_639_47# VPWR 0
C4072 _145_/a_68_297# _150_/a_68_297# 0
C4073 clknet_2_1__leaf_clk_regs net13 0.36398f
C4074 _053_ _055_ 0.01123f
C4075 net3 _283_/a_639_47# 0
C4076 _276_/a_1283_21# _035_ 0.00372f
C4077 _140_/a_68_297# _061_ 0.00169f
C4078 net3 _279_/a_761_289# 0.01398f
C4079 genblk1\[7\].fa_inst.b _295_/a_639_47# 0
C4080 net7 _297_/a_639_47# 0.00104f
C4081 _259_/a_1108_47# VPWR 0.02645f
C4082 net25 _280_/a_193_47# 0
C4083 _280_/a_27_47# _295_/a_27_47# 0
C4084 genblk1\[9\].fa_inst.b _042_ 0.06526f
C4085 _301_/a_27_47# _286_/a_543_47# 0.00347f
C4086 genblk1\[3\].fa_inst.a _272_/a_543_47# 0
C4087 _063_ _139_/a_47_47# 0
C4088 _294_/a_193_47# net4 0.02763f
C4089 _275_/a_448_47# VPWR 0.0026f
C4090 clknet_0_clk_regs _261_/a_1108_47# 0
C4091 VPWR b[13] 0.2369f
C4092 VPWR pmu_inst/_06_ 0.02463f
C4093 _144_/a_377_297# net36 0
C4094 _294_/a_27_47# VPWR 0.09202f
C4095 net39 pmu_inst/dc_inst.x4.x16/a_27_47# 0.00208f
C4096 net39 pmu_inst/dc_inst.x5.x5/a_27_47# 0
C4097 _290_/a_27_47# net11 0.03091f
C4098 _261_/a_639_47# net51 0
C4099 _267_/a_193_47# net62 0
C4100 net10 net9 0.00135f
C4101 _256_/a_1108_47# genblk1\[0\].fa_inst.s 0
C4102 _256_/a_1283_21# _000_ 0
C4103 _256_/a_193_47# net39 0.00114f
C4104 _001_ _255_/a_1283_21# 0.00393f
C4105 net46 _255_/a_193_47# 0
C4106 _200_/a_145_75# genblk1\[15\].fa_inst.a 0
C4107 _286_/a_27_47# genblk1\[14\].fa_inst.a 0
C4108 _286_/a_543_47# _031_ -0
C4109 net47 pmu_inst/_23_/a_27_47# 0.01252f
C4110 _291_/a_1217_47# VPWR 0
C4111 _271_/a_1270_413# VPWR -0
C4112 VPWR _299_/a_543_47# 0.05038f
C4113 clknet_2_1__leaf_clk_regs _261_/a_193_47# 0.00938f
C4114 _175_/a_68_297# _089_ 0.00413f
C4115 _283_/a_543_47# net18 0
C4116 _283_/a_761_289# _043_ 0
C4117 _028_ _298_/a_761_289# 0.00112f
C4118 _017_ net56 0.56402f
C4119 _051_ _135_/a_215_297# 0
C4120 net29 _281_/a_27_47# 0.02756f
C4121 _281_/a_651_413# _296_/a_27_47# 0
C4122 _022_ net16 0.00277f
C4123 _274_/a_448_47# net9 0.00574f
C4124 _257_/a_1283_21# clknet_2_0__leaf_clk_regs 0
C4125 _188_/a_215_297# _099_ 0
C4126 net11 net13 0
C4127 VPWR net56 2.98292f
C4128 _283_/a_27_47# net36 0
C4129 _184_/a_285_47# _096_ 0.00633f
C4130 VPWR net60 5.33217f
C4131 genblk1\[2\].fa_inst.a net24 0
C4132 _257_/a_761_289# VPWR 0
C4133 _152_/a_113_47# genblk1\[5\].fa_inst.b 0
C4134 _100_ net60 0
C4135 net25 net30 0
C4136 _296_/a_761_289# net31 0
C4137 _296_/a_193_47# _041_ 0
C4138 net28 _297_/a_761_289# 0
C4139 VPWR _268_/a_448_47# 0
C4140 _139_/a_47_47# _057_ 0.02466f
C4141 net26 _024_ 0
C4142 VPWR pmu_inst/dc_inst.x9/a_247_21# 0
C4143 net14 _278_/a_27_47# 0
C4144 VPWR genblk1\[10\].fa_inst.b 1.12311f
C4145 b[5] input29/a_75_212# 0
C4146 input28/a_75_212# b[6] 0.00367f
C4147 _103_ genblk1\[13\].fa_inst.s 0.04108f
C4148 net7 _299_/a_639_47# 0
C4149 net39 VPWR 4.2605f
C4150 net58 _261_/a_543_47# 0
C4151 net3 genblk1\[11\].fa_inst.a 0.00203f
C4152 _183_/a_27_413# genblk1\[10\].fa_inst.a 0
C4153 _303_/a_448_47# b[15] 0
C4154 _303_/a_1108_47# net23 0
C4155 _076_ _074_ 0.00166f
C4156 VPWR b[14] 0.23729f
C4157 _178_/a_27_413# _087_ 0
C4158 _085_ _174_/a_47_47# 0
C4159 _286_/a_448_47# b[11] 0
C4160 net59 _086_ 0
C4161 genblk1\[1\].fa_inst.b _288_/a_1108_47# 0
C4162 net33 _153_/a_215_297# 0
C4163 net4 net14 0.02509f
C4164 _294_/a_651_413# _279_/a_193_47# 0
C4165 _277_/a_27_47# _022_ 0.00178f
C4166 clk _263_/a_193_47# 0.04585f
C4167 VPWR _298_/a_193_47# 0.05211f
C4168 clknet_0_clk_regs genblk1\[6\].fa_inst.s 0
C4169 _020_ VPWR 0.13557f
C4170 _079_ genblk1\[7\].fa_inst.b 0
C4171 VPWR pmu_inst/dc_inst.x4.x17/a_27_47# 0
C4172 net29 net4 3.26545f
C4173 _092_ genblk1\[9\].fa_inst.b 0.02554f
C4174 _288_/a_27_47# _288_/a_639_47# -0.0015f
C4175 _286_/a_1283_21# clknet_2_2__leaf_clk_regs 0.00104f
C4176 _290_/a_1217_47# net11 0
C4177 _260_/a_1283_21# net50 0.00192f
C4178 _260_/a_651_413# _005_ 0.00151f
C4179 _256_/a_1462_47# net39 0
C4180 net46 _255_/a_1462_47# 0
C4181 _277_/a_193_47# _036_ 0
C4182 genblk1\[8\].fa_inst.b _173_/a_215_297# 0
C4183 _165_/a_68_297# _081_ 0.00127f
C4184 net47 pmu_inst/_23_/a_1217_47# 0
C4185 net33 genblk1\[10\].fa_inst.a 0.3689f
C4186 delay_sel[2] net35 0
C4187 clknet_2_1__leaf_clk_regs _261_/a_1462_47# 0
C4188 clkbuf_0_clk/a_110_47# clk 0.01305f
C4189 VPWR _287_/a_1283_21# 0.07599f
C4190 _285_/a_1283_21# _299_/a_27_47# 0.00161f
C4191 clknet_2_2__leaf_clk_regs _296_/a_543_47# 0
C4192 _026_ _296_/a_193_47# 0
C4193 _281_/a_193_47# _041_ 0
C4194 genblk1\[0\].fa_inst.a _126_/a_68_297# 0.01439f
C4195 _292_/a_1108_47# clknet_2_0__leaf_clk_regs 0.04036f
C4196 _019_ net9 0.00498f
C4197 _183_/a_382_47# VPWR -0
C4198 VPWR _267_/a_448_47# 0
C4199 _294_/a_27_47# net2 0.0267f
C4200 genblk1\[6\].fa_inst.b genblk1\[7\].fa_inst.a 0.02383f
C4201 net7 _298_/a_651_413# 0.00253f
C4202 genblk1\[2\].fa_inst.b _059_ 0.10385f
C4203 _292_/a_543_47# VPWR 0.01601f
C4204 clknet_2_1__leaf_clk_regs _295_/a_1108_47# 0
C4205 input20/a_75_212# b[12] 0.01942f
C4206 VPWR _085_ 0.50947f
C4207 _270_/a_193_47# clk 0.00293f
C4208 _285_/a_193_47# net60 0
C4209 net46 pmu_inst/dc_inst.in 0.00136f
C4210 _022_ _291_/a_193_47# 0
C4211 _296_/a_1462_47# _041_ 0
C4212 VPWR _013_ 0.04555f
C4213 net46 pmu_inst/dc_inst.x4.x11/a_27_47# 0
C4214 VPWR pmu_inst/dc_inst.net2 0.00318f
C4215 cout_next net70 0.09729f
C4216 _258_/a_27_47# net48 0.00108f
C4217 _269_/a_27_47# _269_/a_1283_21# -0
C4218 _188_/a_298_297# net35 0.03868f
C4219 s[10] s[11] 0
C4220 VPWR _055_ 0.13645f
C4221 _290_/a_193_47# VPWR 0.03628f
C4222 _277_/a_761_289# net12 0
C4223 _303_/a_193_47# _303_/a_543_47# -0.01719f
C4224 net24 net16 0.01918f
C4225 clknet_2_1__leaf_clk_regs _280_/a_193_47# 0.00155f
C4226 _025_ _295_/a_1108_47# 0
C4227 _280_/a_1108_47# _040_ 0
C4228 clknet_2_2__leaf_clk_regs _263_/a_761_289# 0
C4229 _301_/a_1270_413# _031_ 0
C4230 _031_ b[11] 0
C4231 genblk1\[1\].fa_inst.b net17 0.02802f
C4232 net47 pmu_inst/dc_inst.x1.x1/a_27_47# 0
C4233 net39 pmu_inst_64/HI 0.00375f
C4234 clk _263_/a_1462_47# 0
C4235 VPWR _298_/a_1462_47# 0.00209f
C4236 _130_/a_382_47# genblk1\[1\].fa_inst.s 0
C4237 _277_/a_1283_21# VPWR 0.05093f
C4238 b[12] b[11] 0.10601f
C4239 clkload0/a_361_47# _260_/a_1108_47# 0.00425f
C4240 net28 net59 0.45928f
C4241 net39 pmu_inst/dc_inst.x4.net12 0.00365f
C4242 _281_/a_543_47# clknet_2_2__leaf_clk_regs 0
C4243 _281_/a_193_47# _026_ 0
C4244 net17 _281_/a_543_47# 0
C4245 _204_/a_33_297# _109_ 0.02913f
C4246 _284_/a_1283_21# _299_/a_27_47# 0
C4247 input32/a_75_212# b[9] 0.01391f
C4248 _288_/a_543_47# _033_ -0
C4249 _288_/a_1283_21# net17 0
C4250 net28 _298_/a_27_47# 0
C4251 net22 net34 0.00226f
C4252 _144_/a_47_47# _064_ 0.0309f
C4253 _280_/a_193_47# _025_ 0.00117f
C4254 net4 _278_/a_651_413# 0.00353f
C4255 net58 _280_/a_543_47# 0
C4256 output55/a_27_47# net70 0.05886f
C4257 net46 pmu_inst/dc_inst.x1.net3 0.00414f
C4258 _294_/a_761_289# _024_ 0
C4259 _281_/a_1462_47# _041_ 0
C4260 net27 clknet_2_0__leaf_clk_regs 0.04357f
C4261 _294_/a_543_47# _280_/a_543_47# 0
C4262 clknet_2_3__leaf_clk_regs cout_next 0.09287f
C4263 VPWR _012_ 0.11129f
C4264 _300_/a_1108_47# net60 0.00617f
C4265 _275_/a_193_47# net10 0.0897f
C4266 _273_/a_1108_47# genblk1\[1\].fa_inst.a 0.00475f
C4267 _165_/a_68_297# genblk1\[8\].fa_inst.a 0.06612f
C4268 net47 pmu_inst/dc_inst.x7.x19/a_27_47# 0.00245f
C4269 clknet_2_1__leaf_clk_regs net30 0
C4270 _148_/a_27_413# _062_ 0.02567f
C4271 _285_/a_1462_47# net60 0
C4272 _022_ _291_/a_1462_47# 0
C4273 _301_/a_761_289# _046_ 0.00473f
C4274 _301_/a_543_47# net21 0
C4275 VPWR _261_/a_761_289# 0.00972f
C4276 clknet_2_1__leaf_clk_regs _164_/a_285_47# 0
C4277 _169_/a_129_47# VPWR -0
C4278 _273_/a_1108_47# _272_/a_193_47# 0
C4279 _275_/a_27_47# _274_/a_651_413# 0
C4280 _275_/a_448_47# _274_/a_193_47# 0
C4281 _273_/a_27_47# _272_/a_448_47# 0
C4282 output40/a_27_47# s[10] 0.00932f
C4283 _276_/a_543_47# _035_ 0.01698f
C4284 _066_ _061_ 0
C4285 net46 pmu_inst/dc_inst.x2.x18/a_27_47# 0.00102f
C4286 _284_/a_761_289# net59 0
C4287 _266_/a_1283_21# clknet_2_3__leaf_clk_regs 0
C4288 net39 pmu_inst/dc_inst.x1.net5 0
C4289 _139_/a_285_47# _058_ 0
C4290 _290_/a_1462_47# VPWR 0
C4291 genblk1\[4\].fa_inst.s net57 0.00217f
C4292 _292_/a_543_47# net2 0.00656f
C4293 _164_/a_129_47# genblk1\[7\].fa_inst.s 0
C4294 _284_/a_27_47# _298_/a_761_289# 0
C4295 _181_/a_113_47# _029_ 0
C4296 _284_/a_761_289# _298_/a_27_47# 0
C4297 _284_/a_193_47# _298_/a_193_47# 0
C4298 net39 net71 0.35895f
C4299 _258_/a_1270_413# net36 0
C4300 genblk1\[14\].fa_inst.s net60 0
C4301 net27 genblk1\[7\].fa_inst.a 0
C4302 _143_/a_382_47# _057_ 0.00192f
C4303 _025_ net30 0
C4304 _268_/a_448_47# genblk1\[14\].fa_inst.s 0
C4305 genblk1\[8\].fa_inst.a _081_ 0.12164f
C4306 genblk1\[11\].fa_inst.a _175_/a_68_297# 0
C4307 _274_/a_193_47# net56 0
C4308 _291_/a_193_47# net24 0
C4309 clkload0/a_27_47# _005_ 0.00972f
C4310 _281_/a_639_47# genblk1\[9\].fa_inst.a 0
C4311 _284_/a_805_47# clknet_2_3__leaf_clk_regs 0
C4312 output48/a_27_47# VPWR 0.09827f
C4313 VPWR genblk1\[7\].fa_inst.b 0.69458f
C4314 _283_/a_1270_413# net30 0
C4315 _282_/a_651_413# net30 0
C4316 _300_/a_543_47# net19 0.02075f
C4317 _131_/a_68_297# _288_/a_543_47# 0
C4318 _134_/a_129_47# genblk1\[1\].fa_inst.s 0
C4319 _276_/a_761_289# _291_/a_193_47# 0
C4320 _280_/a_639_47# genblk1\[8\].fa_inst.a 0
C4321 fanout59/a_27_47# _264_/a_1283_21# 0.0148f
C4322 net61 _264_/a_193_47# 0
C4323 s[13] s[14] 0
C4324 _198_/a_27_413# _105_ 0
C4325 net7 _295_/a_193_47# 0.03428f
C4326 _097_ _193_/a_215_297# 0.02501f
C4327 net39 pmu_inst/dc_inst.x4.net6 0.00156f
C4328 net33 _141_/a_113_47# 0
C4329 net52 _262_/a_1283_21# 0.0024f
C4330 net20 net60 0.00199f
C4331 VPWR pmu_inst/dc_inst.x1.x14/a_27_47# 0.00229f
C4332 _269_/a_193_47# net62 0
C4333 _094_ genblk1\[12\].fa_inst.a 0.01854f
C4334 _273_/a_761_289# clknet_2_0__leaf_clk_regs 0
C4335 net39 pmu_inst/_18_/a_505_21# 0.00863f
C4336 _020_ _274_/a_193_47# 0
C4337 _275_/a_193_47# _019_ 0.00963f
C4338 _018_ _272_/a_27_47# 0
C4339 _269_/a_448_47# net44 0
C4340 _277_/a_651_413# net56 0
C4341 _273_/a_193_47# net1 0
C4342 _273_/a_27_47# VPWR 0.05118f
C4343 net33 _284_/a_1283_21# 0
C4344 input11/a_75_212# a[4] 0.01942f
C4345 _259_/a_1283_21# clknet_2_0__leaf_clk_regs 0
C4346 VPWR _295_/a_448_47# 0.0021f
C4347 input22/a_75_212# cin 0
C4348 _276_/a_639_47# _035_ 0.0017f
C4349 _303_/a_448_47# genblk1\[15\].fa_inst.b 0
C4350 net49 net62 0.04733f
C4351 _280_/a_1270_413# net62 0
C4352 _300_/a_193_47# net18 0.0012f
C4353 VPWR clkbuf_1_0__f_clk/a_110_47# 0.16439f
C4354 VPWR _173_/a_27_413# 0.06217f
C4355 net39 pmu_inst/dc_inst.x5.x2/a_27_47# 0.00234f
C4356 _129_/a_377_297# genblk1\[0\].fa_inst.b 0
C4357 _129_/a_47_47# _050_ 0.02368f
C4358 b[4] input27/a_75_212# 0.01391f
C4359 net59 _296_/a_193_47# 0.0358f
C4360 _284_/a_805_47# net19 0
C4361 genblk1\[4\].fa_inst.s _066_ 0
C4362 VPWR _280_/a_761_289# 0.01022f
C4363 VPWR pmu_inst/dc_inst.x7.net2 0.01818f
C4364 VPWR _143_/a_298_297# -0
C4365 net54 net59 0.11066f
C4366 _187_/a_113_47# genblk1\[12\].fa_inst.a 0
C4367 _034_ net56 0.02083f
C4368 _174_/a_377_297# _088_ 0
C4369 clk _265_/a_1270_413# 0
C4370 _286_/a_805_47# clknet_2_3__leaf_clk_regs 0
C4371 net61 _266_/a_805_47# 0
C4372 _147_/a_113_47# _065_ 0
C4373 net2 genblk1\[7\].fa_inst.b 0
C4374 _148_/a_298_297# _061_ 0.02554f
C4375 VPWR clknet_0_clk_regs 5.30485f
C4376 _288_/a_193_47# net56 0.00191f
C4377 genblk1\[2\].fa_inst.a _304_/a_27_47# 0
C4378 clknet_2_0__leaf_clk_regs genblk1\[5\].fa_inst.s 0.05534f
C4379 _280_/a_1283_21# genblk1\[7\].fa_inst.a 0
C4380 cout_next _112_ 0.00246f
C4381 _284_/a_1283_21# net35 0.03506f
C4382 delay_sel[1] net35 0.00281f
C4383 VPWR input32/a_75_212# 0.09177f
C4384 _276_/a_448_47# net26 0
C4385 _277_/a_543_47# net16 0.01112f
C4386 input3/a_27_47# net14 0
C4387 VPWR _071_ 0.55273f
C4388 _275_/a_639_47# genblk1\[2\].fa_inst.a 0
C4389 net39 net65 0.03434f
C4390 _263_/a_27_47# net59 0
C4391 _014_ net44 0
C4392 _304_/a_1108_47# genblk1\[1\].fa_inst.b 0.00242f
C4393 net49 net69 0.00433f
C4394 clk _268_/a_193_47# 0.00648f
C4395 _273_/a_1217_47# VPWR 0
C4396 _255_/a_639_47# net57 0
C4397 fanout57/a_27_47# net36 0
C4398 net3 _296_/a_761_289# 0.00756f
C4399 _283_/a_1108_47# _028_ 0.00818f
C4400 _283_/a_761_289# genblk1\[11\].fa_inst.a 0
C4401 _277_/a_761_289# net3 0
C4402 VPWR _040_ 0.06894f
C4403 net33 cin 0.00292f
C4404 _272_/a_27_47# _272_/a_639_47# -0.0015f
C4405 _292_/a_193_47# _277_/a_761_289# 0
C4406 _282_/a_27_47# genblk1\[10\].fa_inst.a 0
C4407 _282_/a_543_47# _027_ 0
C4408 genblk1\[12\].fa_inst.a _298_/a_1283_21# 0
C4409 _048_ genblk1\[15\].fa_inst.b 0.22356f
C4410 _107_ _112_ 0.00699f
C4411 _029_ _298_/a_651_413# 0
C4412 VPWR _133_/a_113_47# -0
C4413 _259_/a_1108_47# net57 0.00379f
C4414 _294_/a_27_47# net4 0.02395f
C4415 _281_/a_193_47# net59 0.00709f
C4416 VPWR _269_/a_448_47# 0
C4417 _276_/a_27_47# _290_/a_1108_47# 0
C4418 fanout58/a_27_47# _263_/a_27_47# 0
C4419 s[13] VPWR 0.37243f
C4420 net28 _295_/a_1108_47# 0.00501f
C4421 clknet_2_0__leaf_clk_regs _056_ 0
C4422 _088_ _086_ 0.01526f
C4423 _301_/a_1283_21# clknet_2_3__leaf_clk_regs 0
C4424 _273_/a_651_413# net8 0.00211f
C4425 _020_ _288_/a_193_47# 0
C4426 net39 pmu_inst/dc_inst.x2.x7/a_27_47# -0
C4427 clknet_2_0__leaf_clk_regs net58 0.19916f
C4428 _039_ net3 0.02088f
C4429 net2 _295_/a_448_47# 0
C4430 _303_/a_761_289# clknet_2_3__leaf_clk_regs 0.01139f
C4431 _291_/a_448_47# a[9] 0
C4432 _098_ _198_/a_27_413# 0
C4433 net6 _295_/a_193_47# 0
C4434 _277_/a_448_47# VPWR 0.00187f
C4435 net28 _280_/a_193_47# 0
C4436 _286_/a_805_47# net19 0.00213f
C4437 net4 genblk1\[10\].fa_inst.b 0
C4438 _060_ net56 0
C4439 _303_/a_1283_21# net60 0.01433f
C4440 VPWR input11/a_75_212# 0.09722f
C4441 VPWR _282_/a_543_47# 0.01535f
C4442 clknet_2_2__leaf_clk_regs _297_/a_805_47# 0.00212f
C4443 VPWR _283_/a_1283_21# 0.07268f
C4444 _275_/a_193_47# net12 0
C4445 net3 _281_/a_761_289# 0.01158f
C4446 net5 input30/a_75_212# 0.00552f
C4447 _288_/a_1462_47# net56 0
C4448 _257_/a_761_289# net57 0.02073f
C4449 _276_/a_651_413# net56 0
C4450 net26 _041_ 0.00179f
C4451 net39 pmu_inst/dc_inst.x6.x11/a_27_47# 0.00101f
C4452 net23 net34 0.07581f
C4453 _271_/a_193_47# fanout62/a_110_47# 0
C4454 clk _267_/a_193_47# 0.02915f
C4455 cin net35 0
C4456 _256_/a_651_413# genblk1\[1\].fa_inst.s 0.00211f
C4457 net58 genblk1\[7\].fa_inst.a 0
C4458 b[4] net36 0
C4459 _270_/a_1270_413# clknet_2_3__leaf_clk_regs 0
C4460 genblk1\[11\].fa_inst.s clkbuf_2_3__f_clk_regs/a_110_47# 0.01054f
C4461 clknet_2_0__leaf_clk_regs _057_ 0.03097f
C4462 _035_ _289_/a_193_47# 0
C4463 genblk1\[3\].fa_inst.a genblk1\[2\].fa_inst.a 0.05353f
C4464 _290_/a_193_47# _034_ 0
C4465 net15 net16 0.06997f
C4466 net33 genblk1\[1\].fa_inst.b 0.15342f
C4467 a[15] input17/a_27_47# 0
C4468 clknet_2_1__leaf_clk_regs _262_/a_27_47# 0.03414f
C4469 input7/a_27_47# b[0] 0
C4470 net4 _298_/a_193_47# 0.03408f
C4471 net39 net57 0.02582f
C4472 _023_ _278_/a_761_289# -0.00655f
C4473 net49 net48 1.12365f
C4474 _272_/a_543_47# _017_ 0
C4475 _272_/a_1108_47# clknet_2_0__leaf_clk_regs 0.08522f
C4476 _272_/a_27_47# genblk1\[0\].fa_inst.a 0
C4477 _277_/a_27_47# _291_/a_543_47# 0
C4478 _279_/a_761_289# _024_ 0
C4479 _282_/a_1217_47# genblk1\[10\].fa_inst.a 0
C4480 _277_/a_543_47# _291_/a_193_47# 0
C4481 _293_/a_448_47# genblk1\[5\].fa_inst.b 0
C4482 _281_/a_1462_47# net59 0
C4483 net7 _283_/a_805_47# 0
C4484 VPWR _014_ 0.3857f
C4485 net33 _288_/a_1283_21# 0
C4486 _304_/a_543_47# _033_ 0
C4487 _276_/a_27_47# net25 0
C4488 net5 input27/a_75_212# 0.00552f
C4489 net7 _282_/a_639_47# 0.00203f
C4490 _272_/a_1283_21# net1 0
C4491 _272_/a_543_47# VPWR 0.00918f
C4492 net3 _278_/a_761_289# 0.01299f
C4493 _293_/a_27_47# clknet_2_1__leaf_clk_regs 0.24133f
C4494 _302_/a_27_47# _047_ 0.01056f
C4495 _302_/a_193_47# net22 0.00949f
C4496 net28 net30 0.0559f
C4497 _290_/a_448_47# a[7] 0
C4498 _290_/a_1108_47# net14 0
C4499 _294_/a_193_47# net25 0
C4500 _302_/a_761_289# net7 0.01752f
C4501 _286_/a_1270_413# net18 0
C4502 genblk1\[3\].fa_inst.a _288_/a_639_47# 0.00539f
C4503 genblk1\[6\].fa_inst.s _074_ 0
C4504 genblk1\[12\].fa_inst.b _193_/a_382_47# 0
C4505 net46 pmu_inst/dc_inst.x1.x18/a_27_47# 0.00251f
C4506 cin_q _304_/a_448_47# 0
C4507 net2 _040_ 0
C4508 net41 net35 0.02587f
C4509 _261_/a_543_47# _260_/a_761_289# 0
C4510 genblk1\[7\].fa_inst.s _262_/a_1108_47# 0
C4511 _303_/a_1108_47# _287_/a_543_47# 0
C4512 net39 pmu_inst/dc_inst.x2.x5/a_27_47# 0
C4513 _259_/a_193_47# fanout57/a_27_47# 0.00172f
C4514 VPWR b[0] 0.23667f
C4515 net29 net18 0.00418f
C4516 _270_/a_543_47# net61 0.00383f
C4517 net26 _026_ 0
C4518 _046_ net60 0.26917f
C4519 _287_/a_27_47# clknet_2_2__leaf_clk_regs 0
C4520 _274_/a_27_47# _273_/a_193_47# 0
C4521 _274_/a_193_47# _273_/a_27_47# 0
C4522 _256_/a_27_47# clknet_2_0__leaf_clk_regs 0.01945f
C4523 net47 pmu_inst_68/HI 0.00212f
C4524 _291_/a_27_47# _291_/a_1283_21# -0
C4525 VPWR _279_/a_1270_413# 0
C4526 _302_/a_651_413# VPWR 0.00114f
C4527 net13 _278_/a_193_47# 0.08964f
C4528 clk _267_/a_1462_47# 0
C4529 net28 _283_/a_543_47# 0
C4530 VPWR genblk1\[9\].fa_inst.b 1.47258f
C4531 _064_ _141_/a_113_47# 0
C4532 VPWR pmu_inst/_15_/a_397_47# 0
C4533 _060_ _055_ 0
C4534 _258_/a_543_47# clknet_2_0__leaf_clk_regs 0.00325f
C4535 _036_ net12 0
C4536 _277_/a_448_47# net2 0
C4537 _189_/a_47_47# _099_ 0.06803f
C4538 _284_/a_761_289# net30 0
C4539 genblk1\[15\].fa_inst.a _106_ 0
C4540 genblk1\[14\].fa_inst.b _195_/a_68_297# 0.02567f
C4541 genblk1\[12\].fa_inst.b _104_ 0.02722f
C4542 _130_/a_215_297# _050_ 0.03676f
C4543 _258_/a_193_47# VPWR 0.03624f
C4544 _293_/a_1108_47# net33 0.01542f
C4545 clknet_2_1__leaf_clk_regs _262_/a_543_47# 0.0016f
C4546 net2 _282_/a_543_47# 0
C4547 genblk1\[12\].fa_inst.s net60 0
C4548 _279_/a_805_47# genblk1\[7\].fa_inst.a 0
C4549 _130_/a_298_297# _051_ 0
C4550 _276_/a_651_413# _290_/a_193_47# 0
C4551 net7 genblk1\[10\].fa_inst.a 0
C4552 _291_/a_193_47# net15 0
C4553 net33 _145_/a_68_297# 0.00851f
C4554 _067_ _065_ 0.13183f
C4555 clknet_2_0__leaf_clk_regs net1 0.08635f
C4556 _302_/a_1217_47# _047_ 0
C4557 net16 _038_ 0
C4558 net25 net14 1.09684f
C4559 net51 s[6] 0.09627f
C4560 VPWR _198_/a_27_413# 0.03891f
C4561 a[15] net7 0.00144f
C4562 s[8] s[7] 0
C4563 a[0] net1 0.00147f
C4564 _293_/a_761_289# genblk1\[5\].fa_inst.a 0
C4565 net29 net25 0
C4566 cin_q _049_ 0.16937f
C4567 net39 pmu_inst/dc_inst.x2.x1/a_27_47# 0
C4568 _068_ _065_ 0.13532f
C4569 genblk1\[6\].fa_inst.s _260_/a_27_47# 0
C4570 net34 net50 0.02624f
C4571 net46 pmu_inst/dc_inst.x2.net1 0
C4572 VPWR pmu_inst/dc_inst.x4.x4/a_27_47# 0
C4573 _276_/a_448_47# _035_ 0.00355f
C4574 net58 _262_/a_761_289# 0
C4575 genblk1\[12\].fa_inst.b _300_/a_1283_21# 0.00127f
C4576 net67 pmu_inst_67/HI 0.00337f
C4577 net68 net69 0.11169f
C4578 _071_ _069_ 0.09683f
C4579 _205_/a_47_47# _111_ 0.00517f
C4580 _112_ _204_/a_33_297# 0.08054f
C4581 _269_/a_448_47# genblk1\[14\].fa_inst.s 0.0056f
C4582 _093_ _180_/a_150_297# 0
C4583 _085_ _170_/a_68_297# 0.00594f
C4584 _021_ net12 0
C4585 _277_/a_1270_413# net16 0
C4586 genblk1\[8\].fa_inst.s _263_/a_543_47# 0
C4587 _265_/a_1283_21# clknet_2_3__leaf_clk_regs 0
C4588 _265_/a_761_289# _010_ -0
C4589 _255_/a_761_289# net39 0
C4590 net71 pmu_inst/dc_inst.x5.net15 0
C4591 _255_/a_448_47# genblk1\[0\].fa_inst.s 0.00758f
C4592 _255_/a_1108_47# _000_ 0.02575f
C4593 _292_/a_448_47# net16 0
C4594 _039_ _295_/a_1283_21# 0
C4595 _265_/a_639_47# genblk1\[10\].fa_inst.s 0
C4596 _256_/a_639_47# VPWR 0
C4597 net47 pmu_inst/dc_inst.x3.net19 0.00317f
C4598 _063_ _062_ 0.09067f
C4599 _259_/a_27_47# net58 0.01321f
C4600 _087_ _086_ 0.07589f
C4601 genblk1\[14\].fa_inst.a _110_ 0
C4602 net5 net36 0.48198f
C4603 net2 b[0] 0
C4604 genblk1\[6\].fa_inst.b genblk1\[6\].fa_inst.a 0.29134f
C4605 net38 net37 0.12172f
C4606 clknet_2_1__leaf_clk_regs _289_/a_761_289# 0
C4607 _291_/a_1283_21# net56 0.06662f
C4608 net38 net45 0.02921f
C4609 _112_ _109_ 0.06495f
C4610 net75 _134_/a_377_297# 0.00152f
C4611 VPWR net66 0.51655f
C4612 genblk1\[12\].fa_inst.s _267_/a_448_47# 0.00652f
C4613 _297_/a_1108_47# net32 0
C4614 _179_/a_47_47# _178_/a_215_297# 0
C4615 _297_/a_1283_21# _042_ 0.0351f
C4616 _198_/a_298_297# _102_ 0.02473f
C4617 _270_/a_1108_47# genblk1\[15\].fa_inst.s 0
C4618 _276_/a_27_47# clknet_2_1__leaf_clk_regs 0.0368f
C4619 s[4] VPWR 0.38857f
C4620 _281_/a_1108_47# _295_/a_193_47# 0
C4621 _039_ _280_/a_27_47# 0
C4622 _281_/a_543_47# _295_/a_543_47# 0
C4623 genblk1\[7\].fa_inst.b net4 0
C4624 _294_/a_193_47# clknet_2_1__leaf_clk_regs 0.00125f
C4625 _256_/a_193_47# net46 0.00124f
C4626 _256_/a_1283_21# _001_ 0.00119f
C4627 VPWR pmu_inst/dc_inst.x4.x1/a_27_47# 0.00269f
C4628 clknet_0_clk_regs _011_ 0.00187f
C4629 clkbuf_2_0__f_clk_regs/a_110_47# _260_/a_448_47# 0
C4630 clknet_0_clk_regs _260_/a_543_47# 0
C4631 _303_/a_1270_413# net36 0
C4632 _293_/a_543_47# genblk1\[5\].fa_inst.a 0
C4633 _296_/a_193_47# net30 0.02815f
C4634 clknet_2_2__leaf_clk_regs net36 0.75773f
C4635 net17 net36 0.0615f
C4636 net39 net63 0.02989f
C4637 _276_/a_193_47# _290_/a_27_47# 0
C4638 _260_/a_193_47# genblk1\[5\].fa_inst.s 0.08049f
C4639 VPWR pmu_inst_73/HI 0.03287f
C4640 net59 _297_/a_1270_413# 0
C4641 net47 pmu_inst/dc_inst.x7.net14 0.00302f
C4642 _062_ _057_ 0
C4643 _194_/a_47_47# _193_/a_215_297# 0
C4644 net39 pmu_inst/dc_inst.x1.net17 0.00219f
C4645 _304_/a_193_47# net56 0.00117f
C4646 _289_/a_761_289# net11 0.01632f
C4647 _290_/a_651_413# net12 0.00195f
C4648 genblk1\[4\].fa_inst.s _259_/a_543_47# 0.00387f
C4649 _294_/a_448_47# genblk1\[6\].fa_inst.b 0
C4650 _014_ genblk1\[14\].fa_inst.s 0.02159f
C4651 _294_/a_193_47# _025_ 0
C4652 _098_ genblk1\[13\].fa_inst.a 0
C4653 _274_/a_1270_413# clknet_2_1__leaf_clk_regs 0
C4654 _274_/a_543_47# genblk1\[1\].fa_inst.a 0
C4655 net48 net68 0.0149f
C4656 genblk1\[14\].fa_inst.a _105_ 0.16345f
C4657 _276_/a_193_47# net13 0
C4658 _291_/a_805_47# net26 0
C4659 _291_/a_639_47# _036_ 0.00128f
C4660 net29 _280_/a_448_47# 0
C4661 _265_/a_805_47# net40 0
C4662 _198_/a_215_297# _104_ 0.03304f
C4663 genblk1\[0\].fa_inst.s _000_ 0.00381f
C4664 _037_ net16 0
C4665 net40 genblk1\[10\].fa_inst.s 0.00177f
C4666 _271_/a_27_47# net38 0
C4667 _271_/a_805_47# clknet_2_3__leaf_clk_regs 0
C4668 _271_/a_543_47# _016_ 0.00341f
C4669 net27 genblk1\[9\].fa_inst.a 0
C4670 net46 VPWR 7.56871f
C4671 _276_/a_27_47# net11 0.04181f
C4672 net4 _295_/a_448_47# 0
C4673 _074_ _073_ 0.27422f
C4674 _294_/a_193_47# _279_/a_193_47# 0
C4675 clknet_2_3__leaf_clk_regs net32 0.89221f
C4676 genblk1\[8\].fa_inst.s clknet_2_2__leaf_clk_regs 0.04272f
C4677 VPWR pmu_inst/dc_inst.x6.net1 0
C4678 _183_/a_215_297# _091_ 0.01162f
C4679 _044_ clknet_2_3__leaf_clk_regs 0
C4680 genblk1\[11\].fa_inst.s _266_/a_1283_21# 0
C4681 _138_/a_113_47# genblk1\[2\].fa_inst.b 0
C4682 _282_/a_27_47# _296_/a_543_47# 0
C4683 _282_/a_193_47# _296_/a_761_289# 0
C4684 _282_/a_543_47# _296_/a_27_47# 0
C4685 genblk1\[12\].fa_inst.s _012_ 0.00446f
C4686 _044_ _299_/a_1108_47# 0
C4687 net60 _299_/a_651_413# 0.00535f
C4688 _179_/a_129_47# _092_ 0.00176f
C4689 _268_/a_1270_413# clknet_2_3__leaf_clk_regs 0
C4690 input32/a_75_212# b[10] 0
C4691 b[9] input18/a_75_212# 0
C4692 net58 _260_/a_193_47# 0
C4693 net3 _297_/a_639_47# 0.00132f
C4694 _103_ _192_/a_113_47# 0
C4695 clknet_2_1__leaf_clk_regs _007_ 0
C4696 net17 _295_/a_761_289# 0
C4697 _026_ _295_/a_27_47# 0
C4698 _281_/a_193_47# net30 0.03475f
C4699 _281_/a_27_47# _040_ 0
C4700 clkload1/a_110_47# clknet_2_2__leaf_clk_regs 0
C4701 _044_ net32 0
C4702 VPWR pmu_inst_72/HI 0.0487f
C4703 net39 pmu_inst/dc_inst.x1.x6/a_27_47# 0
C4704 _277_/a_761_289# genblk1\[5\].fa_inst.a 0
C4705 clknet_2_1__leaf_clk_regs net14 0.27988f
C4706 _200_/a_59_75# genblk1\[14\].fa_inst.a 0
C4707 net39 net72 0.07055f
C4708 net27 genblk1\[6\].fa_inst.a 0
C4709 _256_/a_1462_47# net46 0.00105f
C4710 _291_/a_193_47# _290_/a_1283_21# 0
C4711 clk _269_/a_193_47# 0
C4712 _300_/a_761_289# VPWR 0.01464f
C4713 clkbuf_2_0__f_clk_regs/a_110_47# _005_ 0
C4714 net29 clknet_2_1__leaf_clk_regs 0.00208f
C4715 net26 net59 0
C4716 VPWR pmu_inst/dc_inst.x1.x5/a_27_47# 0.00197f
C4717 _259_/a_27_47# _258_/a_543_47# 0
C4718 net6 a[15] 0.04303f
C4719 net61 genblk1\[10\].fa_inst.s 0
C4720 clkbuf_2_3__f_clk_regs/a_110_47# _266_/a_1108_47# 0.00318f
C4721 net47 pmu_inst/_24_/a_1283_21# 0.0085f
C4722 _148_/a_215_297# _068_ 0.002f
C4723 _277_/a_27_47# _037_ 0
C4724 VPWR _285_/a_639_47# 0
C4725 cin_q _130_/a_382_47# 0.00123f
C4726 _277_/a_1283_21# _291_/a_1283_21# 0
C4727 _098_ genblk1\[12\].fa_inst.a 0.02504f
C4728 _304_/a_1462_47# net56 0
C4729 _104_ _102_ 0.16814f
C4730 _259_/a_448_47# net58 0
C4731 _022_ clknet_2_0__leaf_clk_regs 0
C4732 clknet_0_clk_regs _263_/a_805_47# 0
C4733 _178_/a_215_297# net59 0
C4734 net61 _268_/a_543_47# 0.00126f
C4735 _019_ _018_ 0
C4736 net7 _284_/a_1283_21# 0.00236f
C4737 net46 pmu_inst/dc_inst.net3 0
C4738 genblk1\[4\].fa_inst.a genblk1\[2\].fa_inst.a 0
C4739 _036_ genblk1\[3\].fa_inst.b 0
C4740 net29 _025_ 0.00111f
C4741 VPWR _264_/a_1108_47# 0.0079f
C4742 _302_/a_651_413# net20 0
C4743 clknet_2_3__leaf_clk_regs net19 0.23925f
C4744 _299_/a_1108_47# net19 0
C4745 net57 clknet_0_clk_regs 0
C4746 net28 _293_/a_27_47# 0.02939f
C4747 _077_ _076_ 0
C4748 net36 _297_/a_27_47# 0
C4749 _271_/a_1217_47# net38 0
C4750 _287_/a_448_47# clknet_2_3__leaf_clk_regs 0.00198f
C4751 _273_/a_639_47# net9 0
C4752 VPWR _074_ 0.1621f
C4753 net4 _040_ 0
C4754 _304_/a_193_47# _055_ 0
C4755 clkbuf_2_2__f_clk_regs/a_110_47# _090_ 0
C4756 genblk1\[10\].fa_inst.b _298_/a_1108_47# 0
C4757 _287_/a_27_47# _287_/a_193_47# -0.13049f
C4758 net11 net14 0
C4759 _274_/a_27_47# clknet_2_0__leaf_clk_regs 0.61709f
C4760 _129_/a_377_297# VPWR 0
C4761 net39 pmu_inst/dc_inst.x6.net5 0
C4762 net14 _279_/a_193_47# 0.01561f
C4763 _302_/a_543_47# _286_/a_1108_47# 0
C4764 _267_/a_1270_413# clknet_2_3__leaf_clk_regs 0
C4765 net19 net32 0
C4766 VPWR _266_/a_543_47# 0.01064f
C4767 clknet_2_0__leaf_clk_regs genblk1\[5\].fa_inst.b 0
C4768 _304_/a_1283_21# net33 0
C4769 _304_/a_543_47# _049_ 0
C4770 net29 _279_/a_193_47# 0
C4771 _162_/a_113_47# _078_ 0
C4772 _044_ net19 0
C4773 tdo pmu_inst_70/HI 0
C4774 net5 _283_/a_27_47# 0
C4775 net59 _298_/a_448_47# 0
C4776 _287_/a_1270_413# net60 0
C4777 genblk1\[1\].fa_inst.a _288_/a_543_47# 0.00155f
C4778 clk clk_regs 0.31963f
C4779 _264_/a_651_413# genblk1\[9\].fa_inst.s 0
C4780 VPWR pmu_inst/dc_inst.x4.x2/a_27_47# 0.00548f
C4781 VPWR pmu_inst/dc_inst.x2.x20/a_27_47# 0.00307f
C4782 _281_/a_1217_47# _040_ 0
C4783 net46 pmu_inst/dc_inst.x4.net12 0
C4784 _050_ net56 0.01034f
C4785 VPWR _289_/a_543_47# 0.01034f
C4786 _302_/a_543_47# genblk1\[14\].fa_inst.b 0
C4787 _191_/a_113_47# _101_ 0
C4788 _158_/a_27_413# _071_ 0.00111f
C4789 clknet_2_2__leaf_clk_regs _081_ 0
C4790 VPWR _284_/a_639_47# 0
C4791 _272_/a_543_47# _288_/a_193_47# 0
C4792 _272_/a_761_289# _288_/a_761_289# 0
C4793 _127_/a_113_47# net56 0
C4794 _257_/a_543_47# genblk1\[2\].fa_inst.s 0.00127f
C4795 _257_/a_761_289# _002_ 0.00225f
C4796 _291_/a_27_47# net25 0
C4797 _178_/a_27_413# _085_ 0.04451f
C4798 genblk1\[13\].fa_inst.a _198_/a_382_47# 0
C4799 _300_/a_761_289# _285_/a_193_47# 0
C4800 _300_/a_27_47# _285_/a_543_47# 0
C4801 _300_/a_193_47# _285_/a_761_289# 0
C4802 _300_/a_543_47# _285_/a_27_47# 0
C4803 net47 pmu_inst/_25_/a_1108_47# 0.00687f
C4804 genblk1\[3\].fa_inst.a _068_ 0
C4805 net47 pmu_inst/clknet_1_1__leaf_clk 0.02113f
C4806 net47 pmu_inst/dc_inst.x8/a_750_97# 0.00171f
C4807 VPWR genblk1\[13\].fa_inst.a 0.55726f
C4808 _268_/a_805_47# _013_ 0
C4809 _021_ genblk1\[3\].fa_inst.b 0.22161f
C4810 _281_/a_1283_21# genblk1\[8\].fa_inst.a 0
C4811 clkload2/X clknet_0_clk_regs 0.00216f
C4812 net61 _267_/a_543_47# 0.00118f
C4813 net12 genblk1\[2\].fa_inst.b 0
C4814 net46 pmu_inst/dc_inst.x2.net17 0.0039f
C4815 _290_/a_1108_47# net56 0.00165f
C4816 net26 net13 0.02432f
C4817 _302_/a_27_47# _301_/a_761_289# 0
C4818 _302_/a_193_47# _301_/a_193_47# 0
C4819 net70 pmu_inst/dc_inst.x5.net12 -0
C4820 _291_/a_1270_413# net36 0
C4821 net41 net62 0.06106f
C4822 genblk1\[8\].fa_inst.b genblk1\[9\].fa_inst.a 0.02395f
C4823 net3 _298_/a_651_413# 0
C4824 net60 net18 0
C4825 _283_/a_27_47# clknet_2_2__leaf_clk_regs 0.03448f
C4826 _071_ _070_ 0.01376f
C4827 _084_ _082_ 0.01615f
C4828 _032_ clknet_2_3__leaf_clk_regs 0
C4829 genblk1\[1\].fa_inst.a net9 0
C4830 net46 pmu_inst/dc_inst.x1.net5 0.005f
C4831 clknet_2_0__leaf_clk_regs _260_/a_761_289# 0.00117f
C4832 _293_/a_1283_21# genblk1\[6\].fa_inst.a 0.02025f
C4833 VPWR clknet_1_0__leaf_clk 0.27299f
C4834 b[1] b[2] 0.06871f
C4835 genblk1\[10\].fa_inst.b net18 0
C4836 net22 _286_/a_543_47# 0
C4837 _302_/a_761_289# _031_ 0
C4838 _104_ _190_/a_68_297# 0
C4839 net46 net71 0.09529f
C4840 VPWR _260_/a_27_47# 0.07036f
C4841 _263_/a_761_289# net62 0
C4842 _286_/a_1283_21# net7 0.0122f
C4843 _274_/a_639_47# VPWR 0
C4844 _282_/a_639_47# net31 0
C4845 _088_ _170_/a_150_297# 0
C4846 net59 _043_ 0.10609f
C4847 clknet_2_0__leaf_clk_regs net24 0
C4848 a[3] net8 0
C4849 _054_ _056_ 0.00724f
C4850 _052_ hold1/a_285_47# 0
C4851 net75 hold1/a_49_47# 0.00128f
C4852 net7 _296_/a_543_47# 0.0171f
C4853 VPWR input28/a_75_212# 0.09177f
C4854 _183_/a_27_413# _096_ 0.0011f
C4855 _264_/a_27_47# _264_/a_761_289# -0
C4856 net40 net35 0.02399f
C4857 net27 net32 0
C4858 _131_/a_68_297# genblk1\[2\].fa_inst.b 0
C4859 net47 pmu_inst/_14_/a_76_199# 0.00389f
C4860 _298_/a_193_47# net18 0.00382f
C4861 _298_/a_27_47# _043_ -0
C4862 _279_/a_1283_21# _278_/a_1283_21# 0.00127f
C4863 _294_/a_27_47# net25 0
C4864 _179_/a_47_47# _089_ 0
C4865 _091_ _175_/a_68_297# 0
C4866 _287_/a_27_47# net35 0
C4867 VPWR genblk1\[12\].fa_inst.a 0.45753f
C4868 _100_ genblk1\[12\].fa_inst.a 0
C4869 clknet_2_0__leaf_clk_regs _288_/a_27_47# 0.18357f
C4870 _257_/a_805_47# net47 0
C4871 net46 pmu_inst/dc_inst.x4.net6 0.00985f
C4872 net47 pmu_inst/_00_ 0.02043f
C4873 clkbuf_2_1__f_clk_regs/a_110_47# _261_/a_27_47# 0.0213f
C4874 input13/a_75_212# a[6] 0.01461f
C4875 a[14] net6 0.02927f
C4876 _039_ _024_ 0
C4877 _285_/a_193_47# genblk1\[13\].fa_inst.a 0
C4878 _285_/a_1283_21# _030_ 0.05555f
C4879 _050_ _055_ 0
C4880 net47 pmu_inst/dc_inst.x9/a_193_47# 0
C4881 VPWR _286_/a_639_47# 0
C4882 pmu_inst/dc_inst.x3.net12 cout_next 0
C4883 net17 genblk1\[8\].fa_inst.a 0.02907f
C4884 net25 net56 0
C4885 VPWR input18/a_75_212# 0.09177f
C4886 net46 pmu_inst/dc_inst.x4.net2 0
C4887 net4 genblk1\[9\].fa_inst.b 0
C4888 VPWR _296_/a_1270_413# 0
C4889 _198_/a_215_297# genblk1\[13\].fa_inst.s 0
C4890 _198_/a_382_47# _103_ 0
C4891 _083_ net59 0
C4892 genblk1\[2\].fa_inst.s _139_/a_47_47# 0.00168f
C4893 net16 _279_/a_27_47# 0.0242f
C4894 net28 _294_/a_193_47# 0
C4895 _287_/a_193_47# net36 0
C4896 VPWR _103_ 0.02486f
C4897 net46 pmu_inst/_18_/a_505_21# 0
C4898 _054_ _057_ 0.02954f
C4899 s[8] net53 0.09627f
C4900 _100_ _103_ 0
C4901 net17 _279_/a_1283_21# 0.00785f
C4902 _164_/a_285_47# _080_ 0.00459f
C4903 _282_/a_805_47# clknet_2_2__leaf_clk_regs 0
C4904 _282_/a_1108_47# genblk1\[9\].fa_inst.a 0
C4905 net38 output38/a_27_47# 0.01331f
C4906 net61 net35 0.02805f
C4907 net27 genblk1\[6\].fa_inst.b 0
C4908 _302_/a_543_47# clknet_2_2__leaf_clk_regs 0.00401f
C4909 net7 _281_/a_543_47# 0.01323f
C4910 _287_/a_543_47# genblk1\[15\].fa_inst.a 0
C4911 _287_/a_448_47# _032_ 0
C4912 net65 net66 0.09799f
C4913 genblk1\[2\].fa_inst.a _136_/a_68_297# 0.08157f
C4914 _292_/a_27_47# net36 0
C4915 net59 _295_/a_27_47# 0.01022f
C4916 clknet_2_2__leaf_clk_regs _171_/a_113_47# 0
C4917 net47 pmu_inst/dc_inst.x10/a_76_199# 0.0033f
C4918 clkbuf_0_clk_regs/a_110_47# net53 0.15017f
C4919 genblk1\[2\].fa_inst.a VPWR 1.33576f
C4920 net58 genblk1\[6\].fa_inst.a 0
C4921 clknet_0_clk_regs _265_/a_448_47# 0
C4922 genblk1\[10\].fa_inst.a net31 0
C4923 _275_/a_1108_47# _273_/a_1108_47# 0
C4924 _258_/a_193_47# net57 0.00525f
C4925 _283_/a_27_47# _297_/a_27_47# 0
C4926 _267_/a_651_413# net42 0
C4927 _280_/a_543_47# net15 0
C4928 _301_/a_543_47# VPWR 0.01533f
C4929 VPWR _263_/a_651_413# 0
C4930 _291_/a_27_47# clknet_2_1__leaf_clk_regs 0.04806f
C4931 _293_/a_448_47# _293_/a_193_47# -0.00297f
C4932 _300_/a_193_47# _045_ 0
C4933 _300_/a_761_289# net20 0
C4934 net33 net36 0.06873f
C4935 _292_/a_1283_21# _037_ -0
C4936 _292_/a_1108_47# net27 0.00124f
C4937 _292_/a_193_47# genblk1\[4\].fa_inst.b 0
C4938 _074_ _075_ 0.01599f
C4939 _303_/a_193_47# VPWR -0.28844f
C4940 net20 _285_/a_639_47# 0
C4941 _096_ net35 0.07698f
C4942 net39 pmu_inst/dc_inst.x4.x14/a_27_47# 0.00207f
C4943 VPWR _281_/a_1270_413# 0
C4944 VPWR _288_/a_639_47# 0
C4945 _285_/a_1462_47# genblk1\[13\].fa_inst.a 0
C4946 _273_/a_1283_21# net56 0.02825f
C4947 net47 net35 0.13719f
C4948 net47 pmu_inst/_05_ 0.01017f
C4949 _293_/a_448_47# _038_ 0
C4950 _297_/a_1270_413# net30 0
C4951 VPWR genblk1\[14\].fa_inst.a 2.22504f
C4952 net33 _195_/a_68_297# 0.00988f
C4953 genblk1\[13\].fa_inst.s _102_ 0.00982f
C4954 net3 _295_/a_193_47# 0.02183f
C4955 a[10] net24 0
C4956 _036_ _276_/a_1283_21# 0
C4957 net26 _280_/a_193_47# 0.01413f
C4958 _301_/a_639_47# net7 0.00188f
C4959 _291_/a_1108_47# fanout56/a_27_47# 0.00317f
C4960 genblk1\[9\].fa_inst.b _170_/a_68_297# 0.0162f
C4961 _269_/a_193_47# _268_/a_1283_21# 0
C4962 _269_/a_543_47# _268_/a_761_289# 0
C4963 _269_/a_27_47# _268_/a_1108_47# 0
C4964 net46 net65 0.13885f
C4965 _270_/a_651_413# VPWR 0
C4966 _256_/a_639_47# net57 0
C4967 VPWR _278_/a_1270_413# 0
C4968 net28 net29 0.01913f
C4969 net39 pmu_inst/dc_inst.x6.net4 0
C4970 _199_/a_47_47# _201_/a_479_47# 0
C4971 _304_/a_1283_21# _059_ 0
C4972 _290_/a_193_47# net25 0.03895f
C4973 _291_/a_27_47# net11 0
C4974 _290_/a_27_47# _035_ 0.00292f
C4975 net59 _295_/a_1217_47# 0
C4976 _168_/a_298_297# VPWR 0
C4977 net47 pmu_inst/dc_inst.net8 0.00342f
C4978 _286_/a_1283_21# net6 0
C4979 clknet_0_clk_regs _010_ 0.04106f
C4980 _275_/a_448_47# clknet_2_1__leaf_clk_regs 0.00358f
C4981 _020_ _273_/a_1283_21# 0.00102f
C4982 _275_/a_193_47# genblk1\[1\].fa_inst.a 0
C4983 _293_/a_27_47# _278_/a_193_47# 0
C4984 net35 net36 1.39315f
C4985 net39 pmu_inst/dc_inst.x6.x13/a_27_47# 0
C4986 _282_/a_543_47# _297_/a_651_413# 0
C4987 _284_/a_1283_21# _029_ 0.05421f
C4988 _284_/a_193_47# genblk1\[12\].fa_inst.a 0
C4989 _294_/a_27_47# clknet_2_1__leaf_clk_regs 0.01474f
C4990 _264_/a_1283_21# net54 0.00291f
C4991 _199_/a_47_47# _106_ 0
C4992 net39 pmu_inst/dc_inst.x1.net12 0
C4993 _035_ net13 0
C4994 genblk1\[3\].fa_inst.a _131_/a_150_297# 0
C4995 _290_/a_639_47# net36 0
C4996 VPWR _152_/a_113_47# -0
C4997 genblk1\[3\].fa_inst.b genblk1\[2\].fa_inst.b 0.00213f
C4998 _303_/a_1462_47# VPWR 0
C4999 net26 net30 0
C5000 clknet_2_0__leaf_clk_regs _065_ 0
C5001 genblk1\[0\].fa_inst.a _033_ 0
C5002 _021_ _276_/a_1283_21# 0.05568f
C5003 _078_ _161_/a_113_47# 0
C5004 b[2] input26/a_75_212# 0
C5005 input25/a_75_212# b[3] 0
C5006 genblk1\[12\].fa_inst.b _094_ 0
C5007 VPWR net16 2.12198f
C5008 _183_/a_298_297# _089_ 0.00302f
C5009 net64 cout_next 0.0818f
C5010 _274_/a_1283_21# net10 -0
C5011 _266_/a_27_47# net41 0
C5012 _148_/a_27_413# _063_ 0
C5013 net37 input37/a_75_212# 0.00378f
C5014 VPWR pmu_inst/dc_inst.x2.net6 0
C5015 VPWR pmu_inst/dc_inst.x7.net12 0
C5016 clknet_2_1__leaf_clk_regs net56 0.00187f
C5017 net33 _165_/a_68_297# 0.00138f
C5018 _169_/a_377_297# _083_ 0.00391f
C5019 genblk1\[14\].fa_inst.a _285_/a_193_47# 0
C5020 net39 pmu_inst/dc_inst.x6.x12/a_27_47# 0
C5021 net56 _135_/a_215_297# 0.01278f
C5022 net47 pmu_inst/dc_inst.x3.net9 0.00959f
C5023 _256_/a_27_47# _255_/a_27_47# 0
C5024 _294_/a_27_47# _025_ 0
C5025 clknet_2_0__leaf_clk_regs _076_ 0
C5026 fanout59/a_27_47# clknet_0_clk_regs 0.02089f
C5027 net46 pmu_inst/dc_inst.x6.x11/a_27_47# 0.00433f
C5028 net52 net35 0.02399f
C5029 _147_/a_113_47# VPWR -0
C5030 net39 pmu_inst/dc_inst.x5.x17/a_27_47# 0.0093f
C5031 net26 fanout56/a_27_47# 0
C5032 clkload0/Y clknet_2_0__leaf_clk_regs 0.00141f
C5033 _178_/a_215_297# _088_ 0.01084f
C5034 _302_/a_27_47# b[13] 0
C5035 net5 _285_/a_1108_47# 0
C5036 genblk1\[14\].fa_inst.b genblk1\[13\].fa_inst.b 0
C5037 net46 net57 0.02331f
C5038 cin_q hold1/a_285_47# 0.01545f
C5039 _294_/a_27_47# _279_/a_193_47# 0
C5040 _098_ _299_/a_1283_21# 0
C5041 genblk1\[1\].fa_inst.a _304_/a_543_47# 0
C5042 clk _264_/a_27_47# 0.04791f
C5043 genblk1\[4\].fa_inst.a _067_ 0
C5044 _195_/a_68_297# _195_/a_150_297# 0
C5045 clknet_2_0__leaf_clk_regs _255_/a_193_47# 0.00945f
C5046 _277_/a_27_47# VPWR 0.07448f
C5047 net61 _269_/a_543_47# 0.00106f
C5048 _020_ clknet_2_1__leaf_clk_regs 0.00142f
C5049 _298_/a_448_47# net30 0
C5050 _289_/a_1283_21# net24 0
C5051 _289_/a_543_47# _034_ 0
C5052 _289_/a_27_47# genblk1\[1\].fa_inst.b 0
C5053 net33 _081_ 0
C5054 _283_/a_448_47# net32 0
C5055 _283_/a_1108_47# _042_ 0
C5056 _301_/a_761_289# _300_/a_448_47# 0
C5057 _301_/a_193_47# _300_/a_651_413# 0
C5058 _301_/a_1283_21# _300_/a_1283_21# 0
C5059 _300_/a_27_47# b[11] 0
C5060 clkbuf_2_3__f_clk_regs/a_110_47# _265_/a_1108_47# 0
C5061 _027_ _297_/a_1283_21# 0
C5062 _284_/a_1462_47# genblk1\[12\].fa_inst.a 0
C5063 net11 net56 0.03869f
C5064 genblk1\[4\].fa_inst.a _068_ 0
C5065 input23/a_75_212# net23 0.00267f
C5066 cin b[15] 0.06871f
C5067 _097_ net60 0
C5068 genblk1\[9\].fa_inst.b _297_/a_651_413# 0
C5069 _302_/a_27_47# net60 0.01569f
C5070 _188_/a_215_297# genblk1\[11\].fa_inst.b 0
C5071 _180_/a_68_297# genblk1\[11\].fa_inst.a 0.00269f
C5072 net46 pmu_inst/dc_inst.x2.x5/a_27_47# -0
C5073 _271_/a_1283_21# net62 0.01101f
C5074 cout_next _204_/a_561_297# 0.03693f
C5075 _294_/a_761_289# _280_/a_193_47# 0
C5076 net39 pmu_inst/dc_inst.x2.net12 0.0247f
C5077 net39 pmu_inst/dc_inst.x5.net13 0.0027f
C5078 _261_/a_543_47# genblk1\[6\].fa_inst.s 0.00387f
C5079 _261_/a_761_289# _006_ 0
C5080 net35 net51 0.02399f
C5081 _256_/a_651_413# _255_/a_1283_21# 0
C5082 VPWR pmu_inst_65/HI 0.05625f
C5083 _291_/a_193_47# VPWR 0.01958f
C5084 genblk1\[6\].fa_inst.b net58 0.00173f
C5085 net27 _295_/a_1270_413# 0
C5086 _282_/a_1270_413# net59 0
C5087 VPWR _265_/a_543_47# 0.01017f
C5088 genblk1\[11\].fa_inst.b genblk1\[11\].fa_inst.a 0.22168f
C5089 _274_/a_1283_21# _019_ 0.04919f
C5090 _274_/a_193_47# genblk1\[2\].fa_inst.a 0
C5091 _294_/a_543_47# genblk1\[6\].fa_inst.b 0
C5092 _283_/a_1108_47# _298_/a_1283_21# 0
C5093 _283_/a_761_289# _298_/a_651_413# 0
C5094 VPWR _179_/a_129_47# -0
C5095 _283_/a_651_413# _298_/a_761_289# 0
C5096 _283_/a_1283_21# _298_/a_1108_47# 0
C5097 net47 pmu_inst/dc_inst.x7.x12/a_27_47# 0.00495f
C5098 net2 net16 3.27416f
C5099 genblk1\[11\].fa_inst.s clknet_2_3__leaf_clk_regs 0.90409f
C5100 VPWR _297_/a_1283_21# 0.06716f
C5101 _135_/a_215_297# _055_ 0.07769f
C5102 net49 net74 0.03001f
C5103 _169_/a_47_47# _082_ 0.00112f
C5104 clknet_2_2__leaf_clk_regs _264_/a_193_47# 0.00201f
C5105 _021_ genblk1\[5\].fa_inst.a 0
C5106 _290_/a_193_47# clknet_2_1__leaf_clk_regs 0.00656f
C5107 input28/a_75_212# b[5] 0.01391f
C5108 _290_/a_805_47# genblk1\[2\].fa_inst.b 0
C5109 genblk1\[14\].fa_inst.b _201_/a_61_47# 0
C5110 net27 _280_/a_1283_21# 0
C5111 net29 _296_/a_193_47# 0.02491f
C5112 _028_ clknet_2_3__leaf_clk_regs 0
C5113 clknet_2_0__leaf_clk_regs net15 0
C5114 _292_/a_1108_47# net58 0.02287f
C5115 clk _266_/a_639_47# 0.00158f
C5116 _277_/a_1283_21# clknet_2_1__leaf_clk_regs 0
C5117 _023_ _279_/a_543_47# 0
C5118 _043_ net30 0.03741f
C5119 _255_/a_805_47# VPWR 0
C5120 clknet_2_0__leaf_clk_regs _304_/a_27_47# 0.63873f
C5121 _028_ net32 0
C5122 _302_/a_1283_21# _287_/a_27_47# 0
C5123 _302_/a_543_47# _287_/a_193_47# 0
C5124 _302_/a_761_289# _287_/a_761_289# 0
C5125 _302_/a_193_47# _287_/a_543_47# 0
C5126 _301_/a_543_47# net20 0.01317f
C5127 _046_ _300_/a_761_289# 0
C5128 _301_/a_761_289# _045_ 0
C5129 output41/a_27_47# s[11] 0.00932f
C5130 net27 genblk1\[8\].fa_inst.b 0
C5131 net3 _283_/a_805_47# 0
C5132 net3 _279_/a_543_47# 0.01389f
C5133 _158_/a_27_413# _074_ 0
C5134 net3 _282_/a_639_47# 0.00118f
C5135 net36 _059_ 0
C5136 _280_/a_27_47# _295_/a_193_47# 0
C5137 _280_/a_193_47# _295_/a_27_47# 0
C5138 genblk1\[7\].fa_inst.b _295_/a_805_47# 0
C5139 net5 b[4] 0
C5140 net46 pmu_inst/dc_inst.x2.x1/a_27_47# 0.00484f
C5141 net33 _155_/a_68_297# 0.00356f
C5142 _094_ _090_ 0
C5143 _301_/a_27_47# _286_/a_1283_21# 0
C5144 _301_/a_193_47# _286_/a_543_47# 0.00115f
C5145 net39 pmu_inst/dc_inst.x4.net18 0.00332f
C5146 _277_/a_27_47# net2 0
C5147 _293_/a_1462_47# clknet_2_1__leaf_clk_regs 0.00184f
C5148 net33 genblk1\[8\].fa_inst.a 0.88066f
C5149 _302_/a_1217_47# net60 0
C5150 net53 cout_next 0.02886f
C5151 net40 net62 0.05864f
C5152 _275_/a_651_413# VPWR 0.00222f
C5153 _178_/a_27_413# genblk1\[9\].fa_inst.b 0
C5154 net20 genblk1\[14\].fa_inst.a 0
C5155 net38 net44 1.02971f
C5156 _276_/a_543_47# _036_ 0
C5157 _144_/a_129_47# net36 0
C5158 _290_/a_193_47# net11 0.03693f
C5159 _261_/a_805_47# net51 0
C5160 _286_/a_193_47# genblk1\[14\].fa_inst.a 0
C5161 _286_/a_1283_21# _031_ 0.02785f
C5162 genblk1\[11\].fa_inst.a net59 0.25159f
C5163 _256_/a_448_47# genblk1\[0\].fa_inst.s 0
C5164 _001_ _255_/a_1108_47# 0
C5165 _256_/a_1108_47# _000_ 0.00105f
C5166 _291_/a_1462_47# VPWR 0
C5167 VPWR _299_/a_1283_21# 0.0419f
C5168 _054_ _129_/a_285_47# 0
C5169 net47 pmu_inst/_23_/a_193_47# 0.00716f
C5170 _064_ net36 0.05452f
C5171 _051_ _135_/a_298_297# 0.00123f
C5172 clknet_2_1__leaf_clk_regs _261_/a_761_289# 0
C5173 _281_/a_193_47# _296_/a_651_413# 0
C5174 _281_/a_1283_21# _296_/a_1283_21# 0
C5175 _281_/a_1108_47# _296_/a_543_47# 0
C5176 _281_/a_651_413# _296_/a_193_47# 0
C5177 _028_ _298_/a_543_47# 0
C5178 _283_/a_543_47# _043_ 0
C5179 net29 _281_/a_193_47# 0.03481f
C5180 _277_/a_1108_47# net36 0
C5181 input18/a_75_212# b[10] 0.01391f
C5182 _257_/a_1108_47# clknet_2_0__leaf_clk_regs 0
C5183 _083_ _088_ 0.07112f
C5184 _283_/a_193_47# net36 0
C5185 genblk1\[2\].fa_inst.a _034_ 0.04243f
C5186 pmu_inst/dc_inst.x3.x11/a_27_47# net67 0
C5187 _295_/a_27_47# net30 0.38029f
C5188 _282_/a_27_47# net36 0.00345f
C5189 clknet_2_2__leaf_clk_regs b[4] 0
C5190 net45 cout_next 0
C5191 _257_/a_543_47# VPWR 0.01623f
C5192 net47 pmu_inst/dc_inst.x7.net1 0.03106f
C5193 _291_/a_193_47# net2 0
C5194 _152_/a_113_47# _069_ 0
C5195 net25 _040_ 0
C5196 _039_ _294_/a_1108_47# 0.00597f
C5197 _296_/a_761_289# _041_ 0
C5198 _296_/a_543_47# net31 0.0078f
C5199 net28 _297_/a_543_47# 0
C5200 net61 net62 1.32121f
C5201 VPWR _268_/a_651_413# 0
C5202 net24 a[12] 0
C5203 _139_/a_377_297# _057_ 0.00154f
C5204 _165_/a_68_297# _165_/a_150_297# 0
C5205 net4 genblk1\[12\].fa_inst.a 0
C5206 _051_ genblk1\[1\].fa_inst.s 0.00169f
C5207 net14 _278_/a_193_47# 0
C5208 net27 net58 1.02008f
C5209 clk net41 0
C5210 genblk1\[2\].fa_inst.a _288_/a_193_47# 0
C5211 net27 _294_/a_543_47# 0.00679f
C5212 _287_/a_27_47# net7 0.23136f
C5213 b[7] b[8] 0.06434f
C5214 _276_/a_1283_21# genblk1\[2\].fa_inst.b 0
C5215 net58 _261_/a_1283_21# 0.02052f
C5216 _183_/a_215_297# genblk1\[10\].fa_inst.a 0
C5217 net3 genblk1\[10\].fa_inst.a 0
C5218 VPWR pmu_inst/dc_inst.x6.x17/a_27_47# 0.00615f
C5219 _067_ VPWR 0.09318f
C5220 _303_/a_448_47# net23 0.00656f
C5221 VPWR pmu_inst/dc_inst.x1.net2 0.01404f
C5222 _276_/a_543_47# _021_ 0
C5223 net27 _282_/a_1108_47# 0
C5224 genblk1\[3\].fa_inst.a clknet_2_0__leaf_clk_regs 0.18069f
C5225 _294_/a_1270_413# genblk1\[6\].fa_inst.b 0
C5226 _178_/a_215_297# _087_ 0.01263f
C5227 VPWR _298_/a_761_289# 0.01293f
C5228 clk _263_/a_761_289# 0.008f
C5229 net46 pmu_inst/dc_inst.x1.net17 0.00889f
C5230 a[10] net15 0.0335f
C5231 genblk1\[4\].fa_inst.b genblk1\[5\].fa_inst.a 0.02393f
C5232 clknet_0_clk_regs _006_ 0.00123f
C5233 _079_ _077_ 0.12805f
C5234 _068_ VPWR 0.61923f
C5235 _259_/a_193_47# clkbuf_2_0__f_clk_regs/a_110_47# 0
C5236 net39 pmu_inst/dc_inst.net4 0.02309f
C5237 _277_/a_805_47# VPWR 0
C5238 a[12] input5/a_27_47# 0
C5239 input4/a_27_47# a[13] 0.00371f
C5240 _286_/a_1108_47# clknet_2_2__leaf_clk_regs 0.00893f
C5241 _290_/a_1462_47# net11 0
C5242 _154_/a_47_47# _071_ 0.01682f
C5243 _260_/a_1108_47# net50 0.00146f
C5244 _260_/a_1270_413# _005_ 0
C5245 _293_/a_193_47# genblk1\[7\].fa_inst.a 0
C5246 genblk1\[5\].fa_inst.b genblk1\[6\].fa_inst.a 0.02157f
C5247 _001_ genblk1\[0\].fa_inst.s 0.0056f
C5248 _165_/a_150_297# _081_ 0
C5249 _276_/a_1108_47# net56 0.01089f
C5250 _277_/a_651_413# net16 0.00272f
C5251 net16 _296_/a_27_47# 0
C5252 net38 VPWR 2.23288f
C5253 _285_/a_27_47# clknet_2_3__leaf_clk_regs 0.08291f
C5254 _285_/a_1283_21# _299_/a_193_47# 0
C5255 _285_/a_1108_47# _299_/a_27_47# 0
C5256 VPWR pmu_inst/dc_inst.x1.net15 0.00577f
C5257 net47 net62 0.03299f
C5258 _151_/a_113_47# genblk1\[5\].fa_inst.b 0
C5259 net28 _294_/a_27_47# 0
C5260 clknet_2_2__leaf_clk_regs _296_/a_1283_21# 0
C5261 _281_/a_761_289# _041_ 0
C5262 _281_/a_543_47# net31 0
C5263 _026_ _296_/a_761_289# 0
C5264 VPWR _287_/a_1108_47# 0.02843f
C5265 clknet_2_0__leaf_clk_regs genblk1\[0\].fa_inst.b 0
C5266 genblk1\[0\].fa_inst.a _126_/a_150_297# 0
C5267 _289_/a_639_47# net12 0.00136f
C5268 _292_/a_448_47# clknet_2_0__leaf_clk_regs 0.02526f
C5269 _038_ genblk1\[7\].fa_inst.a 0
C5270 _271_/a_27_47# cout_next 0.15869f
C5271 _273_/a_27_47# clknet_2_1__leaf_clk_regs 0.03115f
C5272 genblk1\[2\].fa_inst.s clknet_2_0__leaf_clk_regs 0.77863f
C5273 VPWR _267_/a_651_413# 0
C5274 _285_/a_27_47# net32 0
C5275 _276_/a_27_47# _276_/a_193_47# -0.01782f
C5276 clknet_2_1__leaf_clk_regs _295_/a_448_47# 0
C5277 genblk1\[14\].fa_inst.b clknet_2_2__leaf_clk_regs 0
C5278 _292_/a_1283_21# VPWR 0.07077f
C5279 _285_/a_761_289# net60 0
C5280 net39 pmu_inst_71/HI 0.00375f
C5281 _270_/a_761_289# clk 0
C5282 VPWR net55 0.26847f
C5283 genblk1\[2\].fa_inst.a _060_ 0
C5284 _022_ _291_/a_761_289# 0
C5285 _085_ _086_ 0.45976f
C5286 _092_ _172_/a_113_47# 0
C5287 clkbuf_2_2__f_clk_regs/a_110_47# _179_/a_285_47# 0.00206f
C5288 net46 pmu_inst/dc_inst.x1.x6/a_27_47# 0.0026f
C5289 _263_/a_27_47# _008_ 0
C5290 _092_ _090_ 0.13171f
C5291 _269_/a_27_47# _269_/a_1108_47# -0
C5292 net46 pmu_inst/dc_inst.x6.x16/a_27_47# 0.00127f
C5293 net46 net72 0.34939f
C5294 clkbuf_0_clk/a_110_47# net50 0.30961f
C5295 genblk1\[0\].fa_inst.a _049_ 0
C5296 _047_ _287_/a_639_47# 0
C5297 _270_/a_27_47# _270_/a_448_47# -0.00297f
C5298 net28 genblk1\[10\].fa_inst.b 0
C5299 _290_/a_761_289# VPWR 0.0227f
C5300 clknet_2_1__leaf_clk_regs _280_/a_761_289# 0
C5301 net27 _028_ 0
C5302 _048_ net23 0.00447f
C5303 a[13] _278_/a_448_47# 0
C5304 clknet_2_2__leaf_clk_regs _263_/a_543_47# 0
C5305 VPWR _139_/a_47_47# 0.10101f
C5306 net36 net62 0
C5307 _301_/a_639_47# _031_ 0.0017f
C5308 genblk1\[1\].fa_inst.b _033_ 0
C5309 net25 b[0] 0
C5310 _257_/a_639_47# _001_ 0
C5311 net68 net74 0
C5312 clkload0/a_27_47# _260_/a_651_413# 0
C5313 _281_/a_27_47# net16 0.03772f
C5314 _259_/a_1283_21# net58 0
C5315 _281_/a_1283_21# clknet_2_2__leaf_clk_regs 0
C5316 _281_/a_761_289# _026_ 0
C5317 net46 pmu_inst/dc_inst.x6.net15 0.0011f
C5318 net47 net69 0.02483f
C5319 net17 _281_/a_1283_21# 0
C5320 _284_/a_1283_21# _299_/a_193_47# 0
C5321 _284_/a_27_47# clknet_2_3__leaf_clk_regs 0.12974f
C5322 _288_/a_1108_47# net17 0
C5323 _288_/a_1283_21# _033_ 0.05552f
C5324 net47 pmu_inst/dc_inst.x1.net4 0.00106f
C5325 clknet_2_1__leaf_clk_regs clknet_0_clk_regs 0.67023f
C5326 _144_/a_377_297# _064_ 0.00143f
C5327 _077_ _073_ 0
C5328 genblk1\[12\].fa_inst.s genblk1\[12\].fa_inst.a 0
C5329 pmu_inst/dc_inst.in cout_next 0
C5330 _280_/a_761_289# _025_ 0
C5331 _285_/a_27_47# net19 0.0275f
C5332 _284_/a_27_47# net32 0.02884f
C5333 clknet_2_1__leaf_clk_regs _071_ 0
C5334 _276_/a_27_47# _291_/a_1108_47# 0
C5335 net58 _280_/a_1283_21# 0.03821f
C5336 genblk1\[8\].fa_inst.s net62 0
C5337 genblk1\[1\].fa_inst.b net12 0
C5338 net46 pmu_inst/dc_inst.x6.net5 0.00404f
C5339 _037_ clknet_2_0__leaf_clk_regs 0.43216f
C5340 _275_/a_761_289# net10 0
C5341 _273_/a_448_47# genblk1\[1\].fa_inst.a 0
C5342 VPWR pmu_inst/dc_inst.x6.x18/a_27_47# 0.0024f
C5343 _165_/a_150_297# genblk1\[8\].fa_inst.a 0.00124f
C5344 _300_/a_448_47# net60 0
C5345 _300_/a_1283_21# _044_ 0
C5346 net5 clknet_2_2__leaf_clk_regs 0.03694f
C5347 genblk1\[1\].fa_inst.a genblk1\[2\].fa_inst.b 0
C5348 net16 _278_/a_27_47# 0.02396f
C5349 net17 net5 0.03864f
C5350 clknet_2_1__leaf_clk_regs _040_ 0
C5351 _148_/a_215_297# _062_ 0.09508f
C5352 net52 net62 0.1763f
C5353 _276_/a_193_47# net14 0
C5354 net17 _278_/a_1283_21# 0.00772f
C5355 net7 net36 0.02162f
C5356 _169_/a_285_47# VPWR 0.00114f
C5357 _301_/a_543_47# _046_ 0.00279f
C5358 VPWR _261_/a_543_47# 0.01187f
C5359 input30/a_75_212# net6 0.01946f
C5360 _275_/a_543_47# _274_/a_1108_47# 0
C5361 _275_/a_651_413# _274_/a_193_47# 0
C5362 _275_/a_193_47# _274_/a_651_413# 0
C5363 _275_/a_1283_21# _274_/a_1283_21# 0
C5364 genblk1\[3\].fa_inst.b _141_/a_113_47# 0
C5365 net28 _085_ 0
C5366 _284_/a_543_47# net59 0
C5367 net47 pmu_inst/dc_inst.x3.net2 0.00571f
C5368 net4 net16 0.02414f
C5369 _283_/a_27_47# _283_/a_193_47# -0.15611f
C5370 _266_/a_1108_47# clknet_2_3__leaf_clk_regs 0
C5371 _259_/a_1462_47# net57 0
C5372 _270_/a_27_47# _015_ -0
C5373 net46 pmu_inst/dc_inst.x6.x14/a_27_47# 0.00271f
C5374 _258_/a_639_47# net36 0.00119f
C5375 _164_/a_285_47# genblk1\[7\].fa_inst.s 0.00392f
C5376 _284_/a_193_47# _298_/a_761_289# 0
C5377 _284_/a_761_289# _298_/a_193_47# 0
C5378 _284_/a_543_47# _298_/a_27_47# 0
C5379 net39 pmu_inst/_08_ 0.01233f
C5380 _025_ _040_ 0
C5381 _046_ genblk1\[14\].fa_inst.a 0
C5382 output47/a_27_47# VPWR 0.09825f
C5383 _083_ _087_ 0
C5384 _131_/a_68_297# genblk1\[1\].fa_inst.b 0.01565f
C5385 _277_/a_448_47# clknet_2_1__leaf_clk_regs 0
C5386 clkload0/a_361_47# _005_ 0.09627f
C5387 genblk1\[10\].fa_inst.a _175_/a_68_297# 0.00336f
C5388 _274_/a_761_289# net56 0
C5389 net48 net73 0.06256f
C5390 _281_/a_805_47# genblk1\[9\].fa_inst.a 0
C5391 net6 input27/a_75_212# 0.02109f
C5392 net17 clknet_2_2__leaf_clk_regs 0
C5393 clknet_2_1__leaf_clk_regs input11/a_75_212# 0.00392f
C5394 _277_/a_193_47# net36 0.00115f
C5395 _284_/a_27_47# net19 0
C5396 _284_/a_1217_47# clknet_2_3__leaf_clk_regs 0
C5397 net39 pmu_inst/dc_inst.x5.x19/a_27_47# 0.00196f
C5398 net39 pmu_inst/dc_inst.x7.x6/a_27_47# 0
C5399 VPWR _077_ 0.61879f
C5400 _282_/a_1270_413# net30 0
C5401 _283_/a_639_47# net30 0.0015f
C5402 _300_/a_1283_21# net19 0.00247f
C5403 _045_ _299_/a_543_47# 0
C5404 _134_/a_285_47# genblk1\[1\].fa_inst.s 0.00392f
C5405 _293_/a_448_47# VPWR 0.00109f
C5406 net58 _063_ 0
C5407 net48 net47 0.00994f
C5408 _276_/a_761_289# _291_/a_761_289# 0.00117f
C5409 _280_/a_805_47# genblk1\[8\].fa_inst.a 0
C5410 fanout59/a_27_47# _264_/a_1108_47# 0
C5411 net61 _264_/a_761_289# 0
C5412 net7 _295_/a_761_289# 0
C5413 _285_/a_1217_47# net19 0
C5414 pmu_inst/dc_inst.x3.x9/a_27_47# net67 0
C5415 _276_/a_27_47# net26 0
C5416 fanout58/a_27_47# _262_/a_193_47# 0.00274f
C5417 _286_/a_27_47# clknet_2_3__leaf_clk_regs 0.3809f
C5418 net39 output39/a_27_47# 0.01988f
C5419 net61 _266_/a_27_47# 0
C5420 net62 net51 0.02885f
C5421 net39 pmu_inst/dc_inst.x2.x11/a_27_47# 0.00303f
C5422 net64 net70 -0
C5423 _294_/a_193_47# net26 0
C5424 _018_ genblk1\[1\].fa_inst.a 0.11206f
C5425 _294_/a_543_47# net58 0.00107f
C5426 _045_ net60 0.16138f
C5427 genblk1\[3\].fa_inst.a _062_ 0.00385f
C5428 net33 _150_/a_68_297# 0.01039f
C5429 clknet_2_0__leaf_clk_regs genblk1\[6\].fa_inst.s 0
C5430 net24 a[8] 0
C5431 net47 pmu_inst/dc_inst.x3.x12/a_27_47# 0.0014f
C5432 genblk1\[12\].fa_inst.b _098_ 0.15216f
C5433 _093_ genblk1\[12\].fa_inst.a 0
C5434 _018_ _272_/a_193_47# 0
C5435 _273_/a_543_47# clknet_2_0__leaf_clk_regs 0
C5436 net43 cout_next 0.02886f
C5437 net39 pmu_inst/_18_/a_218_374# 0
C5438 _020_ _274_/a_761_289# 0
C5439 _269_/a_651_413# net44 0
C5440 net55 net71 0.00571f
C5441 _152_/a_113_47# _070_ 0
C5442 _164_/a_47_47# net62 0.05888f
C5443 _273_/a_761_289# net1 0
C5444 _273_/a_193_47# VPWR 0.02064f
C5445 _068_ _069_ 0
C5446 net33 _284_/a_1108_47# 0
C5447 input11/a_75_212# net11 0.00198f
C5448 _063_ _057_ 0
C5449 VPWR _295_/a_651_413# 0.00145f
C5450 _057_ _056_ 0
C5451 net48 net36 0.08506f
C5452 _199_/a_47_47# _205_/a_285_47# 0
C5453 net60 _194_/a_47_47# 0.05519f
C5454 _022_ _292_/a_1108_47# 0
C5455 clknet_2_1__leaf_clk_regs b[0] 0
C5456 VPWR pmu_inst/dc_inst.x5.net4 0
C5457 _131_/a_150_297# VPWR 0
C5458 VPWR _173_/a_215_297# 0.01159f
C5459 net33 genblk1\[13\].fa_inst.b 0.07569f
C5460 _129_/a_377_297# _050_ 0
C5461 _285_/a_639_47# net18 0.00221f
C5462 _105_ _102_ 0
C5463 _168_/a_215_297# _080_ 0.01846f
C5464 net52 output52/a_27_47# 0.12466f
C5465 net59 _296_/a_761_289# 0.00944f
C5466 VPWR _280_/a_543_47# 0.01619f
C5467 genblk1\[11\].fa_inst.a net30 0.0014f
C5468 VPWR _143_/a_382_47# -0
C5469 _149_/a_47_47# _061_ 0
C5470 net28 genblk1\[7\].fa_inst.b 0.03564f
C5471 _174_/a_129_47# _088_ 0.00176f
C5472 _286_/a_27_47# net19 0.18097f
C5473 clk _265_/a_639_47# 0.00158f
C5474 net61 _266_/a_1217_47# 0
C5475 net46 pmu_inst/dc_inst.x7.x4/a_27_47# 0
C5476 net26 net14 0.02345f
C5477 clknet_2_2__leaf_clk_regs _297_/a_27_47# 0.24184f
C5478 a[12] net15 0.0335f
C5479 net29 net26 0
C5480 net42 cout_next 0.03072f
C5481 _288_/a_761_289# net56 0.00101f
C5482 output49/a_27_47# s[5] 0
C5483 _280_/a_1108_47# genblk1\[7\].fa_inst.a 0
C5484 cout_next _110_ 0.11916f
C5485 _284_/a_1108_47# net35 0.0531f
C5486 clknet_2_1__leaf_clk_regs _262_/a_639_47# 0
C5487 clknet_2_3__leaf_clk_regs genblk1\[13\].fa_inst.s 0.10192f
C5488 _147_/a_113_47# _066_ 0
C5489 net7 _280_/a_639_47# 0.0021f
C5490 _275_/a_805_47# genblk1\[2\].fa_inst.a 0
C5491 clknet_2_0__leaf_clk_regs _135_/a_27_413# 0
C5492 _290_/a_1283_21# _289_/a_1283_21# 0
C5493 _071_ _072_ 0.17058f
C5494 clkbuf_regs_0_clk/a_110_47# VPWR 0.19168f
C5495 _263_/a_193_47# net59 0
C5496 net6 net36 0.01218f
C5497 _255_/a_805_47# net57 0
C5498 _130_/a_298_297# net56 0
C5499 _304_/a_448_47# genblk1\[1\].fa_inst.b 0.01425f
C5500 genblk1\[4\].fa_inst.a clknet_2_0__leaf_clk_regs 0
C5501 net3 _296_/a_543_47# 0.01234f
C5502 _273_/a_1462_47# VPWR 0
C5503 _276_/a_1270_413# net56 0
C5504 _283_/a_543_47# genblk1\[11\].fa_inst.a 0
C5505 _258_/a_193_47# genblk1\[3\].fa_inst.s 0.10963f
C5506 _283_/a_1108_47# _027_ 0
C5507 net55 pmu_inst/dc_inst.x5.x2/a_27_47# 0
C5508 _279_/a_1283_21# _279_/a_1108_47# 0
C5509 _282_/a_193_47# genblk1\[10\].fa_inst.a 0
C5510 _282_/a_1283_21# _027_ 0.00228f
C5511 _107_ _110_ 0.32776f
C5512 _022_ net27 0
C5513 _076_ genblk1\[6\].fa_inst.a 0.03922f
C5514 net7 _283_/a_27_47# 0.02687f
C5515 VPWR _269_/a_651_413# 0
C5516 genblk1\[8\].fa_inst.a net62 0
C5517 _304_/a_448_47# _288_/a_1283_21# 0
C5518 _289_/a_639_47# a[6] 0
C5519 _302_/a_193_47# _302_/a_448_47# -0
C5520 genblk1\[13\].fa_inst.a net18 0
C5521 net47 pmu_inst/clkbuf_0_clk/a_110_47# 0.02035f
C5522 net33 _201_/a_61_47# 0
C5523 _301_/a_1108_47# clknet_2_3__leaf_clk_regs 0
C5524 clknet_2_3__leaf_clk_regs input19/a_75_212# 0.01338f
C5525 clknet_2_0__leaf_clk_regs _053_ 0
C5526 _294_/a_1270_413# net58 0
C5527 _273_/a_1270_413# net8 0
C5528 fanout60/a_27_47# _268_/a_27_47# 0
C5529 _303_/a_543_47# clknet_2_3__leaf_clk_regs 0.02969f
C5530 _052_ _051_ 0.01015f
C5531 net62 _279_/a_1283_21# 0.0285f
C5532 _189_/a_47_47# genblk1\[11\].fa_inst.b 0
C5533 a[6] input14/a_75_212# 0
C5534 input13/a_75_212# a[7] 0
C5535 _192_/a_113_47# _102_ 0
C5536 _098_ _198_/a_215_297# 0
C5537 net33 genblk1\[14\].fa_inst.b 0.03009f
C5538 _301_/a_651_413# net60 0
C5539 b[6] net32 0
C5540 net46 pmu_inst/dc_inst.x6.net4 0.00381f
C5541 _079_ genblk1\[7\].fa_inst.a 0
C5542 genblk1\[12\].fa_inst.b VPWR 1.68843f
C5543 _286_/a_1217_47# net19 0
C5544 clk net40 0
C5545 _100_ genblk1\[12\].fa_inst.b 0
C5546 clknet_2_2__leaf_clk_regs _297_/a_1217_47# 0
C5547 VPWR _283_/a_1108_47# 0.03637f
C5548 fanout61/a_27_47# VPWR 0.08472f
C5549 _303_/a_1108_47# net60 0.00108f
C5550 _255_/a_27_47# _255_/a_193_47# -0.01782f
C5551 VPWR _282_/a_1283_21# 0.07592f
C5552 VPWR pmu_inst/dc_inst.x5.x14/a_27_47# 0
C5553 net3 _281_/a_543_47# 0.00665f
C5554 net39 pmu_inst/dc_inst.x7.net8 0
C5555 _054_ _304_/a_27_47# 0.00156f
C5556 _257_/a_543_47# net57 0.01085f
C5557 clk _267_/a_761_289# 0.00122f
C5558 net46 pmu_inst/dc_inst.x6.x13/a_27_47# 0.00272f
C5559 _276_/a_193_47# _291_/a_27_47# 0.00126f
C5560 genblk1\[4\].fa_inst.s _149_/a_47_47# 0.00719f
C5561 s[8] VPWR 0.37243f
C5562 _099_ _193_/a_27_413# 0
C5563 net7 genblk1\[8\].fa_inst.a 0
C5564 net46 pmu_inst/dc_inst.x1.net12 0.00617f
C5565 s[12] output41/a_27_47# 0
C5566 VPWR pmu_inst/_15_/a_27_47# 0.00451f
C5567 _142_/a_113_47# _062_ 0
C5568 _049_ genblk1\[1\].fa_inst.b 0.00368f
C5569 net24 b[1] 0.00165f
C5570 _107_ _105_ 0.40085f
C5571 net39 pmu_inst/dc_inst.x6.net9 0.00198f
C5572 _277_/a_27_47# _291_/a_1283_21# 0
C5573 _023_ _278_/a_543_47# -0
C5574 VPWR clkbuf_0_clk_regs/a_110_47# 0.21852f
C5575 genblk1\[12\].fa_inst.a net18 0
C5576 _272_/a_448_47# clknet_2_0__leaf_clk_regs 0.01786f
C5577 _272_/a_1283_21# _017_ 0.03592f
C5578 _272_/a_193_47# genblk1\[0\].fa_inst.a -0
C5579 _279_/a_27_47# genblk1\[7\].fa_inst.a 0
C5580 _279_/a_543_47# _024_ 0
C5581 _282_/a_1462_47# genblk1\[10\].fa_inst.a 0
C5582 net39 pmu_inst/dc_inst.x1.x10/a_27_47# 0.0075f
C5583 genblk1\[7\].fa_inst.s _262_/a_27_47# 0.11298f
C5584 net33 _288_/a_1108_47# 0
C5585 _276_/a_27_47# _035_ 0.03245f
C5586 net3 _278_/a_543_47# 0.0128f
C5587 net7 _282_/a_805_47# 0
C5588 _272_/a_1108_47# net1 0
C5589 _272_/a_1283_21# VPWR 0.0265f
C5590 net46 pmu_inst/dc_inst.x6.x12/a_27_47# 0.00275f
C5591 _290_/a_448_47# net14 0
C5592 clk net61 0.15637f
C5593 _302_/a_543_47# net7 0.01436f
C5594 _302_/a_193_47# _047_ 0.00537f
C5595 _302_/a_761_289# net22 0
C5596 net28 _040_ 0.02101f
C5597 net21 clknet_2_3__leaf_clk_regs 0.08344f
C5598 input19/a_75_212# net19 0.0021f
C5599 b[15] net36 0
C5600 genblk1\[3\].fa_inst.a _288_/a_805_47# 0.00279f
C5601 fanout57/a_27_47# clkbuf_2_0__f_clk_regs/a_110_47# 0
C5602 _098_ _102_ 0
C5603 clkload1/Y clkbuf_2_2__f_clk_regs/a_110_47# 0.00246f
C5604 input18/a_75_212# net18 0.0021f
C5605 net46 pmu_inst/dc_inst.x5.x17/a_27_47# 0
C5606 _261_/a_1283_21# _260_/a_761_289# 0
C5607 _270_/a_1283_21# net61 0.02633f
C5608 _286_/a_448_47# net36 0.01119f
C5609 net29 _294_/a_761_289# 0
C5610 VPWR pmu_inst/dc_inst.x4.x19/a_27_47# 0
C5611 net27 net24 0
C5612 _274_/a_27_47# _273_/a_761_289# 0
C5613 _274_/a_193_47# _273_/a_193_47# 0
C5614 _274_/a_761_289# _273_/a_27_47# 0.00833f
C5615 _256_/a_193_47# clknet_2_0__leaf_clk_regs 0.00559f
C5616 a[13] net13 0
C5617 VPWR _279_/a_639_47# 0
C5618 _262_/a_1283_21# net62 0
C5619 net39 pmu_inst/dc_inst.x4.net7 0.0117f
C5620 _073_ genblk1\[7\].fa_inst.a 0
C5621 _179_/a_47_47# _091_ 0.01334f
C5622 _302_/a_1270_413# VPWR 0
C5623 _292_/a_27_47# net17 0
C5624 net13 _278_/a_761_289# 0
C5625 _303_/a_27_47# net34 0.03476f
C5626 VPWR clkbuf_2_3__f_clk_regs/a_110_47# 0.0982f
C5627 net28 _283_/a_1283_21# 0
C5628 net45 clknet_2_3__leaf_clk_regs 3.91996f
C5629 net28 _282_/a_543_47# 0
C5630 _086_ genblk1\[9\].fa_inst.b 0.07851f
C5631 genblk1\[3\].fa_inst.a _054_ 0.00654f
C5632 VPWR pmu_inst/_15_/a_1064_47# 0
C5633 _258_/a_1283_21# clknet_2_0__leaf_clk_regs 0
C5634 _284_/a_543_47# net30 0
C5635 _293_/a_1283_21# genblk1\[5\].fa_inst.b 0.03971f
C5636 net33 _111_ 0
C5637 VPWR pmu_inst/dc_inst.x7.x18/a_27_47# 0
C5638 _258_/a_761_289# VPWR 0.00808f
C5639 net27 _296_/a_805_47# 0
C5640 net2 _282_/a_1283_21# 0
C5641 _276_/a_193_47# net56 0.00276f
C5642 _174_/a_47_47# genblk1\[9\].fa_inst.s 0.00512f
C5643 _181_/a_113_47# genblk1\[11\].fa_inst.b 0
C5644 clknet_2_0__leaf_clk_regs _017_ 0.42062f
C5645 _139_/a_47_47# _060_ 0.03533f
C5646 _279_/a_1217_47# genblk1\[7\].fa_inst.a 0
C5647 VPWR input37/a_75_212# 0.09063f
C5648 net33 clknet_2_2__leaf_clk_regs 0.02687f
C5649 net46 pmu_inst/dc_inst.x2.net12 0
C5650 net33 net17 0.05351f
C5651 net33 _145_/a_150_297# 0
C5652 _163_/a_215_297# _078_ 0
C5653 net6 _283_/a_27_47# 0
C5654 _301_/a_27_47# net36 0
C5655 _035_ net14 0
C5656 clknet_2_0__leaf_clk_regs VPWR 9.34352f
C5657 genblk1\[7\].fa_inst.s _262_/a_543_47# 0.00118f
C5658 _302_/a_1462_47# _047_ 0
C5659 VPWR _198_/a_215_297# -0.00292f
C5660 net21 net19 0
C5661 _100_ _198_/a_215_297# 0
C5662 net5 net35 0.3917f
C5663 a[0] VPWR 0.33938f
C5664 net29 _295_/a_27_47# 0.02704f
C5665 _262_/a_448_47# net62 0.01888f
C5666 _054_ genblk1\[0\].fa_inst.b 0
C5667 _067_ _066_ 0.01862f
C5668 VPWR _172_/a_113_47# -0
C5669 VPWR pmu_inst/dc_inst.x1.net11 0.00377f
C5670 clknet_2_1__leaf_clk_regs _074_ 0
C5671 genblk1\[2\].fa_inst.s _054_ 0
C5672 _048_ _287_/a_543_47# 0
C5673 genblk1\[15\].fa_inst.b _287_/a_27_47# 0
C5674 _031_ net36 0
C5675 _293_/a_193_47# genblk1\[6\].fa_inst.a 0.59115f
C5676 _110_ _204_/a_33_297# 0.00448f
C5677 _112_ _204_/a_561_297# 0.00126f
C5678 genblk1\[12\].fa_inst.b _300_/a_1108_47# 0
C5679 VPWR _090_ 0.72264f
C5680 genblk1\[4\].fa_inst.a _062_ 0
C5681 _269_/a_651_413# genblk1\[14\].fa_inst.s 0.00211f
C5682 VPWR pmu_inst_66/HI 0.05193f
C5683 b[12] net36 0
C5684 a[0] input8/a_75_212# 0
C5685 input1/a_75_212# a[1] 0.07599f
C5686 _068_ _066_ 0.00117f
C5687 _085_ _170_/a_150_297# 0
C5688 net36 net31 0.02718f
C5689 a[8] net15 0.00502f
C5690 _291_/a_27_47# net26 0.04061f
C5691 genblk1\[6\].fa_inst.b _076_ 0.00295f
C5692 _255_/a_543_47# net39 0
C5693 _255_/a_448_47# _000_ 0
C5694 _275_/a_27_47# net56 0
C5695 VPWR genblk1\[7\].fa_inst.a 0.81778f
C5696 VPWR genblk1\[9\].fa_inst.s 1.59499f
C5697 _265_/a_1108_47# clknet_2_3__leaf_clk_regs 0
C5698 _265_/a_27_47# net40 0
C5699 _265_/a_543_47# _010_ 0
C5700 _271_/a_27_47# clknet_2_3__leaf_clk_regs 0.0363f
C5701 _038_ genblk1\[6\].fa_inst.a 0.24168f
C5702 _039_ _295_/a_1108_47# 0
C5703 _265_/a_805_47# genblk1\[10\].fa_inst.s 0
C5704 _256_/a_805_47# VPWR 0
C5705 _022_ net58 0.28077f
C5706 _263_/a_1283_21# net52 0
C5707 genblk1\[9\].fa_inst.a _092_ 0
C5708 clknet_2_1__leaf_clk_regs _289_/a_543_47# 0
C5709 net47 pmu_inst/dc_inst.x7.x13/a_27_47# 0.00134f
C5710 _110_ _109_ 0
C5711 _291_/a_1108_47# net56 0.01298f
C5712 _293_/a_448_47# _278_/a_27_47# 0
C5713 clknet_2_2__leaf_clk_regs net35 0.0226f
C5714 _129_/a_47_47# genblk1\[1\].fa_inst.s 0
C5715 _052_ _134_/a_285_47# 0
C5716 net75 _134_/a_129_47# 0.00128f
C5717 _129_/a_285_47# _056_ 0.00118f
C5718 genblk1\[8\].fa_inst.s clk 0.01019f
C5719 _198_/a_382_47# _102_ 0
C5720 _297_/a_1108_47# _042_ -0.01922f
C5721 _297_/a_448_47# net32 0.00207f
C5722 net28 genblk1\[9\].fa_inst.b 0.03191f
C5723 net39 pmu_inst/_20_/a_79_21# 0
C5724 _039_ _280_/a_193_47# 0
C5725 _281_/a_651_413# _295_/a_27_47# 0
C5726 _270_/a_448_47# genblk1\[15\].fa_inst.s 0.00574f
C5727 cin_q _051_ 0.00293f
C5728 _262_/a_1270_413# _007_ -0
C5729 clk net52 0.05929f
C5730 clknet_0_clk_regs net54 0.0216f
C5731 VPWR _102_ 0.33897f
C5732 _094_ clknet_2_3__leaf_clk_regs 0.05339f
C5733 net44 cout_next 0.97968f
C5734 _275_/a_27_47# _020_ 0
C5735 _256_/a_761_289# net46 0.00139f
C5736 _256_/a_1108_47# _001_ 0.00809f
C5737 s[9] s[8] 0
C5738 _268_/a_27_47# net60 0.00955f
C5739 _015_ net34 0
C5740 VPWR pmu_inst/dc_inst.x7.net19 0
C5741 clkbuf_2_0__f_clk_regs/a_110_47# _260_/a_651_413# 0
C5742 clknet_0_clk_regs _260_/a_1283_21# 0.00503f
C5743 _296_/a_761_289# net30 0.01473f
C5744 net61 _265_/a_27_47# 0
C5745 _303_/a_639_47# net36 0
C5746 a[9] net36 0
C5747 _130_/a_27_413# _051_ 0.00689f
C5748 genblk1\[11\].fa_inst.b _299_/a_639_47# 0
C5749 _276_/a_193_47# _290_/a_193_47# 0.00195f
C5750 _260_/a_761_289# genblk1\[5\].fa_inst.s 0
C5751 _105_ _204_/a_33_297# 0
C5752 net39 pmu_inst/_07_ 0.02106f
C5753 _264_/a_193_47# net62 0
C5754 genblk1\[12\].fa_inst.b net20 0
C5755 _304_/a_761_289# net56 0.00112f
C5756 _289_/a_543_47# net11 0.01674f
C5757 clknet_2_0__leaf_clk_regs net2 0.02241f
C5758 clknet_0_clk_regs _263_/a_27_47# 0
C5759 _294_/a_27_47# net26 0.00939f
C5760 genblk1\[2\].fa_inst.a _273_/a_1283_21# 0
C5761 _274_/a_1283_21# genblk1\[1\].fa_inst.a 0.00678f
C5762 _291_/a_805_47# _036_ 0
C5763 VPWR a[10] 0.23692f
C5764 net29 _280_/a_651_413# 0.0026f
C5765 _265_/a_1217_47# net40 0
C5766 _271_/a_1217_47# clknet_2_3__leaf_clk_regs 0
C5767 clknet_2_3__leaf_clk_regs _299_/a_448_47# 0
C5768 _271_/a_193_47# net38 -0
C5769 _271_/a_1283_21# _016_ 0.01f
C5770 _097_ genblk1\[13\].fa_inst.a 0
C5771 _105_ _109_ 0
C5772 net12 net36 0.73184f
C5773 _294_/a_193_47# _279_/a_761_289# 0
C5774 _299_/a_448_47# net32 0
C5775 net26 net56 0.00442f
C5776 _183_/a_298_297# _091_ 0.00167f
C5777 genblk1\[11\].fa_inst.s _266_/a_1108_47# 0
C5778 _282_/a_761_289# _296_/a_761_289# 0
C5779 _282_/a_543_47# _296_/a_193_47# 0
C5780 _282_/a_193_47# _296_/a_543_47# 0
C5781 net60 _299_/a_1270_413# 0
C5782 _044_ _299_/a_448_47# 0.00183f
C5783 clk net51 0.02886f
C5784 net2 genblk1\[7\].fa_inst.a 0
C5785 net32 _042_ 0.0044f
C5786 _179_/a_285_47# _092_ 0.00633f
C5787 _268_/a_639_47# clknet_2_3__leaf_clk_regs 0
C5788 net25 net16 0.02259f
C5789 _039_ _280_/a_1462_47# 0
C5790 _026_ _295_/a_193_47# 0
C5791 _281_/a_193_47# _040_ 0
C5792 _281_/a_761_289# net30 0.00493f
C5793 clkload1/a_268_47# clknet_2_2__leaf_clk_regs 0.00119f
C5794 net3 _297_/a_805_47# 0
C5795 _015_ genblk1\[15\].fa_inst.s 0.00501f
C5796 net17 _295_/a_543_47# 0
C5797 _267_/a_27_47# net60 0
C5798 net46 pmu_inst/dc_inst.net4 0.0169f
C5799 net4 _280_/a_543_47# 0.00339f
C5800 net47 pmu_inst/dc_inst.x7.x20/a_27_47# 0.00255f
C5801 _300_/a_543_47# VPWR 0.02815f
C5802 net39 pmu_inst/dc_inst.x5.x9/a_27_47# 0.00194f
C5803 genblk1\[7\].fa_inst.s _007_ 0.00446f
C5804 _200_/a_59_75# _109_ 0.00176f
C5805 genblk1\[3\].fa_inst.a _148_/a_27_413# 0
C5806 genblk1\[15\].fa_inst.b net36 0
C5807 net33 _299_/a_27_47# 0.0013f
C5808 clkbuf_2_3__f_clk_regs/a_110_47# _266_/a_448_47# 0
C5809 net47 pmu_inst/_24_/a_1108_47# 0.00183f
C5810 _148_/a_298_297# _068_ 0.00258f
C5811 VPWR _262_/a_761_289# 0.00865f
C5812 _268_/a_27_47# _013_ 0.00213f
C5813 VPWR _285_/a_805_47# 0
C5814 net56 _132_/a_113_47# 0
C5815 net27 _277_/a_543_47# 0
C5816 VPWR _190_/a_68_297# 0.02622f
C5817 _277_/a_1283_21# _291_/a_1108_47# 0
C5818 genblk1\[8\].fa_inst.s _084_ 0.00351f
C5819 clknet_2_3__leaf_clk_regs _298_/a_1283_21# 0
C5820 VPWR cout_next 7.99822f
C5821 genblk1\[15\].fa_inst.b _195_/a_68_297# 0
C5822 _193_/a_382_47# _104_ 0.00136f
C5823 VPWR pmu_inst/dc_inst.x3.x14/a_27_47# 0
C5824 clknet_0_clk_regs _263_/a_1217_47# 0
C5825 _097_ genblk1\[12\].fa_inst.a 0.14439f
C5826 _178_/a_298_297# net59 0.00113f
C5827 genblk1\[2\].fa_inst.a clknet_2_1__leaf_clk_regs 0.03449f
C5828 _259_/a_27_47# VPWR 0.07127f
C5829 net61 _268_/a_1283_21# 0.06874f
C5830 _199_/a_47_47# _108_ 0.06726f
C5831 net7 _284_/a_1108_47# 0.00343f
C5832 _277_/a_1217_47# net16 0
C5833 VPWR _264_/a_448_47# 0.00113f
C5834 _299_/a_448_47# net19 0.00259f
C5835 _273_/a_805_47# net9 0
C5836 net27 _294_/a_805_47# 0
C5837 net36 _297_/a_193_47# 0
C5838 _271_/a_1462_47# net38 0
C5839 VPWR _107_ 0.03063f
C5840 _287_/a_651_413# clknet_2_3__leaf_clk_regs 0
C5841 _304_/a_761_289# _055_ 0.00129f
C5842 VPWR _062_ 0.19691f
C5843 _274_/a_193_47# clknet_2_0__leaf_clk_regs 0.58729f
C5844 VPWR pmu_inst/dc_inst.x7.x8/a_27_47# 0.00723f
C5845 genblk1\[10\].fa_inst.b _298_/a_448_47# 0
C5846 _302_/a_1108_47# _286_/a_1283_21# 0
C5847 VPWR _266_/a_1283_21# 0.00711f
C5848 net7 genblk1\[13\].fa_inst.b 0
C5849 clknet_2_0__leaf_clk_regs _069_ 0
C5850 _129_/a_129_47# VPWR -0
C5851 VPWR pmu_inst/dc_inst.x4.net5 0.00418f
C5852 genblk1\[1\].fa_inst.a genblk1\[1\].fa_inst.b 0.2214f
C5853 net14 _279_/a_761_289# 0
C5854 _304_/a_1108_47# net33 0
C5855 _304_/a_1283_21# _049_ 0.03284f
C5856 _292_/a_761_289# _036_ 0
C5857 _080_ genblk1\[7\].fa_inst.b 0
C5858 _283_/a_27_47# net31 0.02826f
C5859 VPWR pmu_inst/dc_inst.x1.net8 0.00874f
C5860 a[10] net2 0.00159f
C5861 _293_/a_27_47# _293_/a_761_289# -0.01661f
C5862 _287_/a_639_47# net60 0
C5863 net43 clknet_2_3__leaf_clk_regs 0
C5864 net5 _283_/a_193_47# 0
C5865 net59 _298_/a_651_413# 0
C5866 _267_/a_27_47# _267_/a_448_47# -0.00373f
C5867 genblk1\[1\].fa_inst.a _288_/a_1283_21# 0
C5868 _264_/a_1270_413# genblk1\[9\].fa_inst.s 0
C5869 net17 _059_ 0
C5870 VPWR pmu_inst/dc_inst.x5.net18 0
C5871 a[11] net3 0.00159f
C5872 _075_ genblk1\[7\].fa_inst.a 0
C5873 _084_ _165_/a_68_297# 0
C5874 _302_/a_1283_21# genblk1\[14\].fa_inst.b 0.00584f
C5875 output55/a_27_47# VPWR 0.07052f
C5876 VPWR _289_/a_1283_21# 0.03399f
C5877 clkload0/a_27_47# clkbuf_2_0__f_clk_regs/a_110_47# 0.07461f
C5878 VPWR _284_/a_805_47# 0
C5879 _158_/a_215_297# _071_ 0
C5880 _272_/a_27_47# _288_/a_1108_47# 0
C5881 _272_/a_761_289# _288_/a_543_47# 0
C5882 _272_/a_1283_21# _288_/a_193_47# 0
C5883 _272_/a_543_47# _288_/a_761_289# 0
C5884 _257_/a_1283_21# genblk1\[2\].fa_inst.s 0
C5885 _257_/a_27_47# net47 0.00145f
C5886 _257_/a_543_47# _002_ 0
C5887 _291_/a_193_47# net25 0
C5888 _291_/a_27_47# _035_ 0
C5889 _178_/a_215_297# _085_ 0.08659f
C5890 _300_/a_27_47# _285_/a_1283_21# 0
C5891 _300_/a_543_47# _285_/a_193_47# 0
C5892 _300_/a_193_47# _285_/a_543_47# 0
C5893 genblk1\[2\].fa_inst.a net11 0.1035f
C5894 genblk1\[6\].fa_inst.b _038_ 0
C5895 net47 pmu_inst/_25_/a_448_47# 0.00271f
C5896 net33 _299_/a_1217_47# 0
C5897 clkbuf_2_3__f_clk_regs/a_110_47# _011_ 0.00759f
C5898 _268_/a_1217_47# _013_ 0
C5899 net47 pmu_inst/dc_inst.x8/a_1290_413# 0.0011f
C5900 _280_/a_448_47# net16 0
C5901 net60 net34 0.02392f
C5902 net33 _287_/a_193_47# 0
C5903 a[4] input9/a_75_212# 0
C5904 net47 pmu_inst/dc_inst.x9/a_27_413# 0
C5905 net27 net15 0
C5906 _281_/a_1270_413# _025_ 0
C5907 _281_/a_1108_47# genblk1\[8\].fa_inst.a 0
C5908 _189_/a_47_47# _193_/a_215_297# 0
C5909 net61 _267_/a_1283_21# 0.01279f
C5910 _262_/a_193_47# _262_/a_27_47# -0.12787f
C5911 _270_/a_27_47# _014_ 0
C5912 _302_/a_27_47# _301_/a_543_47# 0
C5913 _302_/a_543_47# _301_/a_27_47# 0
C5914 _302_/a_761_289# _301_/a_193_47# 0
C5915 _291_/a_639_47# net36 0
C5916 _277_/a_1108_47# net17 0.00137f
C5917 _132_/a_113_47# _055_ 0
C5918 _293_/a_1283_21# _076_ 0.00119f
C5919 _283_/a_193_47# clknet_2_2__leaf_clk_regs 0.0045f
C5920 _130_/a_215_297# genblk1\[1\].fa_inst.s 0
C5921 _054_ _135_/a_27_413# 0.07375f
C5922 _282_/a_27_47# clknet_2_2__leaf_clk_regs 0.13953f
C5923 VPWR _009_ 0.04496f
C5924 VPWR _128_/a_113_47# -0
C5925 _084_ _081_ 0.14256f
C5926 input22/a_75_212# net35 0.00446f
C5927 clknet_2_0__leaf_clk_regs _260_/a_543_47# 0.00296f
C5928 _293_/a_1108_47# genblk1\[5\].fa_inst.a 0
C5929 genblk1\[10\].fa_inst.b _043_ 0.10026f
C5930 _302_/a_27_47# genblk1\[14\].fa_inst.a 0
C5931 _302_/a_543_47# _031_ 0.00227f
C5932 clknet_2_3__leaf_clk_regs _110_ 0
C5933 VPWR _260_/a_193_47# -0.02243f
C5934 net5 input17/a_27_47# 0.00546f
C5935 _286_/a_1108_47# net7 0.00761f
C5936 net42 clknet_2_3__leaf_clk_regs 0.01212f
C5937 net46 pmu_inst/_08_ 0.00735f
C5938 genblk1\[5\].fa_inst.a _145_/a_68_297# 0
C5939 _274_/a_805_47# VPWR 0
C5940 _275_/a_27_47# _273_/a_27_47# 0
C5941 _293_/a_27_47# _293_/a_543_47# -0.00936f
C5942 clknet_2_1__leaf_clk_regs net16 0.067f
C5943 genblk1\[15\].fa_inst.a net60 0.00181f
C5944 net10 net8 0
C5945 _267_/a_27_47# _012_ -0
C5946 net39 pmu_inst/dc_inst.x5.net8 0.00241f
C5947 _054_ _053_ 0.0815f
C5948 net75 hold1/a_285_47# 0.0042f
C5949 _183_/a_215_297# _096_ 0.01099f
C5950 net47 pmu_inst/_14_/a_505_21# 0.00281f
C5951 output51/a_27_47# s[7] 0
C5952 net27 _042_ 0
C5953 _298_/a_193_47# _043_ 0
C5954 _298_/a_761_289# net18 0
C5955 net7 genblk1\[14\].fa_inst.b 0
C5956 net46 pmu_inst/dc_inst.x5.x19/a_27_47# 0.00712f
C5957 net46 pmu_inst/dc_inst.x7.x6/a_27_47# 0.00131f
C5958 _279_/a_1283_21# _278_/a_1108_47# 0
C5959 _279_/a_1108_47# _278_/a_1283_21# 0
C5960 _287_/a_193_47# net35 0
C5961 _272_/a_27_47# net17 0
C5962 clknet_2_0__leaf_clk_regs _288_/a_193_47# 0.0481f
C5963 _257_/a_1217_47# net47 0
C5964 _021_ net13 0
C5965 net39 pmu_inst/dc_inst.x6.net6 0.01714f
C5966 net58 net53 0
C5967 clkbuf_2_1__f_clk_regs/a_110_47# _261_/a_193_47# 0.01345f
C5968 net1 _288_/a_27_47# 0
C5969 input13/a_75_212# net13 0.00286f
C5970 _259_/a_448_47# VPWR 0
C5971 _025_ net16 0
C5972 net33 _287_/a_1462_47# 0
C5973 VPWR _286_/a_805_47# 0
C5974 _285_/a_1108_47# _030_ 0.00643f
C5975 _285_/a_761_289# genblk1\[13\].fa_inst.a 0
C5976 net46 pmu_inst/dc_inst.x2.x11/a_27_47# 0
C5977 net47 pmu_inst/dc_inst.x9/a_668_97# 0
C5978 net4 _279_/a_639_47# 0.00158f
C5979 _286_/a_27_47# _285_/a_27_47# 0
C5980 _166_/a_113_47# _088_ 0
C5981 _035_ net56 0.06802f
C5982 _065_ net58 0
C5983 cout_next net71 0
C5984 net62 _278_/a_1283_21# 0.01485f
C5985 _262_/a_543_47# _262_/a_193_47# -0.00431f
C5986 net17 input17/a_27_47# 0.00208f
C5987 genblk1\[3\].fa_inst.b net36 0.065f
C5988 _277_/a_27_47# clknet_2_1__leaf_clk_regs 0.06572f
C5989 _277_/a_1462_47# net17 0
C5990 VPWR _296_/a_639_47# 0
C5991 _198_/a_298_297# genblk1\[13\].fa_inst.s 0
C5992 net16 _279_/a_193_47# 0.02954f
C5993 net46 pmu_inst/_18_/a_218_374# 0
C5994 _282_/a_1217_47# clknet_2_2__leaf_clk_regs 0
C5995 net27 _038_ 0
C5996 net17 _279_/a_1108_47# 0.00167f
C5997 net33 net35 0.05131f
C5998 _287_/a_1283_21# genblk1\[15\].fa_inst.a 0.00291f
C5999 _302_/a_1283_21# clknet_2_2__leaf_clk_regs 0
C6000 net3 net36 0.02502f
C6001 genblk1\[14\].fa_inst.s cout_next 0
C6002 genblk1\[2\].fa_inst.a _136_/a_150_297# 0
C6003 net47 pmu_inst/dc_inst.x10/a_505_21# 0.00101f
C6004 _292_/a_193_47# net36 0
C6005 net59 _295_/a_193_47# 0.0099f
C6006 clkload0/Y net58 0.04978f
C6007 clknet_0_clk_regs _265_/a_651_413# 0
C6008 _259_/a_805_47# clknet_2_0__leaf_clk_regs 0
C6009 clknet_2_0__leaf_clk_regs net4 0
C6010 _084_ genblk1\[8\].fa_inst.a 0
C6011 _283_/a_193_47# _297_/a_27_47# 0.00153f
C6012 _283_/a_27_47# _297_/a_193_47# 0
C6013 _258_/a_761_289# net57 0.00161f
C6014 clk _262_/a_1283_21# 0.05645f
C6015 _282_/a_27_47# _297_/a_27_47# 0
C6016 _267_/a_1270_413# net42 0
C6017 VPWR input9/a_75_212# 0.09181f
C6018 VPWR a[12] 0.23741f
C6019 _301_/a_1283_21# VPWR 0.0759f
C6020 net47 net74 0.00507f
C6021 _277_/a_543_47# net58 0.00521f
C6022 _107_ genblk1\[14\].fa_inst.s 0.00166f
C6023 clknet_2_0__leaf_clk_regs _060_ 0
C6024 net17 net62 0.11221f
C6025 VPWR _204_/a_33_297# 0.06042f
C6026 _300_/a_761_289# _045_ 0
C6027 _300_/a_543_47# net20 0
C6028 net5 net7 0.02748f
C6029 _291_/a_193_47# clknet_2_1__leaf_clk_regs 0.01159f
C6030 clknet_2_0__leaf_clk_regs net57 0.04799f
C6031 net71 pmu_inst/dc_inst.x5.net18 -0
C6032 _292_/a_1108_47# _037_ -0.00801f
C6033 _292_/a_761_289# genblk1\[4\].fa_inst.b 0
C6034 _292_/a_448_47# net27 0.01562f
C6035 net28 input28/a_75_212# 0.0021f
C6036 _303_/a_761_289# VPWR 0.01255f
C6037 _304_/a_1283_21# _143_/a_27_413# 0
C6038 net20 _285_/a_805_47# 0
C6039 _300_/a_27_47# _286_/a_1283_21# 0.00679f
C6040 pmu_inst/_18_/a_505_21# cout_next 0.00152f
C6041 VPWR _288_/a_805_47# 0
C6042 VPWR _281_/a_639_47# 0
C6043 net6 b[4] 0.04299f
C6044 _129_/a_47_47# _052_ 0.06472f
C6045 net33 _195_/a_150_297# 0
C6046 net4 genblk1\[7\].fa_inst.a 0
C6047 _273_/a_1108_47# net56 0
C6048 net47 pmu_inst/dc_inst.net9 0.00212f
C6049 net39 pmu_inst/dc_inst.x1.net14 0
C6050 _294_/a_27_47# _280_/a_651_413# 0
C6051 net3 _295_/a_761_289# 0.00621f
C6052 genblk1\[13\].fa_inst.b _101_ 0.12137f
C6053 clkload2/X clkbuf_2_3__f_clk_regs/a_110_47# 0.00273f
C6054 genblk1\[10\].fa_inst.b _089_ 0.01761f
C6055 VPWR _109_ 0.5886f
C6056 net46 pmu_inst/dc_inst.x2.x16/a_27_47# 0
C6057 _302_/a_639_47# net21 0.00176f
C6058 _269_/a_27_47# net60 0
C6059 _302_/a_1270_413# _046_ 0
C6060 net39 pmu_inst/dc_inst.x5.net10 0.00275f
C6061 _269_/a_193_47# _268_/a_1108_47# 0
C6062 _269_/a_448_47# _268_/a_27_47# 0
C6063 clk _262_/a_448_47# 0
C6064 _027_ genblk1\[9\].fa_inst.a 0.00146f
C6065 _256_/a_805_47# net57 0
C6066 _276_/a_1108_47# genblk1\[2\].fa_inst.a 0
C6067 VPWR _278_/a_639_47# 0
C6068 net28 _296_/a_1270_413# 0
C6069 _073_ genblk1\[6\].fa_inst.a 0.15862f
C6070 net17 net7 0.02597f
C6071 _199_/a_47_47# _201_/a_637_47# 0
C6072 net7 clknet_2_2__leaf_clk_regs 0.08771f
C6073 _304_/a_1108_47# _059_ 0
C6074 _291_/a_193_47# net11 0
C6075 _290_/a_761_289# net25 0
C6076 _290_/a_193_47# _035_ 0.00611f
C6077 _168_/a_382_47# VPWR -0
C6078 _185_/a_68_297# _299_/a_27_47# 0
C6079 _068_ _154_/a_47_47# 0
C6080 _286_/a_1108_47# net6 0
C6081 net59 _082_ 0
C6082 _275_/a_651_413# clknet_2_1__leaf_clk_regs 0.00108f
C6083 _275_/a_1108_47# _018_ 0
C6084 _020_ _273_/a_1108_47# 0
C6085 _054_ VPWR 0.91118f
C6086 clknet_2_0__leaf_clk_regs _070_ 0
C6087 _112_ _110_ 0.06655f
C6088 b[9] clknet_2_3__leaf_clk_regs 0.00141f
C6089 _264_/a_1108_47# net54 0
C6090 _284_/a_761_289# genblk1\[12\].fa_inst.a 0
C6091 _284_/a_1108_47# _029_ 0.0046f
C6092 _107_ _196_/a_113_47# 0
C6093 genblk1\[13\].fa_inst.s _104_ 0.02737f
C6094 a[3] net10 0.00233f
C6095 _290_/a_805_47# net36 0
C6096 _062_ _140_/a_68_297# 0
C6097 b[9] net32 0.00149f
C6098 net27 _037_ 0.02899f
C6099 net26 _040_ 0
C6100 _293_/a_1283_21# _038_ -0.00509f
C6101 _045_ genblk1\[13\].fa_inst.a 0
C6102 _183_/a_382_47# _089_ 0.00229f
C6103 _096_ _175_/a_68_297# 0
C6104 _269_/a_639_47# clknet_2_3__leaf_clk_regs 0
C6105 _274_/a_1108_47# net10 0
C6106 _274_/a_448_47# a[3] 0
C6107 net65 cout_next 0.08179f
C6108 _148_/a_215_297# _063_ 0.01165f
C6109 _277_/a_193_47# net17 0
C6110 VPWR genblk1\[9\].fa_inst.a 0.89152f
C6111 _266_/a_1283_21# _011_ 0.05555f
C6112 _266_/a_193_47# net41 0
C6113 net2 a[12] 0
C6114 net56 _135_/a_298_297# 0.00313f
C6115 _169_/a_47_47# genblk1\[8\].fa_inst.s 0.0026f
C6116 _256_/a_27_47# _255_/a_193_47# 0.00921f
C6117 _256_/a_193_47# _255_/a_27_47# 0.0049f
C6118 _160_/a_68_297# genblk1\[7\].fa_inst.b 0.05039f
C6119 clknet_2_0__leaf_clk_regs _066_ 0
C6120 _022_ net24 0
C6121 _101_ _201_/a_61_47# 0
C6122 net46 pmu_inst/dc_inst.x7.net8 0
C6123 clkload1/Y _092_ 0.00144f
C6124 _262_/a_193_47# _007_ -0.00197f
C6125 _014_ _268_/a_27_47# 0
C6126 _269_/a_27_47# _013_ 0
C6127 _275_/a_651_413# net11 0
C6128 _036_ fanout56/a_27_47# 0.00251f
C6129 _178_/a_298_297# _088_ 0.0127f
C6130 _259_/a_639_47# net57 0
C6131 net5 _285_/a_448_47# 0.00207f
C6132 _277_/a_448_47# net26 0
C6133 _194_/a_285_47# _101_ 0
C6134 cin_q hold1/a_391_47# 0.00686f
C6135 _294_/a_27_47# _279_/a_761_289# 0
C6136 VPWR genblk1\[6\].fa_inst.a 0.53872f
C6137 _098_ _299_/a_1108_47# 0
C6138 net46 pmu_inst/dc_inst.x6.net9 0.01042f
C6139 _290_/a_27_47# genblk1\[2\].fa_inst.b 0
C6140 clkbuf_1_0__f_clk/a_110_47# net34 0.00153f
C6141 clk _264_/a_193_47# 0.04242f
C6142 _304_/a_27_47# _057_ 0
C6143 net33 _059_ 0.03408f
C6144 _097_ _299_/a_1283_21# 0
C6145 net46 pmu_inst/dc_inst.x1.x10/a_27_47# 0
C6146 net47 pmu_inst/dc_inst.net6 0.001f
C6147 VPWR _151_/a_113_47# -0
C6148 net61 _269_/a_1283_21# 0.02877f
C6149 _277_/a_639_47# genblk1\[5\].fa_inst.a 0
C6150 _298_/a_651_413# net30 0.00744f
C6151 _105_ _112_ 0
C6152 _301_/a_1283_21# _300_/a_1108_47# 0
C6153 clkbuf_2_3__f_clk_regs/a_110_47# _265_/a_448_47# 0
C6154 _255_/a_27_47# VPWR 0.04597f
C6155 _289_/a_1108_47# net24 0
C6156 _289_/a_1283_21# _034_ 0.05555f
C6157 _289_/a_193_47# genblk1\[1\].fa_inst.b 0
C6158 _027_ _297_/a_1108_47# 0
C6159 _294_/a_1217_47# net62 0
C6160 net3 _283_/a_27_47# 0.27369f
C6161 genblk1\[11\].fa_inst.s _094_ 0
C6162 net47 pmu_inst/dc_inst.x3.net1 0.01554f
C6163 _039_ _294_/a_193_47# 0
C6164 genblk1\[7\].fa_inst.b _295_/a_27_47# 0
C6165 net7 _297_/a_27_47# 0.02655f
C6166 _301_/a_27_47# genblk1\[13\].fa_inst.b 0
C6167 net74 net51 0
C6168 net5 net6 2.46357f
C6169 genblk1\[9\].fa_inst.b _297_/a_1270_413# 0
C6170 _302_/a_193_47# net60 0.0167f
C6171 _293_/a_193_47# net58 0
C6172 net33 _064_ 0
C6173 cout_next _204_/a_225_47# 0.09224f
C6174 genblk1\[3\].fa_inst.a _063_ 0
C6175 _294_/a_761_289# _280_/a_761_289# 0
C6176 net44 clknet_2_3__leaf_clk_regs 0.00424f
C6177 _271_/a_1108_47# net62 0.00629f
C6178 _285_/a_448_47# clknet_2_2__leaf_clk_regs 0.00713f
C6179 _021_ fanout56/a_27_47# 0
C6180 _276_/a_1283_21# net36 0.01091f
C6181 _260_/a_27_47# _260_/a_1283_21# -0
C6182 _261_/a_27_47# net51 0
C6183 net58 _038_ 0.02176f
C6184 _261_/a_1283_21# genblk1\[6\].fa_inst.s 0
C6185 _261_/a_543_47# _006_ -0
C6186 genblk1\[3\].fa_inst.a net58 0
C6187 output48/a_27_47# s[3] 0.01008f
C6188 net33 _283_/a_193_47# 0
C6189 _031_ genblk1\[13\].fa_inst.b 0
C6190 net46 pmu_inst/dc_inst.x4.net7 0.00722f
C6191 net39 pmu_inst/dc_inst.x1.x9/a_27_47# 0.00184f
C6192 _291_/a_761_289# VPWR 0.0219f
C6193 _294_/a_448_47# VPWR 0.00223f
C6194 _280_/a_27_47# net36 0
C6195 VPWR _265_/a_1283_21# 0.02636f
C6196 _185_/a_68_297# net33 0.001f
C6197 _274_/a_761_289# genblk1\[2\].fa_inst.a 0
C6198 _274_/a_1108_47# _019_ -0.00461f
C6199 _143_/a_27_413# net36 0
C6200 _199_/a_285_47# _111_ 0
C6201 VPWR _179_/a_285_47# 0
C6202 _259_/a_27_47# net57 0.00106f
C6203 _283_/a_1108_47# _298_/a_1108_47# 0
C6204 _283_/a_543_47# _298_/a_651_413# 0
C6205 input14/a_75_212# a[7] 0.01461f
C6206 net26 b[0] 0
C6207 net2 genblk1\[9\].fa_inst.a 0
C6208 VPWR _297_/a_1108_47# 0.02993f
C6209 _135_/a_298_297# _055_ 0
C6210 clknet_2_2__leaf_clk_regs _264_/a_761_289# 0
C6211 net5 _030_ 0.00498f
C6212 VPWR net70 0.62796f
C6213 _078_ genblk1\[8\].fa_inst.a 0
C6214 _083_ _173_/a_27_413# 0
C6215 _169_/a_47_47# _081_ 0
C6216 genblk1\[2\].fa_inst.a _289_/a_651_413# 0
C6217 pmu_inst/dc_inst.x7.x12/a_27_47# net35 0
C6218 _290_/a_761_289# clknet_2_1__leaf_clk_regs 0
C6219 pmu_inst/dc_inst.x7.net11 net34 0.01134f
C6220 _295_/a_27_47# _295_/a_448_47# -0.00297f
C6221 net3 genblk1\[8\].fa_inst.a 0
C6222 VPWR pmu_inst/dc_inst.x1.net16 0.00103f
C6223 _290_/a_1217_47# genblk1\[2\].fa_inst.b 0
C6224 genblk1\[14\].fa_inst.b _201_/a_217_297# 0
C6225 genblk1\[2\].fa_inst.s _056_ 0
C6226 net17 net6 0.01634f
C6227 net27 _280_/a_1108_47# 0.01363f
C6228 net6 clknet_2_2__leaf_clk_regs 0
C6229 _277_/a_1270_413# net58 0
C6230 _292_/a_448_47# net58 0
C6231 clk _266_/a_805_47# 0
C6232 VPWR a[8] 0.21642f
C6233 _023_ _279_/a_1283_21# 0
C6234 _028_ _042_ 0.00117f
C6235 _302_/a_1283_21# _287_/a_193_47# 0
C6236 _302_/a_543_47# _287_/a_761_289# 0
C6237 _301_/a_543_47# _045_ 0
C6238 _046_ _300_/a_543_47# 0
C6239 _194_/a_47_47# _103_ 0.00378f
C6240 net7 _299_/a_27_47# 0.00329f
C6241 clkbuf_2_3__f_clk_regs/a_110_47# _010_ 0
C6242 _255_/a_1217_47# VPWR 0
C6243 clknet_2_0__leaf_clk_regs _304_/a_193_47# 0.58738f
C6244 genblk1\[1\].fa_inst.s _055_ 0
C6245 net2 genblk1\[6\].fa_inst.a 0
C6246 net3 _282_/a_805_47# 0
C6247 _303_/a_27_47# input23/a_75_212# 0
C6248 _280_/a_193_47# _295_/a_193_47# 0
C6249 _280_/a_761_289# _295_/a_27_47# 0
C6250 _280_/a_27_47# _295_/a_761_289# 0
C6251 genblk1\[7\].fa_inst.b _295_/a_1217_47# 0
C6252 _301_/a_27_47# _286_/a_1108_47# 0
C6253 _301_/a_193_47# _286_/a_1283_21# 0.00444f
C6254 _286_/a_27_47# input19/a_75_212# 0
C6255 _130_/a_215_297# _052_ 0
C6256 net33 _155_/a_150_297# 0
C6257 _302_/a_1462_47# net60 0.00106f
C6258 net55 pmu_inst/dc_inst.x5.net13 0
C6259 _039_ net29 0.00571f
C6260 genblk1\[11\].fa_inst.a genblk1\[10\].fa_inst.b 0.02455f
C6261 _275_/a_1270_413# VPWR 0
C6262 _276_/a_1108_47# _291_/a_193_47# 0
C6263 _178_/a_215_297# genblk1\[9\].fa_inst.b 0
C6264 _185_/a_68_297# net35 0
C6265 _148_/a_27_413# VPWR 0.06034f
C6266 _030_ clknet_2_2__leaf_clk_regs 0
C6267 genblk1\[6\].fa_inst.b _073_ 0.13101f
C6268 _290_/a_761_289# net11 0.01666f
C6269 _144_/a_285_47# net36 0.00369f
C6270 _261_/a_1217_47# net51 0
C6271 _269_/a_448_47# genblk1\[15\].fa_inst.s 0
C6272 _286_/a_1108_47# _031_ -0.00728f
C6273 _286_/a_761_289# genblk1\[14\].fa_inst.a 0
C6274 net46 pmu_inst/dc_inst.x5.x20/a_27_47# 0
C6275 genblk1\[2\].fa_inst.s _057_ 0.10898f
C6276 net47 pmu_inst/_23_/a_761_289# 0.0034f
C6277 genblk1\[10\].fa_inst.a net59 0.00717f
C6278 VPWR clknet_2_3__leaf_clk_regs 14.42377f
C6279 VPWR _299_/a_1108_47# 0.00677f
C6280 clknet_2_1__leaf_clk_regs _261_/a_543_47# 0.00164f
C6281 net29 _281_/a_761_289# 0
C6282 _281_/a_1108_47# _296_/a_1283_21# 0
C6283 _281_/a_1283_21# _296_/a_1108_47# 0
C6284 genblk1\[11\].fa_inst.a _298_/a_193_47# 0
C6285 _283_/a_1283_21# _043_ 0
C6286 _028_ _298_/a_1283_21# 0
C6287 net33 _302_/a_1283_21# 0
C6288 net39 pmu_inst/dc_inst.x1.x4/a_27_47# 0
C6289 VPWR pmu_inst/dc_inst.x1.net13 0.00353f
C6290 _257_/a_448_47# clknet_2_0__leaf_clk_regs 0.00139f
C6291 VPWR net32 0.72249f
C6292 VPWR _044_ 0.09097f
C6293 VPWR pmu_inst/dc_inst.x6.x5/a_27_47# 0.00194f
C6294 _257_/a_1283_21# VPWR 0.03932f
C6295 _295_/a_27_47# _040_ 0.01021f
C6296 _295_/a_193_47# net30 0.37698f
C6297 _282_/a_193_47# net36 0
C6298 a[13] net14 0
C6299 net46 pmu_inst/_20_/a_79_21# 0.00254f
C6300 _294_/a_448_47# net2 0
C6301 _296_/a_1283_21# net31 0
C6302 _296_/a_543_47# _041_ 0
C6303 net28 _297_/a_1283_21# 0.00964f
C6304 VPWR _268_/a_1270_413# -0
C6305 _259_/a_1108_47# _003_ 0
C6306 net33 net62 0.02656f
C6307 _139_/a_129_47# _057_ 0.00139f
C6308 _037_ net58 0.21281f
C6309 net22 _287_/a_27_47# 0
C6310 net58 _261_/a_1108_47# 0.00257f
C6311 VPWR b[2] 0.21811f
C6312 _287_/a_193_47# net7 0.26829f
C6313 _304_/a_543_47# _058_ 0
C6314 _183_/a_298_297# genblk1\[10\].fa_inst.a 0
C6315 net27 _283_/a_651_413# 0
C6316 _293_/a_448_47# clknet_2_1__leaf_clk_regs 0.02505f
C6317 net27 _279_/a_27_47# 0.02412f
C6318 net21 _286_/a_27_47# 0.00418f
C6319 _067_ _072_ 0
C6320 net33 _153_/a_382_47# 0
C6321 net39 pmu_inst_63/HI 0.0017f
C6322 net46 pmu_inst/_07_ 0.00626f
C6323 _294_/a_651_413# _279_/a_543_47# 0
C6324 _075_ genblk1\[6\].fa_inst.a 0
C6325 clk _263_/a_543_47# 0.02003f
C6326 VPWR _298_/a_543_47# 0.01457f
C6327 _111_ _201_/a_217_297# 0
C6328 _022_ _277_/a_543_47# 0
C6329 _076_ genblk1\[5\].fa_inst.b 0.00991f
C6330 _080_ _074_ 0
C6331 genblk1\[6\].fa_inst.b VPWR 1.46323f
C6332 _281_/a_1283_21# _281_/a_1108_47# 0
C6333 _259_/a_448_47# net57 0
C6334 _068_ _072_ 0.06237f
C6335 _154_/a_377_297# _071_ 0.00154f
C6336 _260_/a_448_47# net50 0
C6337 _001_ _000_ 0.00273f
C6338 _063_ _142_/a_113_47# 0
C6339 genblk1\[8\].fa_inst.b _173_/a_382_47# 0
C6340 VPWR net19 0.54319f
C6341 clkbuf_0_clk/a_110_47# clknet_0_clk 0.05234f
C6342 net16 _296_/a_193_47# 0
C6343 VPWR _287_/a_448_47# 0.00214f
C6344 _285_/a_1108_47# _299_/a_193_47# 0
C6345 _285_/a_193_47# clknet_2_3__leaf_clk_regs 0.16466f
C6346 _289_/a_805_47# net12 0
C6347 _151_/a_113_47# _069_ 0
C6348 clknet_2_2__leaf_clk_regs _296_/a_1108_47# 0
C6349 _026_ _296_/a_543_47# 0
C6350 genblk1\[9\].fa_inst.a _296_/a_27_47# 0
C6351 _281_/a_543_47# _041_ 0
C6352 clknet_2_0__leaf_clk_regs _050_ 0
C6353 net47 pmu_inst/dc_inst.x3.x19/a_27_47# 0.00267f
C6354 _271_/a_193_47# cout_next 0.11499f
C6355 _002_ clknet_2_0__leaf_clk_regs 0
C6356 net35 net62 0.02785f
C6357 _273_/a_193_47# clknet_2_1__leaf_clk_regs 0
C6358 net7 _298_/a_639_47# 0.00158f
C6359 _285_/a_193_47# net32 0
C6360 _292_/a_27_47# _277_/a_193_47# 0
C6361 a[12] net4 0.00159f
C6362 net5 _031_ 0
C6363 _292_/a_1108_47# VPWR 0.02757f
C6364 _295_/a_1217_47# _040_ 0
C6365 _270_/a_543_47# clk 0
C6366 _285_/a_543_47# net60 0
C6367 cout_next net63 0.07433f
C6368 net71 net70 0.09499f
C6369 _022_ _291_/a_543_47# 0
C6370 VPWR pmu_inst/dc_inst.x6.net8 0
C6371 _263_/a_193_47# _008_ 0
C6372 net5 net31 0.03621f
C6373 net2 net32 0.00251f
C6374 _047_ _287_/a_805_47# 0
C6375 _054_ _288_/a_193_47# 0
C6376 net47 pmu_inst/dc_inst.x3.net18 0.00336f
C6377 net58 genblk1\[6\].fa_inst.s 0
C6378 _270_/a_193_47# _270_/a_448_47# -0.00297f
C6379 _290_/a_543_47# VPWR 0.01347f
C6380 a[10] input3/a_27_47# 0
C6381 input2/a_27_47# a[11] 0
C6382 _082_ _088_ 0.10815f
C6383 clknet_2_1__leaf_clk_regs _280_/a_543_47# 0
C6384 VPWR b[1] 0.2375f
C6385 _303_/a_193_47# _303_/a_1108_47# -0.00656f
C6386 _303_/a_27_47# _303_/a_448_47# -0.00297f
C6387 _301_/a_27_47# clknet_2_2__leaf_clk_regs 0.04767f
C6388 net39 pmu_inst/_17_/a_174_21# 0.00514f
C6389 net27 _279_/a_1217_47# 0
C6390 clknet_2_2__leaf_clk_regs _263_/a_1283_21# 0
C6391 net27 _027_ 0.02745f
C6392 _301_/a_805_47# _031_ 0
C6393 _064_ _059_ 0
C6394 _142_/a_113_47# _057_ 0
C6395 _278_/a_27_47# _278_/a_639_47# -0.0015f
C6396 _257_/a_805_47# _001_ 0
C6397 _276_/a_543_47# net36 0.00803f
C6398 clk _111_ 0
C6399 _281_/a_193_47# net16 0.05722f
C6400 net2 b[2] 0
C6401 VPWR pmu_inst/dc_inst.x5.x8/a_27_47# 0
C6402 _281_/a_1108_47# clknet_2_2__leaf_clk_regs 0
C6403 _281_/a_543_47# _026_ 0
C6404 _281_/a_27_47# genblk1\[9\].fa_inst.a 0
C6405 net39 pmu_inst/dc_inst.x4.net13 0.00523f
C6406 _288_/a_448_47# net17 0.00456f
C6407 _288_/a_1108_47# _033_ 0.00635f
C6408 _273_/a_193_47# net11 0
C6409 _284_/a_193_47# clknet_2_3__leaf_clk_regs 0.01388f
C6410 net7 net35 0.01974f
C6411 _005_ net50 0.00346f
C6412 clk clknet_2_2__leaf_clk_regs 0.19205f
C6413 _031_ clknet_2_2__leaf_clk_regs 0.02849f
C6414 _300_/a_1283_21# _299_/a_448_47# 0
C6415 net46 pmu_inst/dc_inst.x6.x19/a_27_47# 0
C6416 _144_/a_129_47# _064_ 0.00199f
C6417 net4 _278_/a_639_47# 0.00101f
C6418 _280_/a_27_47# genblk1\[8\].fa_inst.a 0
C6419 _280_/a_543_47# _025_ 0
C6420 _264_/a_27_47# net59 0.00951f
C6421 _284_/a_193_47# net32 0.02825f
C6422 b[12] clknet_2_2__leaf_clk_regs 0
C6423 net58 _280_/a_1108_47# 0.0193f
C6424 VPWR _032_ 0.06605f
C6425 _285_/a_193_47# net19 0.03405f
C6426 _030_ _299_/a_27_47# 0.00627f
C6427 genblk1\[15\].fa_inst.b genblk1\[14\].fa_inst.b 0
C6428 pmu_inst/dc_inst.x1.x6/a_27_47# cout_next 0
C6429 clknet_2_2__leaf_clk_regs net31 0.04215f
C6430 _259_/a_543_47# clknet_2_0__leaf_clk_regs 0.0031f
C6431 _294_/a_543_47# _280_/a_1108_47# 0
C6432 genblk1\[6\].fa_inst.b net2 0
C6433 VPWR _112_ 0.47895f
C6434 _300_/a_651_413# net60 0
C6435 _275_/a_543_47# net10 0
C6436 genblk1\[0\].fa_inst.a _051_ 0.00474f
C6437 net47 pmu_inst/dc_inst.x3.net16 0.00761f
C6438 net16 _278_/a_193_47# 0.02648f
C6439 net36 _024_ 0
C6440 _148_/a_298_297# _062_ 0
C6441 _277_/a_761_289# _291_/a_27_47# 0
C6442 net27 VPWR 1.34511f
C6443 net17 _278_/a_1108_47# 0.00207f
C6444 net22 net36 0.02747f
C6445 _301_/a_1283_21# _046_ 0.00291f
C6446 _130_/a_215_297# cin_q 0.00928f
C6447 VPWR _261_/a_1283_21# 0.02744f
C6448 net39 pmu_inst/dc_inst.x5.x11/a_27_47# 0.00294f
C6449 _275_/a_1108_47# _274_/a_1283_21# 0.00255f
C6450 _275_/a_1283_21# _274_/a_1108_47# 0.00995f
C6451 output54/a_27_47# net40 0
C6452 _269_/a_27_47# _014_ 0.00473f
C6453 genblk1\[14\].fa_inst.s clknet_2_3__leaf_clk_regs 0.10478f
C6454 _263_/a_639_47# net53 0
C6455 net25 clknet_2_0__leaf_clk_regs 0
C6456 _283_/a_27_47# _283_/a_761_289# -0.00394f
C6457 _284_/a_1283_21# net59 0.02135f
C6458 net39 pmu_inst/dc_inst.x1.net6 0
C6459 _270_/a_193_47# _015_ -0.00193f
C6460 _266_/a_448_47# clknet_2_3__leaf_clk_regs 0.00558f
C6461 net4 genblk1\[9\].fa_inst.a 0
C6462 VPWR pmu_inst/dc_inst.x2.net14 0
C6463 VPWR pmu_inst/dc_inst.x5.net12 0.01876f
C6464 net39 pmu_inst/dc_inst.x6.net2 0
C6465 _258_/a_805_47# net36 0
C6466 _284_/a_761_289# _298_/a_761_289# 0
C6467 _303_/a_27_47# _048_ -0
C6468 _284_/a_543_47# _298_/a_193_47# 0
C6469 _284_/a_1283_21# _298_/a_27_47# 0
C6470 _004_ genblk1\[4\].fa_inst.s 0
C6471 genblk1\[4\].fa_inst.a net58 0.02938f
C6472 _278_/a_27_47# genblk1\[6\].fa_inst.a 0
C6473 _052_ net56 0
C6474 _276_/a_193_47# genblk1\[2\].fa_inst.a 0
C6475 genblk1\[10\].fa_inst.a _175_/a_150_297# 0
C6476 _274_/a_543_47# net56 0
C6477 _281_/a_1217_47# genblk1\[9\].fa_inst.a 0
C6478 net17 _033_ 0.00483f
C6479 _276_/a_639_47# net36 0.00119f
C6480 _283_/a_805_47# net30 0
C6481 _284_/a_1462_47# clknet_2_3__leaf_clk_regs 0
C6482 net2 b[1] 0
C6483 net20 clknet_2_3__leaf_clk_regs 0.0271f
C6484 _300_/a_1108_47# net19 0.00386f
C6485 _131_/a_68_297# _288_/a_1108_47# 0
C6486 _056_ _053_ 0.05389f
C6487 net61 _264_/a_543_47# 0
C6488 net4 genblk1\[6\].fa_inst.a 0
C6489 _276_/a_761_289# _291_/a_543_47# 0
C6490 net7 _295_/a_543_47# 0.01665f
C6491 _280_/a_1217_47# genblk1\[8\].fa_inst.a 0
C6492 _264_/a_1217_47# net59 0
C6493 _285_/a_1462_47# net19 0
C6494 _276_/a_27_47# _036_ 0
C6495 _286_/a_193_47# clknet_2_3__leaf_clk_regs 0.31796f
C6496 net48 net35 0.02825f
C6497 net61 _266_/a_193_47# 0.00156f
C6498 net65 net70 -0
C6499 net47 pmu_inst/dc_inst.x3.net8 0.02084f
C6500 _293_/a_193_47# genblk1\[5\].fa_inst.b 0
C6501 _135_/a_27_413# _057_ 0
C6502 clknet_2_0__leaf_clk_regs _154_/a_47_47# 0
C6503 net33 _150_/a_150_297# 0
C6504 net24 net15 0.0238f
C6505 VPWR pmu_inst/dc_inst.x5.x10/a_27_47# 0
C6506 _259_/a_1283_21# _258_/a_1283_21# 0
C6507 net58 _279_/a_27_47# 0.02245f
C6508 net39 pmu_inst/_18_/a_535_374# 0
C6509 _275_/a_543_47# _019_ 0
C6510 _020_ _274_/a_543_47# 0.00827f
C6511 _275_/a_27_47# genblk1\[2\].fa_inst.a 0.00392f
C6512 _273_/a_1283_21# clknet_2_0__leaf_clk_regs 0.00107f
C6513 _297_/a_27_47# net31 0.02938f
C6514 _269_/a_1270_413# net44 0
C6515 _038_ genblk1\[5\].fa_inst.b 0.03027f
C6516 _294_/a_543_47# _279_/a_27_47# 0.00156f
C6517 genblk1\[12\].fa_inst.b _097_ 0.07009f
C6518 _255_/a_27_47# net57 0
C6519 _164_/a_377_297# net62 0.00351f
C6520 input22/a_75_212# b[15] 0
C6521 b[14] input23/a_75_212# 0
C6522 _273_/a_543_47# net1 0
C6523 _273_/a_761_289# VPWR 0.00334f
C6524 VPWR _137_/a_113_47# -0
C6525 _277_/a_761_289# net56 0.00114f
C6526 net5 _297_/a_193_47# 0
C6527 _270_/a_639_47# net45 0
C6528 genblk1\[15\].fa_inst.b _111_ 0.00867f
C6529 _011_ clknet_2_3__leaf_clk_regs 0
C6530 net46 pmu_inst/dc_inst.x6.net6 0.01889f
C6531 _039_ _294_/a_27_47# 0.00141f
C6532 VPWR _295_/a_1270_413# 0
C6533 clkload1/Y VPWR 0.00467f
C6534 _057_ _053_ 0.00408f
C6535 VPWR pmu_inst/dc_inst.x3.net6 0
C6536 net27 net2 0.09266f
C6537 clkbuf_2_2__f_clk_regs/a_110_47# _092_ 0.01426f
C6538 net60 _194_/a_377_297# 0.00194f
C6539 net33 _030_ 0
C6540 s[3] s[4] 0
C6541 _259_/a_1283_21# VPWR 0.03248f
C6542 genblk1\[9\].fa_inst.a _170_/a_68_297# 0.06136f
C6543 a[5] net12 0.00222f
C6544 VPWR _173_/a_298_297# -0.00373f
C6545 net33 _101_ 0
C6546 _294_/a_448_47# net4 0.00513f
C6547 net52 _262_/a_1108_47# 0.00182f
C6548 input34/a_27_47# input36/a_27_47# 0.02473f
C6549 _129_/a_129_47# _050_ 0.00107f
C6550 _285_/a_805_47# net18 0
C6551 _276_/a_27_47# _021_ 0
C6552 _293_/a_1283_21# VPWR 0.01689f
C6553 _300_/a_27_47# net36 0
C6554 input5/a_27_47# net15 0.01444f
C6555 b[5] net32 0
C6556 _159_/a_47_47# genblk1\[6\].fa_inst.a 0
C6557 _168_/a_298_297# _080_ 0.00297f
C6558 net59 _296_/a_543_47# 0.00261f
C6559 genblk1\[10\].fa_inst.a net30 0
C6560 net25 a[10] 0
C6561 VPWR _280_/a_1283_21# 0.04612f
C6562 net20 net19 0.0214f
C6563 _266_/a_27_47# net35 0
C6564 fanout59/a_27_47# _009_ 0
C6565 net6 net35 0.20475f
C6566 input20/a_75_212# b[13] 0
C6567 b[12] input21/a_75_212# 0
C6568 input31/a_75_212# b[9] 0
C6569 b[8] input32/a_75_212# 0
C6570 _174_/a_285_47# _088_ 0.00633f
C6571 _087_ _082_ 0
C6572 VPWR input26/a_75_212# 0.09177f
C6573 net28 _077_ 0
C6574 genblk1\[10\].fa_inst.a _088_ 0
C6575 _286_/a_193_47# net19 0.02259f
C6576 VPWR pmu_inst/dc_inst.x4.net4 0.01184f
C6577 net28 _293_/a_448_47# 0.00456f
C6578 genblk1\[8\].fa_inst.b VPWR 1.57453f
C6579 clk _265_/a_805_47# 0
C6580 net61 _266_/a_1462_47# 0
C6581 clknet_2_3__leaf_clk_regs b[10] 0
C6582 clknet_2_2__leaf_clk_regs _297_/a_193_47# 0.02892f
C6583 clk genblk1\[10\].fa_inst.s 0.01016f
C6584 net71 pmu_inst/dc_inst.x6.x6/a_27_47# 0
C6585 _288_/a_543_47# net56 0
C6586 _070_ _151_/a_113_47# 0
C6587 _284_/a_448_47# net35 0.01615f
C6588 VPWR genblk1\[5\].fa_inst.s 1.90934f
C6589 net58 _279_/a_1217_47# 0
C6590 net7 _280_/a_805_47# 0
C6591 _275_/a_1217_47# genblk1\[2\].fa_inst.a 0
C6592 clknet_2_0__leaf_clk_regs _135_/a_215_297# 0
C6593 _290_/a_1283_21# _289_/a_1108_47# 0
C6594 _290_/a_1108_47# _289_/a_1283_21# 0
C6595 clknet_2_1__leaf_clk_regs clknet_2_0__leaf_clk_regs 0.03732f
C6596 genblk1\[2\].fa_inst.b _058_ 0.20908f
C6597 _263_/a_761_289# net59 0
C6598 net45 net37 0.02918f
C6599 _255_/a_1217_47# net57 0
C6600 _304_/a_651_413# genblk1\[1\].fa_inst.b 0.00286f
C6601 _283_/a_1283_21# genblk1\[11\].fa_inst.a 0.00185f
C6602 net33 _029_ 0
C6603 _258_/a_761_289# genblk1\[3\].fa_inst.s 0
C6604 genblk1\[7\].fa_inst.s _262_/a_639_47# 0
C6605 _281_/a_27_47# b[2] 0
C6606 _105_ _104_ 0
C6607 _292_/a_543_47# _277_/a_761_289# 0
C6608 _282_/a_1108_47# _027_ 0.00724f
C6609 _282_/a_761_289# genblk1\[10\].fa_inst.a 0
C6610 genblk1\[14\].fa_inst.s _112_ 0
C6611 _022_ _037_ 0
C6612 _128_/a_113_47# _050_ 0
C6613 _276_/a_27_47# _290_/a_651_413# 0
C6614 _293_/a_639_47# net33 0
C6615 fanout58/a_27_47# _263_/a_761_289# 0
C6616 net7 _283_/a_193_47# 0.0316f
C6617 net7 _282_/a_27_47# 0.02454f
C6618 net71 pmu_inst/dc_inst.x5.net12 -0
C6619 net46 pmu_inst/dc_inst.x1.net14 0.00309f
C6620 _290_/a_27_47# input14/a_75_212# 0
C6621 clknet_2_0__leaf_clk_regs genblk1\[3\].fa_inst.s 0.09597f
C6622 _259_/a_1108_47# _004_ 0.00643f
C6623 net28 _295_/a_651_413# 0
C6624 net4 clknet_2_3__leaf_clk_regs 0.02421f
C6625 _144_/a_47_47# _058_ 0
C6626 _301_/a_448_47# clknet_2_3__leaf_clk_regs 0
C6627 fanout60/a_27_47# _268_/a_193_47# 0
C6628 net46 pmu_inst/dc_inst.x5.net10 0
C6629 genblk1\[3\].fa_inst.a _288_/a_27_47# 0.1548f
C6630 _275_/a_1283_21# net17 0
C6631 VPWR _063_ 0.04894f
C6632 clknet_2_1__leaf_clk_regs genblk1\[7\].fa_inst.a 0
C6633 net75 _051_ 0
C6634 VPWR _056_ 0.21948f
C6635 _021_ net14 0
C6636 _303_/a_1283_21# clknet_2_3__leaf_clk_regs 0.00212f
C6637 net4 net32 1.33387f
C6638 a[11] input4/a_27_47# 0
C6639 input3/a_27_47# a[12] 0
C6640 clknet_1_0__leaf_clk net34 0.28023f
C6641 net47 pmu_inst/dc_inst.x3.x16/a_27_47# 0.00421f
C6642 net62 _279_/a_1108_47# 0.01829f
C6643 VPWR net58 6.84514f
C6644 net13 input14/a_75_212# 0.01278f
C6645 _301_/a_1270_413# net60 0
C6646 clknet_2_2__leaf_clk_regs _299_/a_193_47# 0
C6647 clknet_2_0__leaf_clk_regs net11 0
C6648 _294_/a_543_47# VPWR 0.01871f
C6649 hold1/a_285_47# _134_/a_47_47# 0.00257f
C6650 _286_/a_1462_47# net19 0.00206f
C6651 _097_ _198_/a_215_297# 0
C6652 _021_ _061_ 0
C6653 VPWR input34/a_27_47# 0.06694f
C6654 clknet_2_2__leaf_clk_regs _297_/a_1462_47# 0.00184f
C6655 VPWR _283_/a_448_47# 0.00185f
C6656 VPWR _282_/a_1108_47# 0.03507f
C6657 net39 pmu_inst/dc_inst.x4.x15/a_27_47# 0.00215f
C6658 _257_/a_1283_21# net57 0.00361f
C6659 genblk1\[0\].fa_inst.b _288_/a_27_47# 0
C6660 _054_ _304_/a_193_47# 0
C6661 _025_ genblk1\[7\].fa_inst.a 0.00137f
C6662 _271_/a_27_47# net37 0
C6663 clk _267_/a_543_47# 0.00421f
C6664 _029_ net35 0.15184f
C6665 _276_/a_193_47# _291_/a_193_47# 0
C6666 b[15] net35 0.01906f
C6667 genblk1\[4\].fa_inst.s _149_/a_377_297# 0
C6668 _271_/a_27_47# net45 0
C6669 _035_ _289_/a_543_47# 0
C6670 _290_/a_543_47# _034_ 0
C6671 genblk1\[8\].fa_inst.b net2 0
C6672 cin_q net56 0.0675f
C6673 _258_/a_27_47# genblk1\[4\].fa_inst.s 0
C6674 _297_/a_27_47# _297_/a_193_47# -0.00609f
C6675 _286_/a_448_47# net35 0.00354f
C6676 VPWR _057_ 0.60317f
C6677 net27 _296_/a_27_47# 0.01717f
C6678 genblk1\[6\].fa_inst.b net4 0
C6679 net33 _138_/a_113_47# 0
C6680 _276_/a_761_289# _290_/a_1283_21# 0.00902f
C6681 _277_/a_27_47# _291_/a_1108_47# 0
C6682 _023_ _278_/a_1283_21# 0.00697f
C6683 _272_/a_651_413# clknet_2_0__leaf_clk_regs 0.02676f
C6684 _272_/a_1108_47# _017_ -0.00564f
C6685 _272_/a_761_289# genblk1\[0\].fa_inst.a 0
C6686 _277_/a_543_47# _291_/a_543_47# 0
C6687 _279_/a_1283_21# _024_ 0.00308f
C6688 _279_/a_193_47# genblk1\[7\].fa_inst.a 0
C6689 _104_ _192_/a_113_47# 0
C6690 clkload2/X clknet_2_3__leaf_clk_regs 0.00715f
C6691 _272_/a_448_47# net1 0.00488f
C6692 _272_/a_1108_47# VPWR 0.006f
C6693 _130_/a_27_413# net56 0.00276f
C6694 cout_next pmu_inst/dc_inst.x3.net7 0
C6695 genblk1\[11\].fa_inst.a genblk1\[9\].fa_inst.b 0
C6696 _302_/a_761_289# _047_ 0.0047f
C6697 _302_/a_543_47# net22 0
C6698 net43 genblk1\[13\].fa_inst.s 0
C6699 _256_/a_27_47# _256_/a_193_47# -0.01792f
C6700 _290_/a_651_413# net14 0
C6701 _302_/a_1283_21# net7 0.00104f
C6702 net23 net36 0.01261f
C6703 _046_ clknet_2_3__leaf_clk_regs -0
C6704 genblk1\[1\].fa_inst.a net8 0.00423f
C6705 _293_/a_805_47# _038_ -0.00125f
C6706 clknet_2_1__leaf_clk_regs a[10] 0
C6707 genblk1\[3\].fa_inst.a _288_/a_1217_47# 0
C6708 pmu_inst/dc_inst.x5.x2/a_27_47# pmu_inst/dc_inst.x5.net12 0
C6709 _261_/a_1283_21# _260_/a_543_47# 0
C6710 genblk1\[11\].fa_inst.s VPWR 0.91938f
C6711 net26 net16 2.14002f
C6712 _270_/a_1108_47# net61 0.02198f
C6713 _286_/a_651_413# net36 0
C6714 pmu_inst/_15_/a_788_316# net66 0
C6715 cout_next pmu_inst/dc_inst.x1.net12 0
C6716 genblk1\[3\].fa_inst.b net17 0.03154f
C6717 net7 net62 0
C6718 VPWR _202_/a_109_297# 0
C6719 _274_/a_193_47# _273_/a_761_289# 0.00177f
C6720 _274_/a_761_289# _273_/a_193_47# 0
C6721 _274_/a_543_47# _273_/a_27_47# 0
C6722 _274_/a_27_47# _273_/a_543_47# 0.0011f
C6723 _148_/a_27_413# _066_ 0
C6724 net17 _023_ 0.03372f
C6725 _048_ net60 0.0259f
C6726 VPWR _028_ 0.11833f
C6727 VPWR _279_/a_805_47# 0
C6728 _183_/a_215_297# clknet_2_2__leaf_clk_regs 0
C6729 _301_/a_27_47# net35 0
C6730 net3 net17 0.02348f
C6731 net3 clknet_2_2__leaf_clk_regs 0.02854f
C6732 _265_/a_27_47# genblk1\[10\].fa_inst.s 0.10616f
C6733 _302_/a_639_47# VPWR 0
C6734 _256_/a_27_47# VPWR 0.05192f
C6735 _276_/a_448_47# net36 0.00364f
C6736 net58 net2 0.02009f
C6737 _292_/a_193_47# net17 0
C6738 net27 _281_/a_27_47# 0.01775f
C6739 genblk1\[9\].fa_inst.a _178_/a_27_413# 0
C6740 _179_/a_377_297# _091_ 0.00154f
C6741 genblk1\[12\].fa_inst.s clknet_2_3__leaf_clk_regs 0.10685f
C6742 net47 pmu_inst/dc_inst.net5 0.00122f
C6743 net13 _278_/a_543_47# 0
C6744 net28 _283_/a_1108_47# 0
C6745 _303_/a_193_47# net34 0.54545f
C6746 net46 genblk1\[1\].fa_inst.s 0
C6747 net28 _282_/a_1283_21# 0.00785f
C6748 input37/a_75_212# rst 0.05203f
C6749 _051_ _288_/a_1283_21# 0
C6750 VPWR pmu_inst/_15_/a_1281_47# 0
C6751 _258_/a_1108_47# clknet_2_0__leaf_clk_regs 0
C6752 clknet_0_clk_regs _262_/a_193_47# 0
C6753 _106_ _195_/a_68_297# 0
C6754 _189_/a_129_47# _099_ 0.00287f
C6755 _031_ net35 0
C6756 VPWR input31/a_75_212# 0.09177f
C6757 clk net35 0.0543f
C6758 _258_/a_543_47# VPWR 0.01732f
C6759 clknet_2_1__leaf_clk_regs _262_/a_761_289# 0
C6760 _174_/a_377_297# genblk1\[9\].fa_inst.s 0
C6761 net2 _282_/a_1108_47# 0
C6762 _098_ _104_ 0
C6763 _277_/a_27_47# net26 0.03267f
C6764 _279_/a_1462_47# genblk1\[7\].fa_inst.a 0
C6765 _139_/a_377_297# _060_ 0
C6766 _276_/a_27_47# genblk1\[2\].fa_inst.b 0
C6767 _049_ net17 0
C6768 _259_/a_761_289# genblk1\[4\].fa_inst.s 0.00213f
C6769 _294_/a_1270_413# VPWR 0
C6770 _301_/a_193_47# net36 0
C6771 b[12] net35 0.04582f
C6772 _017_ net1 0
C6773 pmu_inst_66/HI pmu_inst_67/HI 0
C6774 _292_/a_27_47# net12 0
C6775 net73 net50 0.1222f
C6776 net6 _283_/a_193_47# 0
C6777 net35 net31 0.04183f
C6778 cin_q _055_ 0.0402f
C6779 net27 _278_/a_27_47# 0.02404f
C6780 VPWR _198_/a_298_297# -0
C6781 clknet_2_0__leaf_clk_regs _072_ 0.02898f
C6782 net46 pmu_inst/dc_inst.x1.x9/a_27_47# 0.0069f
C6783 _046_ net19 0
C6784 net1 VPWR 2.298f
C6785 net29 _295_/a_193_47# 0.0227f
C6786 _054_ _050_ 0
C6787 net46 pmu_inst/_15_/a_788_316# 0
C6788 _293_/a_193_47# _076_ 0
C6789 s[5] s[6] 0.00191f
C6790 _130_/a_27_413# _055_ 0
C6791 _022_ genblk1\[4\].fa_inst.a 0
C6792 _303_/a_1283_21# _032_ 0
C6793 net27 net4 0.02262f
C6794 _172_/a_113_47# _086_ 0
C6795 net68 net67 0.0119f
C6796 genblk1\[5\].fa_inst.a _150_/a_68_297# 0.05786f
C6797 _110_ _204_/a_561_297# 0.0329f
C6798 _269_/a_1270_413# genblk1\[14\].fa_inst.s 0
C6799 genblk1\[12\].fa_inst.b _300_/a_448_47# 0
C6800 input34/a_27_47# input35/a_27_47# 0
C6801 genblk1\[15\].fa_inst.a genblk1\[14\].fa_inst.a 0
C6802 input1/a_75_212# net8 0
C6803 net1 input8/a_75_212# 0.14424f
C6804 _076_ _038_ 0
C6805 genblk1\[10\].fa_inst.b _176_/a_113_47# 0
C6806 _275_/a_193_47# net56 0
C6807 _291_/a_193_47# net26 0.00623f
C6808 _291_/a_27_47# _036_ 0.01095f
C6809 _265_/a_448_47# clknet_2_3__leaf_clk_regs 0.01481f
C6810 _265_/a_193_47# net40 0
C6811 _265_/a_1283_21# _010_ 0.05464f
C6812 _182_/a_113_47# _095_ 0
C6813 net41 s[11] 0.09627f
C6814 _255_/a_1283_21# net39 0.0026f
C6815 net58 _262_/a_651_413# 0
C6816 _271_/a_193_47# clknet_2_3__leaf_clk_regs 0.00363f
C6817 _299_/a_27_47# _299_/a_193_47# -0.04831f
C6818 _258_/a_193_47# _003_ 0.03985f
C6819 genblk1\[9\].fa_inst.s _086_ 0
C6820 _265_/a_1217_47# genblk1\[10\].fa_inst.s 0
C6821 net25 a[12] 0
C6822 _256_/a_1217_47# VPWR 0
C6823 a[5] a[6] 0.07915f
C6824 genblk1\[3\].fa_inst.s _062_ 0
C6825 net48 net62 0.05746f
C6826 _292_/a_1462_47# net17 0
C6827 _263_/a_1108_47# net52 0
C6828 clknet_2_1__leaf_clk_regs _289_/a_1283_21# 0
C6829 _291_/a_448_47# net56 0
C6830 _169_/a_47_47# clknet_2_2__leaf_clk_regs 0
C6831 genblk1\[8\].fa_inst.b _296_/a_27_47# 0
C6832 _129_/a_285_47# _053_ 0
C6833 net75 _134_/a_285_47# 0.01341f
C6834 net6 input17/a_27_47# 0.02114f
C6835 pmu_inst/dc_inst.x7.net12 net34 0
C6836 net33 genblk1\[15\].fa_inst.b 0.14891f
C6837 _259_/a_1108_47# _258_/a_27_47# 0
C6838 _039_ _280_/a_761_289# 0
C6839 _281_/a_1108_47# _295_/a_543_47# 0
C6840 _281_/a_1283_21# _295_/a_1283_21# 0
C6841 _281_/a_193_47# _295_/a_651_413# 0
C6842 net3 _297_/a_27_47# 0.02329f
C6843 VPWR _193_/a_382_47# -0
C6844 _093_ clknet_2_3__leaf_clk_regs 0.05146f
C6845 _256_/a_543_47# net46 0.00157f
C6846 _256_/a_448_47# _001_ 0.00116f
C6847 _131_/a_68_297# net33 0.00421f
C6848 net27 _278_/a_1217_47# 0
C6849 _275_/a_193_47# _020_ 0
C6850 clknet_0_clk_regs _260_/a_1108_47# 0.00162f
C6851 net61 _265_/a_193_47# 0
C6852 _268_/a_193_47# net60 0.00953f
C6853 clkbuf_0_clk/a_110_47# clkbuf_1_0__f_clk/a_110_47# 0.03362f
C6854 _294_/a_639_47# net3 0.00198f
C6855 _296_/a_543_47# net30 0.00746f
C6856 VPWR _285_/a_27_47# 0.06735f
C6857 genblk1\[11\].fa_inst.b _299_/a_805_47# 0
C6858 _026_ net36 0
C6859 net46 pmu_inst/dc_inst.x1.x4/a_27_47# 0.00148f
C6860 _276_/a_193_47# _290_/a_761_289# 0.00231f
C6861 _021_ _291_/a_27_47# 0
C6862 _260_/a_543_47# genblk1\[5\].fa_inst.s 0.00127f
C6863 net33 _297_/a_193_47# 0
C6864 _304_/a_543_47# net56 0.0011f
C6865 _289_/a_1283_21# net11 0.00451f
C6866 _290_/a_639_47# net12 0.00136f
C6867 genblk1\[12\].fa_inst.b _045_ 0.08945f
C6868 clknet_0_clk_regs _263_/a_193_47# 0
C6869 input33/a_27_47# input34/a_27_47# 0
C6870 _274_/a_1108_47# genblk1\[1\].fa_inst.a 0.00257f
C6871 genblk1\[2\].fa_inst.a _273_/a_1108_47# 0.00244f
C6872 net48 net69 0.09825f
C6873 net41 output40/a_27_47# 0
C6874 _291_/a_1217_47# _036_ 0
C6875 clknet_2_3__leaf_clk_regs _010_ 0
C6876 _265_/a_1462_47# net40 0
C6877 _198_/a_382_47# _104_ 0
C6878 _144_/a_47_47# _061_ 0
C6879 VPWR s[7] 0.39807f
C6880 _271_/a_761_289# net38 0
C6881 _271_/a_1462_47# clknet_2_3__leaf_clk_regs 0
C6882 _271_/a_1108_47# _016_ 0.01643f
C6883 _273_/a_27_47# net9 0.03884f
C6884 _258_/a_639_47# net48 0
C6885 _277_/a_651_413# net58 0.00191f
C6886 net5 _280_/a_27_47# 0
C6887 VPWR _104_ 0.37851f
C6888 _100_ _104_ 0.03929f
C6889 net28 genblk1\[7\].fa_inst.a 0.15125f
C6890 _036_ net56 0.1739f
C6891 _149_/a_47_47# _067_ 0.0591f
C6892 _294_/a_193_47# _279_/a_543_47# 0
C6893 net45 output38/a_27_47# 0
C6894 genblk1\[12\].fa_inst.b _194_/a_47_47# 0
C6895 genblk1\[11\].fa_inst.s _266_/a_448_47# 0.00211f
C6896 _282_/a_1108_47# _296_/a_27_47# 0
C6897 _282_/a_761_289# _296_/a_543_47# 0
C6898 _282_/a_27_47# _296_/a_1108_47# 0
C6899 _282_/a_543_47# _296_/a_761_289# 0
C6900 _044_ _299_/a_651_413# 0
C6901 net16 _295_/a_27_47# 0.04242f
C6902 _268_/a_805_47# clknet_2_3__leaf_clk_regs 0
C6903 genblk1\[4\].fa_inst.a _276_/a_761_289# 0
C6904 net17 _295_/a_1283_21# 0
C6905 _281_/a_761_289# _040_ 0
C6906 _026_ _295_/a_761_289# 0
C6907 _281_/a_543_47# net30 0
C6908 genblk1\[13\].fa_inst.s _192_/a_113_47# 0
C6909 net39 pmu_inst/dc_inst.x4.net1 0.00408f
C6910 genblk1\[3\].fa_inst.a _304_/a_27_47# 0.04102f
C6911 _149_/a_47_47# _068_ 0.03001f
C6912 _267_/a_193_47# net60 0
C6913 _259_/a_1283_21# net57 0.02641f
C6914 VPWR _284_/a_27_47# 0.06967f
C6915 _300_/a_1283_21# VPWR 0.06477f
C6916 _275_/a_639_47# genblk1\[3\].fa_inst.a 0
C6917 genblk1\[8\].fa_inst.b net4 0
C6918 genblk1\[3\].fa_inst.a _148_/a_215_297# 0
C6919 net6 net7 0.00489f
C6920 net33 _299_/a_193_47# 0.00194f
C6921 clkbuf_2_3__f_clk_regs/a_110_47# _266_/a_651_413# 0
C6922 VPWR pmu_inst/dc_inst.x3.net12 0
C6923 net47 pmu_inst/_24_/a_448_47# 0.00114f
C6924 _268_/a_193_47# _013_ 0.00174f
C6925 VPWR _285_/a_1217_47# 0
C6926 VPWR pmu_inst/dc_inst.x6.x2/a_27_47# 0.00236f
C6927 _276_/a_1283_21# net17 0
C6928 _037_ _277_/a_543_47# 0
C6929 VPWR _190_/a_150_297# 0
C6930 _285_/a_27_47# _285_/a_193_47# -0.00582f
C6931 net39 pmu_inst/dc_inst.x1.x19/a_27_47# 0
C6932 net51 net50 0
C6933 net17 _280_/a_27_47# 0
C6934 input30/a_75_212# b[7] 0.01625f
C6935 net24 _279_/a_27_47# 0
C6936 clknet_0_clk_regs _263_/a_1462_47# 0
C6937 _096_ genblk1\[11\].fa_inst.b 0
C6938 clknet_2_0__leaf_clk_regs input10/a_75_212# 0.01336f
C6939 genblk1\[2\].fa_inst.s _304_/a_27_47# 0
C6940 input32/a_75_212# b[11] 0
C6941 _021_ net56 0.15287f
C6942 VPWR clkbuf_2_2__f_clk_regs/a_110_47# 0.16584f
C6943 _199_/a_377_297# _108_ 0
C6944 net61 _268_/a_1108_47# 0.00914f
C6945 _022_ VPWR 0.04838f
C6946 VPWR output51/a_27_47# 0.07863f
C6947 net7 _284_/a_448_47# 0
C6948 clknet_2_1__leaf_clk_regs a[12] 0
C6949 VPWR _264_/a_651_413# 0
C6950 _299_/a_651_413# net19 0
C6951 _273_/a_1217_47# net9 0
C6952 _304_/a_543_47# _055_ 0
C6953 genblk1\[10\].fa_inst.b _298_/a_651_413# 0
C6954 _287_/a_27_47# _287_/a_543_47# -0.00353f
C6955 _274_/a_761_289# clknet_2_0__leaf_clk_regs 0.04287f
C6956 _004_ clknet_0_clk_regs 0
C6957 net14 _279_/a_543_47# 0
C6958 _030_ net7 0.03267f
C6959 VPWR _266_/a_1108_47# 0.01329f
C6960 net46 pmu_inst/_17_/a_174_21# 0
C6961 _129_/a_285_47# VPWR 0.00176f
C6962 _080_ _077_ 0.16745f
C6963 net61 net59 0.11799f
C6964 _283_/a_193_47# net31 0.02185f
C6965 genblk1\[11\].fa_inst.s _011_ 0
C6966 _274_/a_27_47# VPWR 0.01179f
C6967 _304_/a_448_47# net33 0.00236f
C6968 _304_/a_1108_47# _049_ -0.00454f
C6969 net58 _278_/a_27_47# 0.02227f
C6970 net29 _279_/a_543_47# 0
C6971 _282_/a_27_47# net31 0.02517f
C6972 VPWR genblk1\[5\].fa_inst.b 0.55311f
C6973 _287_/a_805_47# net60 0
C6974 _292_/a_27_47# _023_ 0
C6975 _293_/a_193_47# _038_ -0.00289f
C6976 net59 _298_/a_1270_413# 0
C6977 _267_/a_193_47# _267_/a_448_47# -0.00373f
C6978 input15/a_75_212# net36 0
C6979 net5 _282_/a_193_47# 0
C6980 net46 pmu_inst/dc_inst.x4.net13 0
C6981 net27 _297_/a_651_413# 0
C6982 net39 pmu_inst/dc_inst.x4.net17 0.01154f
C6983 VPWR _289_/a_1108_47# 0.01723f
C6984 pmu_inst/dc_inst.x3.net14 net67 -0
C6985 net49 genblk1\[4\].fa_inst.s 0.00164f
C6986 _292_/a_27_47# net3 0
C6987 clkload0/a_361_47# clkbuf_2_0__f_clk_regs/a_110_47# 0.03332f
C6988 _084_ _165_/a_150_297# 0
C6989 _302_/a_1108_47# genblk1\[14\].fa_inst.b 0.00131f
C6990 _292_/a_27_47# _292_/a_193_47# -0.20963f
C6991 net58 net4 0
C6992 VPWR _284_/a_1217_47# 0
C6993 _272_/a_193_47# _288_/a_1108_47# 0
C6994 _272_/a_448_47# _288_/a_27_47# 0
C6995 _272_/a_1108_47# _288_/a_193_47# 0
C6996 _272_/a_27_47# _288_/a_448_47# 0
C6997 _272_/a_543_47# _288_/a_543_47# 0.00173f
C6998 _276_/a_1217_47# VPWR 0
C6999 genblk1\[6\].fa_inst.s _076_ 0.00702f
C7000 _257_/a_1108_47# genblk1\[2\].fa_inst.s 0
C7001 _257_/a_193_47# net47 0
C7002 _257_/a_1283_21# _002_ 0.01158f
C7003 _063_ _060_ 0
C7004 _291_/a_193_47# _035_ 0
C7005 _294_/a_543_47# net4 0.00415f
C7006 _178_/a_298_297# _085_ 0.0181f
C7007 _300_/a_193_47# _285_/a_1283_21# 0
C7008 _300_/a_27_47# _285_/a_1108_47# 0
C7009 net47 pmu_inst/_25_/a_651_413# 0.00143f
C7010 genblk1\[3\].fa_inst.b net33 0.26307f
C7011 net33 _299_/a_1462_47# 0
C7012 cin_q _133_/a_113_47# 0
C7013 net47 pmu_inst/dc_inst.x8/a_1478_413# 0.00186f
C7014 net47 pmu_inst/_02_ 0.03527f
C7015 _268_/a_639_47# net43 0
C7016 _268_/a_1462_47# _013_ 0
C7017 net47 pmu_inst/dc_inst.x9/a_193_413# 0
C7018 net4 _283_/a_448_47# 0
C7019 VPWR _286_/a_27_47# 0.02877f
C7020 clknet_2_3__leaf_clk_regs net18 0.16204f
C7021 _277_/a_1283_21# _036_ 0.00104f
C7022 net58 net57 0.18441f
C7023 net33 _078_ 0
C7024 genblk1\[8\].fa_inst.b _170_/a_68_297# 0
C7025 clknet_2_1__leaf_clk_regs _278_/a_639_47# 0.00441f
C7026 net61 _267_/a_1108_47# 0.00467f
C7027 _302_/a_1283_21# _301_/a_27_47# 0
C7028 _302_/a_193_47# _301_/a_543_47# 0.00121f
C7029 _302_/a_543_47# _301_/a_193_47# 0
C7030 genblk1\[12\].fa_inst.a genblk1\[11\].fa_inst.a 0.19708f
C7031 genblk1\[0\].fa_inst.s _051_ 0
C7032 _294_/a_1108_47# _279_/a_1283_21# 0
C7033 _198_/a_215_297# _194_/a_47_47# 0.00155f
C7034 net18 net32 0.34859f
C7035 _291_/a_805_47# net36 0
C7036 net46 pmu_inst/dc_inst.x5.x11/a_27_47# 0
C7037 net3 _298_/a_639_47# 0
C7038 _283_/a_761_289# clknet_2_2__leaf_clk_regs 0
C7039 _044_ net18 0
C7040 net7 _029_ 0.00763f
C7041 genblk1\[3\].fa_inst.a genblk1\[0\].fa_inst.b 0
C7042 _054_ _135_/a_215_297# 0.06472f
C7043 _293_/a_1217_47# _038_ -0
C7044 _282_/a_193_47# clknet_2_2__leaf_clk_regs 0.02089f
C7045 a[11] net13 0
C7046 net25 a[8] 0
C7047 clknet_2_0__leaf_clk_regs _260_/a_1283_21# 0
C7048 net46 pmu_inst/dc_inst.x1.net6 0.00497f
C7049 net46 pmu_inst/dc_inst.x6.net2 0.00839f
C7050 VPWR _260_/a_761_289# 0.00834f
C7051 genblk1\[5\].fa_inst.a net17 0.13342f
C7052 _263_/a_1283_21# net62 0
C7053 net29 genblk1\[10\].fa_inst.a 0
C7054 output55/a_27_47# pmu_inst_71/HI 0.00172f
C7055 _274_/a_1217_47# VPWR 0
C7056 net33 _049_ 0
C7057 _060_ _057_ 0.02935f
C7058 net58 _278_/a_1217_47# 0
C7059 _275_/a_193_47# _273_/a_27_47# 0
C7060 _275_/a_27_47# _273_/a_193_47# 0
C7061 _022_ net2 0
C7062 genblk1\[1\].fa_inst.a net17 0.02608f
C7063 _277_/a_1108_47# net12 0
C7064 _292_/a_1217_47# _023_ 0
C7065 _267_/a_193_47# _012_ 0
C7066 _284_/a_27_47# _284_/a_193_47# -0.01902f
C7067 net75 hold1/a_391_47# 0.00266f
C7068 net54 genblk1\[9\].fa_inst.s 0
C7069 net47 pmu_inst/_14_/a_218_374# 0
C7070 genblk1\[4\].fa_inst.a _065_ 0.07994f
C7071 _298_/a_543_47# net18 0
C7072 _298_/a_761_289# _043_ 0
C7073 _279_/a_1108_47# _278_/a_1108_47# 0
C7074 VPWR net24 1.44165f
C7075 net22 genblk1\[14\].fa_inst.b 0
C7076 net59 net36 0
C7077 clk net62 0.20039f
C7078 VPWR net64 0.45542f
C7079 _274_/a_651_413# net8 0
C7080 clknet_2_0__leaf_clk_regs _288_/a_761_289# 0.00222f
C7081 _257_/a_1462_47# net47 0
C7082 net20 _285_/a_27_47# 0
C7083 _276_/a_761_289# VPWR 0.00584f
C7084 net36 _298_/a_27_47# 0
C7085 net1 _288_/a_193_47# 0
C7086 VPWR _288_/a_27_47# 0.11149f
C7087 net39 pmu_inst/dc_inst.x4.x9/a_27_47# 0.00237f
C7088 net47 pmu_inst/dc_inst.x9/a_834_97# 0
C7089 net47 pmu_inst/_13_/a_112_47# 0.01087f
C7090 net4 _028_ 0
C7091 _194_/a_47_47# _102_ 0
C7092 VPWR _286_/a_1217_47# 0
C7093 net19 net18 0
C7094 _285_/a_543_47# genblk1\[13\].fa_inst.a 0
C7095 b[7] net36 0
C7096 net4 _279_/a_805_47# 0
C7097 _026_ genblk1\[8\].fa_inst.a 0.00121f
C7098 _270_/a_1283_21# net62 0.01163f
C7099 clknet_2_1__leaf_clk_regs genblk1\[6\].fa_inst.a 0.18733f
C7100 net46 pmu_inst/dc_inst.x4.net3 0.00101f
C7101 cout_next pmu_inst/_08_ 0
C7102 net62 _278_/a_1108_47# 0
C7103 _079_ _076_ 0
C7104 _301_/a_27_47# net7 0.02206f
C7105 VPWR _296_/a_805_47# 0
C7106 genblk1\[2\].fa_inst.s _139_/a_129_47# 0
C7107 net46 pmu_inst/_18_/a_535_374# 0
C7108 VPWR input5/a_27_47# 0.09214f
C7109 VPWR genblk1\[13\].fa_inst.s 1.15124f
C7110 _162_/a_113_47# genblk1\[7\].fa_inst.b 0
C7111 _282_/a_1462_47# clknet_2_2__leaf_clk_regs 0
C7112 _256_/a_27_47# net57 0.01024f
C7113 _276_/a_1462_47# VPWR 0
C7114 _066_ net58 0
C7115 VPWR pmu_inst/dc_inst.x2.net15 0.00193f
C7116 net25 b[2] 0.00223f
C7117 net52 net59 0
C7118 _287_/a_1108_47# genblk1\[15\].fa_inst.a 0
C7119 _287_/a_1270_413# _032_ -0
C7120 _302_/a_1108_47# clknet_2_2__leaf_clk_regs 0
C7121 net59 _295_/a_761_289# 0
C7122 net47 pmu_inst/dc_inst.x10/a_218_374# 0
C7123 _031_ net7 0.4924f
C7124 clknet_0_clk_regs _265_/a_1270_413# 0
C7125 _258_/a_543_47# net57 0
C7126 _283_/a_193_47# _297_/a_193_47# 0
C7127 _283_/a_761_289# _297_/a_27_47# 0
C7128 fanout58/a_27_47# net52 0.00199f
C7129 net7 net31 2.31809f
C7130 _282_/a_193_47# _297_/a_27_47# 0
C7131 _282_/a_27_47# _297_/a_193_47# 0
C7132 a[0] a[2] 0.01483f
C7133 genblk1\[1\].fa_inst.b _058_ 0.00134f
C7134 _301_/a_1108_47# VPWR 0.02891f
C7135 VPWR input19/a_75_212# 0.08486f
C7136 _004_ _258_/a_193_47# 0
C7137 _290_/a_27_47# net36 0.00316f
C7138 _024_ _278_/a_1283_21# 0
C7139 VPWR _204_/a_561_297# 0
C7140 _300_/a_543_47# _045_ 0
C7141 _300_/a_1283_21# net20 0
C7142 _291_/a_761_289# clknet_2_1__leaf_clk_regs 0.00142f
C7143 net49 _259_/a_1108_47# 0.00142f
C7144 _292_/a_448_47# _037_ 0
C7145 _292_/a_543_47# genblk1\[4\].fa_inst.b 0
C7146 _292_/a_651_413# net27 0
C7147 _294_/a_448_47# clknet_2_1__leaf_clk_regs 0
C7148 _303_/a_543_47# VPWR 0.0038f
C7149 net43 net42 0
C7150 VPWR b[6] 0.21705f
C7151 VPWR _281_/a_805_47# 0
C7152 _300_/a_27_47# _286_/a_1108_47# 0
C7153 _300_/a_193_47# _286_/a_1283_21# 0.00861f
C7154 VPWR _288_/a_1217_47# 0
C7155 _273_/a_448_47# net56 0
C7156 _129_/a_377_297# _052_ 0
C7157 _129_/a_47_47# net75 0.01082f
C7158 _297_/a_805_47# net30 0
C7159 net37 net44 0.04855f
C7160 net13 net36 0.02764f
C7161 net56 genblk1\[2\].fa_inst.b 0.03111f
C7162 net2 net24 0.02166f
C7163 net3 _295_/a_543_47# 0.01171f
C7164 net45 net44 0
C7165 net33 _197_/a_113_47# 0
C7166 _302_/a_805_47# net21 0
C7167 _285_/a_27_47# b[10] 0
C7168 _274_/a_27_47# _274_/a_193_47# -0.32207f
C7169 _291_/a_1283_21# net58 0
C7170 genblk1\[5\].fa_inst.b _069_ 0.14724f
C7171 clknet_2_1__leaf_clk_regs a[8] 0.00223f
C7172 _076_ _073_ 0.12062f
C7173 _256_/a_1217_47# net57 0
C7174 output46/a_27_47# VPWR 0.1034f
C7175 net17 _024_ 0.00169f
C7176 net22 clknet_2_2__leaf_clk_regs 0.06662f
C7177 net54 cout_next 0.02886f
C7178 VPWR _278_/a_805_47# 0
C7179 _290_/a_543_47# net25 0
C7180 _290_/a_761_289# _035_ 0.00331f
C7181 net25 b[1] 0
C7182 output42/a_27_47# s[12] 0.01236f
C7183 _185_/a_68_297# _299_/a_193_47# 0
C7184 _286_/a_448_47# net6 0.00197f
C7185 a[14] net14 0.00124f
C7186 net59 _081_ 0
C7187 net71 pmu_inst/dc_inst.x5.x15/a_27_47# -0
C7188 _275_/a_1270_413# clknet_2_1__leaf_clk_regs 0
C7189 _284_/a_543_47# genblk1\[12\].fa_inst.a 0
C7190 _264_/a_639_47# _009_ 0.00128f
C7191 _264_/a_448_47# net54 0
C7192 net21 VPWR 0.46935f
C7193 net46 pmu_inst/dc_inst.x6.x20/a_27_47# 0
C7194 input30/a_75_212# net30 0.00197f
C7195 _290_/a_1217_47# net36 0
C7196 VPWR net53 4.39474f
C7197 clkbuf_2_1__f_clk_regs/a_110_47# clknet_0_clk_regs 0.30098f
C7198 _098_ _094_ 0
C7199 net33 _143_/a_27_413# 0
C7200 net40 output40/a_27_47# 0.0207f
C7201 _271_/a_27_47# net44 0.03386f
C7202 _269_/a_805_47# clknet_2_3__leaf_clk_regs 0
C7203 net20 _286_/a_27_47# 0.00486f
C7204 _274_/a_448_47# net10 0
C7205 net11 a[8] 0
C7206 VPWR _065_ 0.58649f
C7207 net15 _279_/a_27_47# 0
C7208 _266_/a_1108_47# _011_ 0.00643f
C7209 _266_/a_761_289# net41 0
C7210 VPWR pmu_inst/dc_inst.x2.net7 0
C7211 _018_ net56 0.07597f
C7212 _169_/a_285_47# _083_ 0.01298f
C7213 genblk1\[9\].fa_inst.a _086_ 0.00324f
C7214 net56 _135_/a_382_47# 0
C7215 net34 pmu_inst/clkbuf_1_0__f_clk/a_110_47# 0
C7216 _256_/a_193_47# _255_/a_193_47# 0
C7217 _256_/a_27_47# _255_/a_761_289# 0
C7218 _160_/a_150_297# genblk1\[7\].fa_inst.b 0
C7219 _160_/a_68_297# _077_ 0.0013f
C7220 _283_/a_27_47# net59 0
C7221 _286_/a_27_47# _286_/a_193_47# -0.168f
C7222 net27 net25 0
C7223 net47 pmu_inst/dc_inst.x3.x6/a_27_47# 0.00243f
C7224 _283_/a_27_47# _298_/a_27_47# 0
C7225 net37 VPWR 1.01698f
C7226 _184_/a_47_47# clknet_2_3__leaf_clk_regs 0.09683f
C7227 genblk1\[3\].fa_inst.b _064_ 0.00223f
C7228 _269_/a_193_47# _013_ 0
C7229 _014_ _268_/a_193_47# 0
C7230 VPWR _076_ 0.68977f
C7231 net45 VPWR 2.88854f
C7232 genblk1\[2\].fa_inst.b _055_ 0
C7233 _277_/a_193_47# net12 0.08979f
C7234 clkload0/Y VPWR -0.06684f
C7235 _294_/a_27_47# _279_/a_543_47# 0
C7236 _290_/a_193_47# genblk1\[2\].fa_inst.b 0
C7237 net3 _280_/a_805_47# 0
C7238 clk _264_/a_761_289# 0.00573f
C7239 _270_/a_27_47# cout_next 0
C7240 _049_ _059_ 0
C7241 _304_/a_193_47# _057_ 0
C7242 _097_ _299_/a_1108_47# 0
C7243 clknet_2_0__leaf_clk_regs _255_/a_543_47# 0.00144f
C7244 net61 _269_/a_1108_47# 0.01302f
C7245 _031_ net6 0.00426f
C7246 _099_ _186_/a_113_47# 0
C7247 net4 _284_/a_27_47# 0.03602f
C7248 _277_/a_543_47# VPWR 0.02813f
C7249 _298_/a_1270_413# net30 0
C7250 _105_ _110_ 0.02786f
C7251 _302_/a_27_47# clknet_2_3__leaf_clk_regs 0.0418f
C7252 clk _266_/a_27_47# 0.04375f
C7253 _020_ _018_ 0
C7254 _255_/a_193_47# VPWR 0.02022f
C7255 genblk1\[3\].fa_inst.a _135_/a_27_413# 0
C7256 _289_/a_448_47# net24 0.00252f
C7257 _289_/a_1108_47# _034_ 0.00643f
C7258 _289_/a_761_289# genblk1\[1\].fa_inst.b 0
C7259 _283_/a_651_413# _042_ 0
C7260 _301_/a_543_47# _300_/a_651_413# 0
C7261 clkbuf_2_3__f_clk_regs/a_110_47# _265_/a_651_413# 0
C7262 genblk1\[4\].fa_inst.a genblk1\[3\].fa_inst.a 0.24f
C7263 _292_/a_193_47# _277_/a_1108_47# 0
C7264 _200_/a_145_75# net33 0
C7265 _099_ _185_/a_68_297# 0
C7266 _259_/a_651_413# VPWR 0
C7267 _009_ net54 0
C7268 net3 _283_/a_193_47# 0.30392f
C7269 net6 net31 0.01621f
C7270 genblk1\[11\].fa_inst.s _093_ 0
C7271 genblk1\[7\].fa_inst.b _295_/a_193_47# 0
C7272 net3 _282_/a_27_47# 0.01965f
C7273 net7 _297_/a_193_47# 0.03443f
C7274 _097_ _044_ 0
C7275 pmu_inst/_18_/a_505_21# net64 0
C7276 _301_/a_193_47# genblk1\[13\].fa_inst.b 0
C7277 genblk1\[8\].fa_inst.a net59 0
C7278 _275_/a_27_47# clknet_2_0__leaf_clk_regs 0
C7279 _302_/a_761_289# net60 0.00349f
C7280 _080_ genblk1\[7\].fa_inst.a 0
C7281 _300_/a_27_47# clknet_2_2__leaf_clk_regs 0.02814f
C7282 _188_/a_382_47# genblk1\[11\].fa_inst.b 0
C7283 _049_ _064_ 0
C7284 _271_/a_448_47# net62 0
C7285 output47/a_27_47# s[3] 0
C7286 _292_/a_27_47# genblk1\[5\].fa_inst.a 0
C7287 _294_/a_805_47# VPWR 0
C7288 _294_/a_761_289# _280_/a_543_47# 0
C7289 net20 _286_/a_1217_47# 0
C7290 _019_ net10 0
C7291 net39 pmu_inst/dc_inst.x5.net14 0.00505f
C7292 genblk1\[0\].fa_inst.b _135_/a_27_413# 0
C7293 _260_/a_27_47# _260_/a_1108_47# -0
C7294 _261_/a_193_47# net51 0
C7295 _261_/a_1108_47# genblk1\[6\].fa_inst.s 0.00104f
C7296 _261_/a_1283_21# _006_ 0.05464f
C7297 input7/a_27_47# net15 0.0065f
C7298 _031_ _030_ 0
C7299 _284_/a_448_47# net31 0.00993f
C7300 _291_/a_543_47# VPWR 0.01497f
C7301 _280_/a_193_47# net36 0
C7302 _283_/a_1217_47# net59 0
C7303 _143_/a_215_297# net36 0.00156f
C7304 net27 _295_/a_805_47# 0
C7305 net28 genblk1\[9\].fa_inst.a 0.15966f
C7306 _009_ _263_/a_27_47# 0
C7307 VPWR _265_/a_1108_47# 0.01379f
C7308 _271_/a_27_47# VPWR 0.03633f
C7309 _185_/a_150_297# net33 0
C7310 _188_/a_27_413# clknet_2_3__leaf_clk_regs 0
C7311 _274_/a_543_47# genblk1\[2\].fa_inst.a 0
C7312 _272_/a_639_47# net56 0.00445f
C7313 input14/a_75_212# net14 0.00208f
C7314 _268_/a_1283_21# net62 0.00229f
C7315 genblk1\[5\].fa_inst.a net33 0.89116f
C7316 VPWR _297_/a_448_47# 0.00177f
C7317 _135_/a_382_47# _055_ 0.00306f
C7318 clknet_2_2__leaf_clk_regs _264_/a_543_47# 0
C7319 net22 input21/a_75_212# 0.01583f
C7320 _290_/a_543_47# clknet_2_1__leaf_clk_regs 0.00195f
C7321 _083_ _173_/a_215_297# 0.01094f
C7322 clknet_2_1__leaf_clk_regs b[1] 0
C7323 genblk1\[0\].fa_inst.b _053_ 0
C7324 _050_ _056_ 0.00137f
C7325 genblk1\[2\].fa_inst.a _289_/a_1270_413# 0
C7326 _290_/a_1462_47# genblk1\[2\].fa_inst.b 0
C7327 _295_/a_193_47# _295_/a_448_47# -0.00297f
C7328 _106_ _201_/a_61_47# 0
C7329 genblk1\[1\].fa_inst.a net33 0
C7330 net29 _296_/a_543_47# 0.0012f
C7331 genblk1\[11\].fa_inst.a _299_/a_1283_21# 0
C7332 genblk1\[2\].fa_inst.s _053_ 0
C7333 _051_ _134_/a_47_47# 0
C7334 _258_/a_27_47# _258_/a_193_47# -0.05253f
C7335 _292_/a_651_413# net58 0.00327f
C7336 clkbuf_0_clk/a_110_47# clknet_1_0__leaf_clk 0.00578f
C7337 clk _266_/a_1217_47# 0
C7338 net28 genblk1\[6\].fa_inst.a 0.0291f
C7339 _302_/a_27_47# net19 0
C7340 _255_/a_1462_47# VPWR 0
C7341 clknet_2_0__leaf_clk_regs _304_/a_761_289# 0.04283f
C7342 net24 _034_ 0.00443f
C7343 _023_ _279_/a_1108_47# 0
C7344 VPWR net15 1.34145f
C7345 _161_/a_113_47# genblk1\[7\].fa_inst.b 0
C7346 _302_/a_543_47# _287_/a_543_47# 0
C7347 _302_/a_1108_47# _287_/a_193_47# 0
C7348 _302_/a_1283_21# _287_/a_761_289# 0
C7349 _302_/a_448_47# _287_/a_27_47# 0
C7350 _301_/a_1283_21# _045_ 0
C7351 _094_ VPWR 0.35014f
C7352 net7 _299_/a_193_47# 0.00106f
C7353 _304_/a_27_47# _136_/a_68_297# 0
C7354 VPWR pmu_inst_69/HI 0.05202f
C7355 _027_ _042_ 0
C7356 _100_ _094_ 0.01107f
C7357 _303_/a_193_47# input23/a_75_212# 0
C7358 genblk1\[14\].fa_inst.b _106_ 0.13441f
C7359 net36 net30 0.02772f
C7360 _304_/a_27_47# VPWR 0.03665f
C7361 net3 _279_/a_1108_47# 0
C7362 genblk1\[7\].fa_inst.b _295_/a_1462_47# 0
C7363 net64 net65 0.0732f
C7364 _130_/a_215_297# net75 0.00216f
C7365 _067_ _153_/a_27_413# 0.00114f
C7366 _280_/a_193_47# _295_/a_761_289# 0
C7367 _280_/a_543_47# _295_/a_27_47# 0
C7368 _280_/a_27_47# _295_/a_543_47# 0.00156f
C7369 _280_/a_761_289# _295_/a_193_47# 0
C7370 _301_/a_761_289# _286_/a_1283_21# 0.00118f
C7371 _301_/a_193_47# _286_/a_1108_47# 0
C7372 _286_/a_193_47# input19/a_75_212# 0
C7373 net39 pmu_inst/dc_inst.x4.net19 0.01325f
C7374 _275_/a_639_47# VPWR 0.0012f
C7375 _163_/a_27_413# _074_ 0.02095f
C7376 genblk1\[10\].fa_inst.a genblk1\[10\].fa_inst.b 0.39894f
C7377 fanout61/a_27_47# net34 0
C7378 _016_ net62 0.1208f
C7379 _158_/a_27_413# genblk1\[5\].fa_inst.b 0.00126f
C7380 VPWR pmu_inst/dc_inst.in 0.03275f
C7381 _148_/a_215_297# VPWR -0.00272f
C7382 _023_ net62 0.00285f
C7383 _200_/a_59_75# _105_ 0
C7384 _288_/a_27_47# _288_/a_193_47# -0.00613f
C7385 net26 clknet_2_0__leaf_clk_regs 0.04114f
C7386 _078_ net62 0
C7387 _050_ _057_ 0
C7388 net39 pmu_inst/dc_inst.x5.net5 0.00183f
C7389 _290_/a_543_47# net11 0.02004f
C7390 _261_/a_1462_47# net51 0
C7391 net27 clknet_2_1__leaf_clk_regs 0.01807f
C7392 _029_ net31 0
C7393 _256_/a_1283_21# net39 0.00541f
C7394 _256_/a_651_413# _000_ 0
C7395 net46 _255_/a_1283_21# 0
C7396 net3 net62 0
C7397 _286_/a_543_47# genblk1\[14\].fa_inst.a 0
C7398 _286_/a_448_47# _031_ 0
C7399 net47 pmu_inst/_23_/a_543_47# 0.00338f
C7400 VPWR _299_/a_448_47# 0.01577f
C7401 net70 pmu_inst_71/HI 0
C7402 fanout56/a_27_47# net36 0.00423f
C7403 clknet_2_1__leaf_clk_regs _261_/a_1283_21# 0
C7404 _283_/a_1108_47# _043_ 0
C7405 _283_/a_448_47# net18 0
C7406 net22 input22/a_75_212# 0.00386f
C7407 genblk1\[0\].fa_inst.a net56 0.9142f
C7408 _289_/a_27_47# net12 0.04017f
C7409 _281_/a_543_47# _296_/a_651_413# 0
C7410 net29 _281_/a_543_47# 0.0171f
C7411 _281_/a_1108_47# _296_/a_1108_47# 0
C7412 net44 net43 0
C7413 _274_/a_639_47# net9 0.00114f
C7414 _257_/a_651_413# clknet_2_0__leaf_clk_regs 0
C7415 VPWR _042_ 0.01206f
C7416 _100_ _187_/a_113_47# 0
C7417 _187_/a_113_47# VPWR -0
C7418 _257_/a_1108_47# VPWR 0.01991f
C7419 _070_ genblk1\[5\].fa_inst.b 0.1227f
C7420 _295_/a_761_289# net30 0.04242f
C7421 _295_/a_193_47# _040_ 0.00483f
C7422 net46 pmu_inst/_20_/a_470_297# 0
C7423 _291_/a_543_47# net2 0
C7424 net27 _025_ 0.08318f
C7425 _296_/a_1283_21# _041_ 0.00785f
C7426 _296_/a_1108_47# net31 0
C7427 net28 _297_/a_1108_47# 0.00288f
C7428 net24 net4 0.02165f
C7429 _139_/a_285_47# _057_ 0.00833f
C7430 _259_/a_543_47# net58 0
C7431 fanout58/a_27_47# _262_/a_1283_21# 0.00548f
C7432 b[5] b[6] 0.06871f
C7433 _047_ _287_/a_27_47# 0
C7434 net22 _287_/a_193_47# 0
C7435 net21 net20 0.13444f
C7436 _304_/a_1283_21# _058_ 0
C7437 _065_ _069_ 0
C7438 _293_/a_193_47# VPWR 0.03484f
C7439 net58 _261_/a_448_47# 0
C7440 _287_/a_761_289# net7 0.01115f
C7441 _173_/a_27_413# _082_ 0.04261f
C7442 VPWR pmu_inst/dc_inst.x1.net3 0.02168f
C7443 net47 pmu_inst/dc_inst.x7.x17/a_27_47# 0.00254f
C7444 _076_ _075_ 0.08815f
C7445 net10 net12 0
C7446 _143_/a_27_413# _059_ 0.04506f
C7447 net27 _279_/a_193_47# 0.02937f
C7448 _085_ _174_/a_285_47# 0
C7449 net6 _297_/a_193_47# 0
C7450 net27 _282_/a_651_413# 0.00266f
C7451 genblk1\[10\].fa_inst.a _085_ 0.00115f
C7452 _301_/a_27_47# _031_ 0.03102f
C7453 net21 _286_/a_193_47# 0.00831f
C7454 genblk1\[3\].fa_inst.a _017_ 0
C7455 genblk1\[3\].fa_inst.a _136_/a_68_297# 0.01324f
C7456 net3 net7 1.62479f
C7457 clk _263_/a_1283_21# 0.00238f
C7458 b[10] input19/a_75_212# 0
C7459 input18/a_75_212# b[11] 0.00367f
C7460 VPWR _298_/a_1283_21# 0.07291f
C7461 net47 pmu_inst/dc_inst.x3.x5/a_27_47# 0.00444f
C7462 genblk1\[3\].fa_inst.a VPWR 1.05803f
C7463 VPWR _038_ 0.34376f
C7464 _301_/a_27_47# b[12] 0
C7465 s[1] s[0] 0
C7466 _076_ _069_ 0
C7467 net2 net15 0.04424f
C7468 _286_/a_651_413# clknet_2_2__leaf_clk_regs 0.00535f
C7469 VPWR pmu_inst/dc_inst.x4.x18/a_27_47# 0
C7470 _154_/a_47_47# genblk1\[5\].fa_inst.s 0.00408f
C7471 _189_/a_47_47# genblk1\[12\].fa_inst.a 0
C7472 input6/a_27_47# net15 0.00655f
C7473 _165_/a_68_297# _088_ 0
C7474 VPWR pmu_inst/dc_inst.x2.x18/a_27_47# 0.00688f
C7475 net33 _024_ 0
C7476 _285_/a_761_289# clknet_2_3__leaf_clk_regs 0
C7477 net47 pmu_inst/_01_ 0.0051f
C7478 _143_/a_27_413# _064_ 0
C7479 pmu_inst/dc_inst.x7.x11/a_27_47# net34 0
C7480 _277_/a_761_289# net16 0.00478f
C7481 _106_ _111_ -0
C7482 VPWR _287_/a_651_413# 0.00131f
C7483 clknet_2_2__leaf_clk_regs _296_/a_448_47# 0
C7484 _281_/a_1283_21# _041_ 0
C7485 genblk1\[9\].fa_inst.a _296_/a_193_47# 0
C7486 _026_ _296_/a_1283_21# 0
C7487 net39 pmu_inst/dc_inst.x6.x10/a_27_47# 0.00148f
C7488 _271_/a_761_289# cout_next 0.00189f
C7489 genblk1\[2\].fa_inst.a net9 0
C7490 net7 _298_/a_805_47# 0
C7491 _273_/a_761_289# clknet_2_1__leaf_clk_regs 0
C7492 net39 pmu_inst/dc_inst.x2.net4 0.01044f
C7493 _273_/a_27_47# _018_ 0
C7494 VPWR genblk1\[0\].fa_inst.b 0.7085f
C7495 _277_/a_193_47# net3 0
C7496 _277_/a_1270_413# VPWR 0
C7497 _292_/a_193_47# _277_/a_193_47# 0
C7498 _292_/a_448_47# VPWR 0.00198f
C7499 input9/a_75_212# a[2] 0.01461f
C7500 genblk1\[2\].fa_inst.s VPWR 2.46271f
C7501 net49 clknet_0_clk_regs 0
C7502 _295_/a_1462_47# _040_ 0
C7503 _270_/a_1283_21# clk 0
C7504 _285_/a_1283_21# net60 0.02177f
C7505 VPWR _092_ 0.43489f
C7506 net26 a[10] 0
C7507 net28 net32 0.02177f
C7508 _022_ _291_/a_1283_21# 0
C7509 VPWR net43 4.93476f
C7510 net46 pmu_inst/dc_inst.x4.net1 0
C7511 cout_next pmu_inst/_07_ 0
C7512 genblk1\[0\].fa_inst.a _055_ 0
C7513 _277_/a_1217_47# net58 0
C7514 _189_/a_47_47# _103_ 0
C7515 _039_ net16 0
C7516 _293_/a_1283_21# clknet_2_1__leaf_clk_regs 0.06702f
C7517 net39 pmu_inst/dc_inst.x5.x6/a_27_47# 0.00196f
C7518 net58 _006_ 0.04149f
C7519 output43/a_27_47# s[13] 0.00932f
C7520 _290_/a_1283_21# VPWR 0.04304f
C7521 clknet_2_1__leaf_clk_regs _280_/a_1283_21# 0
C7522 _081_ _088_ 0.05363f
C7523 _303_/a_193_47# _303_/a_448_47# -0.00779f
C7524 _301_/a_193_47# clknet_2_2__leaf_clk_regs 0.01741f
C7525 net39 pmu_inst/_17_/a_27_93# 0.00361f
C7526 net46 pmu_inst/dc_inst.x1.x19/a_27_47# 0.00302f
C7527 VPWR _139_/a_129_47# -0
C7528 clknet_2_2__leaf_clk_regs _263_/a_1108_47# 0
C7529 net69 net74 -0
C7530 _294_/a_1108_47# net17 0.00476f
C7531 pmu_inst/dc_inst.x3.x11/a_27_47# cout_next 0
C7532 _281_/a_761_289# net16 0
C7533 _281_/a_448_47# clknet_2_2__leaf_clk_regs 0
C7534 _281_/a_193_47# genblk1\[9\].fa_inst.a 0
C7535 _281_/a_1283_21# _026_ 0.00308f
C7536 clk_regs clknet_0_clk_regs 0.01879f
C7537 net22 net35 0.21105f
C7538 _284_/a_761_289# clknet_2_3__leaf_clk_regs 0
C7539 net47 net67 0.28252f
C7540 _283_/a_27_47# net30 0.02837f
C7541 _144_/a_285_47# _064_ 0.00164f
C7542 net4 _278_/a_805_47# 0
C7543 _280_/a_193_47# genblk1\[8\].fa_inst.a 0
C7544 _280_/a_1283_21# _025_ 0.00308f
C7545 _264_/a_193_47# net59 0.00977f
C7546 net28 genblk1\[6\].fa_inst.b 0.02404f
C7547 output38/a_27_47# VPWR 0.06059f
C7548 _285_/a_761_289# net19 0.01758f
C7549 _030_ _299_/a_193_47# 0
C7550 clknet_2_1__leaf_clk_regs genblk1\[5\].fa_inst.s 0
C7551 genblk1\[0\].fa_inst.s _129_/a_47_47# 0.00375f
C7552 net46 pmu_inst/dc_inst.x6.net17 0.0034f
C7553 net2 _038_ 0
C7554 clknet_2_2__leaf_clk_regs _041_ 0
C7555 _108_ _205_/a_47_47# 0.00111f
C7556 a[13] net16 0
C7557 _284_/a_1283_21# net60 0
C7558 _275_/a_1283_21# net10 0
C7559 VPWR _110_ 0.41172f
C7560 VPWR net42 17.39804f
C7561 _300_/a_1270_413# net60 0
C7562 genblk1\[1\].fa_inst.a _059_ 0
C7563 _277_/a_651_413# _291_/a_543_47# 0
C7564 _148_/a_382_47# _062_ 0.00346f
C7565 _037_ VPWR 0.06405f
C7566 _277_/a_761_289# _291_/a_193_47# 0
C7567 net62 _295_/a_1283_21# 0
C7568 _160_/a_68_297# genblk1\[7\].fa_inst.a 0.04519f
C7569 _047_ net36 0
C7570 _301_/a_1108_47# _046_ 0.00621f
C7571 _301_/a_448_47# net21 0.00574f
C7572 VPWR _261_/a_1108_47# 0.00782f
C7573 _275_/a_651_413# _274_/a_543_47# 0
C7574 _275_/a_1108_47# _274_/a_1108_47# 0
C7575 net46 pmu_inst/dc_inst.x4.net17 0
C7576 genblk1\[6\].fa_inst.s _073_ 0
C7577 _269_/a_193_47# _014_ 0.00741f
C7578 _263_/a_805_47# net53 0
C7579 _283_/a_193_47# _283_/a_761_289# -0.00365f
C7580 _283_/a_27_47# _283_/a_543_47# -0.00297f
C7581 _284_/a_1108_47# net59 0.00232f
C7582 net47 pmu_inst/dc_inst.x3.net3 0.00408f
C7583 _270_/a_761_289# _015_ 0
C7584 _292_/a_448_47# net2 0.00758f
C7585 _282_/a_27_47# _282_/a_193_47# -0.01782f
C7586 _284_/a_1108_47# _298_/a_27_47# 0
C7587 _303_/a_193_47# _048_ -0.00105f
C7588 _181_/a_113_47# genblk1\[12\].fa_inst.a 0
C7589 _284_/a_1283_21# _298_/a_193_47# 0
C7590 _284_/a_761_289# _298_/a_543_47# 0
C7591 _284_/a_543_47# _298_/a_761_289# 0
C7592 _135_/a_27_413# _053_ 0.00497f
C7593 _258_/a_1217_47# net36 0
C7594 _277_/a_1108_47# genblk1\[5\].fa_inst.a 0
C7595 net39 pmu_inst/dc_inst.x5.x4/a_27_47# 0.00231f
C7596 clknet_2_1__leaf_clk_regs net58 0.02275f
C7597 net75 net56 0
C7598 _278_/a_193_47# genblk1\[6\].fa_inst.a 0
C7599 _294_/a_543_47# clknet_2_1__leaf_clk_regs 0
C7600 _285_/a_27_47# net18 0.03257f
C7601 genblk1\[8\].fa_inst.a _088_ 0
C7602 _274_/a_1283_21# net56 0.01172f
C7603 net36 _058_ 0
C7604 _063_ genblk1\[3\].fa_inst.s 0.00336f
C7605 net48 net74 0.06851f
C7606 clknet_2_2__leaf_clk_regs _026_ 0.00462f
C7607 net17 _026_ 0
C7608 _281_/a_1462_47# genblk1\[9\].fa_inst.a 0
C7609 _284_/a_761_289# net19 0
C7610 _283_/a_1217_47# net30 0
C7611 _300_/a_448_47# net19 0.00687f
C7612 net46 pmu_inst/dc_inst.x1.x15/a_27_47# 0.00203f
C7613 VPWR _142_/a_113_47# -0
C7614 _280_/a_1462_47# genblk1\[8\].fa_inst.a 0
C7615 _264_/a_1462_47# net59 0
C7616 net61 _264_/a_1283_21# 0.00389f
C7617 net39 pmu_inst/dc_inst.x2.net5 0.0075f
C7618 net58 _025_ 0.19922f
C7619 VPWR _105_ 0.67943f
C7620 _286_/a_761_289# clknet_2_3__leaf_clk_regs 0.01054f
C7621 clk _265_/a_27_47# 0.04445f
C7622 net61 _266_/a_761_289# 0.00139f
C7623 _294_/a_543_47# _025_ 0
C7624 net64 net63 0.00625f
C7625 _045_ _044_ 0
C7626 net12 a[9] 0
C7627 clkload0/Y net57 0
C7628 _135_/a_215_297# _057_ 0.00362f
C7629 net58 _279_/a_193_47# 0.0288f
C7630 _286_/a_1283_21# net60 0
C7631 net21 _046_ 0.00468f
C7632 _300_/a_27_47# net35 0
C7633 tdo net39 0.00566f
C7634 _273_/a_1108_47# clknet_2_0__leaf_clk_regs 0.00286f
C7635 genblk1\[1\].fa_inst.a _272_/a_27_47# 0
C7636 _259_/a_1283_21# _258_/a_1108_47# 0
C7637 VPWR genblk1\[6\].fa_inst.s 1.71382f
C7638 net7 _280_/a_27_47# 0.02348f
C7639 _269_/a_1283_21# net62 0.01129f
C7640 net39 pmu_inst/_18_/a_218_47# 0
C7641 _275_/a_193_47# genblk1\[2\].fa_inst.a 0.00492f
C7642 _020_ _274_/a_1283_21# 0
C7643 _275_/a_1283_21# _019_ 0
C7644 _146_/a_113_47# _065_ 0
C7645 _294_/a_543_47# _279_/a_193_47# 0
C7646 net52 _262_/a_27_47# 0
C7647 _297_/a_193_47# net31 0.02414f
C7648 _164_/a_129_47# net62 0
C7649 net27 net28 0.0119f
C7650 _273_/a_1283_21# net1 0
C7651 _255_/a_193_47# net57 0
C7652 _273_/a_543_47# VPWR 0.00557f
C7653 _158_/a_27_413# _076_ 0
C7654 net34 cout_next 0.02913f
C7655 genblk1\[3\].fa_inst.s _057_ 0
C7656 _259_/a_651_413# net57 0
C7657 VPWR _295_/a_639_47# 0
C7658 _270_/a_805_47# net45 0
C7659 _272_/a_27_47# _272_/a_193_47# -0.0213f
C7660 net72 pmu_inst/dc_inst.x5.x15/a_27_47# -0
C7661 _277_/a_1462_47# genblk1\[5\].fa_inst.a 0
C7662 _037_ net2 0.00166f
C7663 _090_ _089_ 0.4421f
C7664 _200_/a_59_75# VPWR 0.0156f
C7665 _303_/a_639_47# genblk1\[15\].fa_inst.b 0
C7666 net60 _194_/a_129_47# 0.00275f
C7667 _284_/a_27_47# net18 0.02473f
C7668 net46 pmu_inst/dc_inst.x4.x9/a_27_47# 0
C7669 net46 pmu_inst/dc_inst.x6.net18 0
C7670 genblk1\[9\].fa_inst.a _170_/a_150_297# 0
C7671 _289_/a_27_47# a[6] 0.00158f
C7672 VPWR _173_/a_382_47# -0
C7673 _079_ _073_ 0
C7674 net39 pmu_inst/dc_inst.x5.net2 0.00778f
C7675 _129_/a_285_47# _050_ 0
C7676 pmu_inst/dc_inst.x3.net10 net67 0
C7677 _259_/a_1270_413# net36 0
C7678 _159_/a_47_47# _076_ 0.03071f
C7679 clkbuf_2_1__f_clk_regs/a_110_47# _260_/a_27_47# 0
C7680 _300_/a_193_47# net36 0
C7681 _168_/a_382_47# _080_ 0.0013f
C7682 net59 _296_/a_1283_21# 0.01681f
C7683 net4 _297_/a_448_47# 0
C7684 VPWR _280_/a_1108_47# 0.02089f
C7685 s[14] net44 0.01123f
C7686 _131_/a_68_297# _033_ 0
C7687 _045_ net19 0.00737f
C7688 _266_/a_193_47# net35 0
C7689 _076_ _070_ 0
C7690 _184_/a_47_47# genblk1\[11\].fa_inst.s 0
C7691 net75 _055_ 0.0275f
C7692 genblk1\[1\].fa_inst.b net56 0.11215f
C7693 _087_ _081_ 0
C7694 _179_/a_47_47# clknet_2_2__leaf_clk_regs 0
C7695 _286_/a_761_289# net19 0.02201f
C7696 clk _265_/a_1217_47# 0
C7697 _066_ _065_ 0.2104f
C7698 genblk1\[3\].fa_inst.a _140_/a_68_297# 0.07861f
C7699 net4 net15 0.0365f
C7700 clknet_2_2__leaf_clk_regs _297_/a_761_289# 0.02202f
C7701 VPWR _192_/a_113_47# -0
C7702 _288_/a_1283_21# net56 0.01544f
C7703 cout_next genblk1\[15\].fa_inst.s 0.02984f
C7704 _284_/a_651_413# net35 0.02627f
C7705 VPWR b[9] 0.23712f
C7706 a[11] net14 0
C7707 net46 pmu_inst/dc_inst.x7.x1/a_27_47# 0.00119f
C7708 _270_/a_27_47# clknet_2_3__leaf_clk_regs 0.62942f
C7709 _275_/a_1462_47# genblk1\[2\].fa_inst.a 0
C7710 VPWR pmu_inst/dc_inst.x1.x18/a_27_47# 0.00214f
C7711 _263_/a_543_47# net59 0
C7712 genblk1\[12\].fa_inst.b genblk1\[11\].fa_inst.a 0
C7713 _304_/a_1270_413# genblk1\[1\].fa_inst.b 0
C7714 genblk1\[5\].fa_inst.s _072_ 0.00311f
C7715 s[15] cout 0.00221f
C7716 clknet_2_1__leaf_clk_regs net1 0
C7717 _255_/a_1462_47# net57 0
C7718 genblk1\[4\].fa_inst.a _136_/a_68_297# 0
C7719 net52 _262_/a_543_47# 0
C7720 _283_/a_1108_47# genblk1\[11\].fa_inst.a 0.00143f
C7721 net33 net23 0
C7722 VPWR _135_/a_27_413# 0.02994f
C7723 _258_/a_543_47# genblk1\[3\].fa_inst.s 0
C7724 _281_/a_193_47# b[2] 0
C7725 genblk1\[4\].fa_inst.a VPWR 1.27784f
C7726 _282_/a_543_47# genblk1\[10\].fa_inst.a 0
C7727 _282_/a_448_47# _027_ 0
C7728 genblk1\[14\].fa_inst.s _110_ 0.05854f
C7729 genblk1\[3\].fa_inst.a _034_ 0
C7730 pmu_inst/dc_inst.x3.x9/a_27_47# cout_next 0
C7731 net49 s[4] 0.00187f
C7732 _281_/a_1283_21# net59 0.04258f
C7733 net7 _283_/a_761_289# 0.00122f
C7734 _304_/a_651_413# _288_/a_1108_47# 0
C7735 fanout58/a_27_47# _263_/a_543_47# 0
C7736 net7 _282_/a_193_47# 0.02512f
C7737 net26 a[12] 0
C7738 _294_/a_1283_21# genblk1\[6\].fa_inst.b 0.00127f
C7739 _079_ VPWR 0.54854f
C7740 clkload2/a_27_47# genblk1\[10\].fa_inst.s 0
C7741 _290_/a_193_47# input14/a_75_212# 0
C7742 net28 _295_/a_1270_413# 0
C7743 clknet_2_0__leaf_clk_regs genblk1\[1\].fa_inst.s 0.19478f
C7744 _080_ genblk1\[6\].fa_inst.a 0
C7745 _275_/a_1108_47# net17 0
C7746 genblk1\[3\].fa_inst.a _288_/a_193_47# 0.01866f
C7747 VPWR pmu_inst/dc_inst.x7.x10/a_27_47# 0.00212f
C7748 net4 _042_ 0
C7749 VPWR _053_ 0.72899f
C7750 net5 input25/a_75_212# 0.00552f
C7751 _303_/a_1108_47# clknet_2_3__leaf_clk_regs 0.00273f
C7752 _291_/a_448_47# net16 0
C7753 _022_ net25 0
C7754 _303_/a_27_47# _287_/a_27_47# 0
C7755 _276_/a_27_47# net36 0.0178f
C7756 _189_/a_129_47# genblk1\[11\].fa_inst.b 0
C7757 _293_/a_193_47# _278_/a_27_47# 0
C7758 net33 _106_ 0.00198f
C7759 net58 _072_ 0
C7760 _294_/a_193_47# net36 0
C7761 net5 _298_/a_27_47# 0
C7762 _098_ VPWR 0.38928f
C7763 hold1/a_391_47# _134_/a_47_47# 0
C7764 VPWR pmu_inst/dc_inst.x7.net10 0.00498f
C7765 s[14] VPWR 0.39807f
C7766 _100_ _098_ 0.0044f
C7767 VPWR _283_/a_651_413# 0.0015f
C7768 VPWR a[4] 0.3628f
C7769 VPWR _282_/a_448_47# 0.00167f
C7770 net5 b[7] 0
C7771 VPWR _279_/a_27_47# 0.05916f
C7772 net3 _281_/a_1108_47# 0
C7773 genblk1\[0\].fa_inst.b _288_/a_193_47# 0
C7774 _257_/a_1108_47# net57 0.01704f
C7775 clk _267_/a_1283_21# 0.00103f
C7776 _054_ _304_/a_761_289# 0
C7777 net28 genblk1\[8\].fa_inst.b 0.03556f
C7778 net23 net35 0.03771f
C7779 _271_/a_1283_21# fanout62/a_110_47# 0.01346f
C7780 _271_/a_193_47# net37 0
C7781 genblk1\[1\].fa_inst.b _055_ 0.07871f
C7782 _277_/a_193_47# genblk1\[5\].fa_inst.a 0
C7783 _271_/a_193_47# net45 0
C7784 VPWR pmu_inst/_15_/a_288_47# 0.00212f
C7785 _035_ _289_/a_1283_21# 0
C7786 _290_/a_1283_21# _034_ 0
C7787 net6 _280_/a_27_47# 0
C7788 VPWR input36/a_27_47# 0.13744f
C7789 a[15] b[0] 0.07915f
C7790 net3 net31 0.01702f
C7791 genblk1\[14\].fa_inst.s _105_ 0
C7792 net4 _038_ 0
C7793 _023_ _278_/a_1108_47# 0.00363f
C7794 net27 _296_/a_193_47# 0.01959f
C7795 _272_/a_1270_413# clknet_2_0__leaf_clk_regs 0
C7796 _272_/a_543_47# genblk1\[0\].fa_inst.a 0
C7797 _276_/a_761_289# _290_/a_1108_47# 0
C7798 _279_/a_1108_47# _024_ 0.00546f
C7799 _279_/a_761_289# genblk1\[7\].fa_inst.a 0
C7800 _196_/a_113_47# _110_ 0
C7801 clknet_0_clk_regs _264_/a_27_47# 0
C7802 clknet_2_2__leaf_clk_regs net59 0.08658f
C7803 VPWR net44 19.69723f
C7804 net17 net59 0
C7805 net3 _278_/a_1108_47# 0
C7806 _272_/a_651_413# net1 0.0016f
C7807 _272_/a_448_47# VPWR -0.00289f
C7808 genblk1\[10\].fa_inst.a genblk1\[9\].fa_inst.b 0.21853f
C7809 _302_/a_543_47# _047_ 0.00263f
C7810 _256_/a_27_47# _256_/a_761_289# -0
C7811 _290_/a_1270_413# net14 0
C7812 clknet_2_2__leaf_clk_regs _298_/a_27_47# 0.02606f
C7813 _302_/a_1108_47# net7 0.00597f
C7814 clknet_2_0__leaf_clk_regs _153_/a_27_413# 0
C7815 _301_/a_651_413# net19 0
C7816 genblk1\[3\].fa_inst.a _288_/a_1462_47# 0
C7817 _276_/a_193_47# a[8] 0
C7818 genblk1\[6\].fa_inst.s _075_ 0.00175f
C7819 cin_q _304_/a_639_47# 0
C7820 VPWR _073_ 0.47325f
C7821 b[7] clknet_2_2__leaf_clk_regs 0
C7822 _148_/a_298_297# _065_ 0
C7823 net33 _041_ 0
C7824 _036_ net16 0
C7825 _261_/a_1283_21# _260_/a_1283_21# 0
C7826 _261_/a_761_289# _260_/a_448_47# 0
C7827 _270_/a_448_47# net61 0
C7828 _303_/a_1283_21# _287_/a_651_413# 0
C7829 _097_ _193_/a_382_47# 0.0017f
C7830 _292_/a_448_47# net4 0
C7831 net62 _024_ 0.22141f
C7832 net5 input24/a_27_47# 0.00546f
C7833 net14 net36 0.02708f
C7834 fanout60/a_27_47# net61 0.02979f
C7835 _274_/a_193_47# _273_/a_543_47# 0.00175f
C7836 _274_/a_761_289# _273_/a_761_289# 0
C7837 _274_/a_543_47# _273_/a_193_47# 0
C7838 _274_/a_1283_21# _273_/a_27_47# 0
C7839 net28 net58 0
C7840 net29 net36 0.02773f
C7841 VPWR _174_/a_47_47# 0.05363f
C7842 VPWR _027_ 0.06312f
C7843 _301_/a_193_47# net35 0
C7844 net5 net13 0.00349f
C7845 net39 pmu_inst/dc_inst.x4.net8 0.01693f
C7846 genblk1\[2\].fa_inst.s _060_ 0.00145f
C7847 VPWR _279_/a_1217_47# 0
C7848 _265_/a_193_47# genblk1\[10\].fa_inst.s 0.00599f
C7849 _271_/a_27_47# _271_/a_193_47# -0.05034f
C7850 VPWR pmu_inst/dc_inst.x4.x16/a_27_47# 0
C7851 VPWR pmu_inst/dc_inst.x5.x5/a_27_47# 0
C7852 _256_/a_193_47# VPWR 0.02407f
C7853 genblk1\[2\].fa_inst.s net57 0.00225f
C7854 net27 _281_/a_193_47# 0.02463f
C7855 _302_/a_805_47# VPWR 0
C7856 _061_ net36 0.07378f
C7857 net13 _278_/a_1283_21# 0
C7858 VPWR input7/a_27_47# 0.0923f
C7859 genblk1\[11\].fa_inst.a _090_ 0.00463f
C7860 _179_/a_47_47# genblk1\[10\].fa_inst.s 0.00112f
C7861 _303_/a_761_289# net34 0.01847f
C7862 _271_/a_1462_47# net37 0
C7863 _051_ _288_/a_1108_47# 0
C7864 net28 _282_/a_1108_47# 0.00173f
C7865 _129_/a_47_47# _134_/a_47_47# 0.01239f
C7866 _258_/a_448_47# clknet_2_0__leaf_clk_regs 0.00338f
C7867 net25 net24 4.44744f
C7868 genblk1\[12\].fa_inst.s _187_/a_113_47# 0
C7869 _189_/a_285_47# _099_ 0.00424f
C7870 _293_/a_1270_413# genblk1\[6\].fa_inst.a 0
C7871 _106_ _195_/a_150_297# 0
C7872 net39 pmu_inst/dc_inst.x2.x2/a_27_47# 0.0034f
C7873 net2 _282_/a_448_47# 0.00231f
C7874 _258_/a_1283_21# VPWR 0.03454f
C7875 net2 _279_/a_27_47# 0.02216f
C7876 net52 _007_ 0.04879f
C7877 _139_/a_129_47# _060_ 0
C7878 _277_/a_27_47# _036_ 0
C7879 net34 _109_ 0
C7880 _276_/a_651_413# _290_/a_1283_21# 0
C7881 net33 _026_ 0
C7882 _097_ _104_ 0
C7883 net46 pmu_inst/dc_inst.x5.net14 0
C7884 _084_ _078_ 0
C7885 _017_ VPWR -0.0029f
C7886 genblk1\[7\].fa_inst.s _262_/a_761_289# 0
C7887 net6 _282_/a_193_47# 0
C7888 _131_/a_68_297# _304_/a_448_47# 0
C7889 VPWR _136_/a_68_297# 0.02238f
C7890 net27 _278_/a_193_47# 0.0291f
C7891 VPWR _198_/a_382_47# -0
C7892 _303_/a_27_47# net36 0.03819f
C7893 _262_/a_1108_47# net62 0.0011f
C7894 net46 pmu_inst/_15_/a_600_345# 0
C7895 _022_ clknet_2_1__leaf_clk_regs 0
C7896 _100_ VPWR 0.61561f
C7897 genblk1\[11\].fa_inst.b _299_/a_27_47# 0
C7898 net39 pmu_inst/dc_inst.net1 0
C7899 cin_q _139_/a_47_47# 0
C7900 genblk1\[15\].fa_inst.a _204_/a_33_297# 0
C7901 _006_ _260_/a_761_289# 0
C7902 net59 _297_/a_27_47# 0.00773f
C7903 _015_ net61 0.19306f
C7904 net35 net50 0.02646f
C7905 genblk1\[12\].fa_inst.b _300_/a_651_413# 0
C7906 genblk1\[5\].fa_inst.a _150_/a_150_297# 0
C7907 _110_ _204_/a_225_47# 0.00137f
C7908 _205_/a_285_47# _111_ 0
C7909 _092_ _170_/a_68_297# 0
C7910 VPWR input8/a_75_212# 0.00489f
C7911 _274_/a_27_47# clknet_2_1__leaf_clk_regs 0.04339f
C7912 _079_ _075_ 0
C7913 _275_/a_761_289# net56 0
C7914 _291_/a_761_289# net26 0
C7915 _291_/a_193_47# _036_ 0.00571f
C7916 clknet_2_1__leaf_clk_regs genblk1\[5\].fa_inst.b 0.05859f
C7917 genblk1\[8\].fa_inst.s _263_/a_448_47# 0.00196f
C7918 _265_/a_1108_47# _010_ 0.00818f
C7919 _265_/a_761_289# net40 0
C7920 _094_ _093_ 0.34971f
C7921 _255_/a_1108_47# net39 0.00221f
C7922 _255_/a_639_47# genblk1\[0\].fa_inst.s 0.00114f
C7923 _258_/a_761_289# _003_ 0.01435f
C7924 _265_/a_1462_47# genblk1\[10\].fa_inst.s 0
C7925 _271_/a_761_289# clknet_2_3__leaf_clk_regs 0
C7926 _256_/a_1462_47# VPWR 0
C7927 genblk1\[15\].fa_inst.a _109_ 0.13813f
C7928 net12 a[6] 0
C7929 output49/a_27_47# s[4] 0.01008f
C7930 clknet_2_1__leaf_clk_regs _289_/a_1108_47# 0
C7931 net49 clknet_1_0__leaf_clk 0.04776f
C7932 genblk1\[6\].fa_inst.b _080_ 0.00977f
C7933 net28 _028_ 0.00165f
C7934 _291_/a_651_413# net56 0.00195f
C7935 genblk1\[8\].fa_inst.b _296_/a_193_47# 0
C7936 _304_/a_27_47# _304_/a_193_47# -0.32207f
C7937 _003_ clknet_2_0__leaf_clk_regs 0.02792f
C7938 genblk1\[12\].fa_inst.s _267_/a_639_47# 0
C7939 net46 pmu_inst/dc_inst.x4.net19 0
C7940 net2 _027_ 0
C7941 _268_/a_27_47# clknet_2_3__leaf_clk_regs 0.16974f
C7942 cout_next pmu_inst/_15_/a_788_316# 0
C7943 _293_/a_651_413# genblk1\[6\].fa_inst.a 0
C7944 _281_/a_1108_47# _295_/a_1283_21# 0
C7945 _281_/a_1283_21# _295_/a_1108_47# 0
C7946 net3 _297_/a_193_47# 0.02623f
C7947 output42/a_27_47# s[13] 0
C7948 _039_ _280_/a_543_47# 0.0012f
C7949 _276_/a_805_47# VPWR 0
C7950 genblk1\[4\].fa_inst.s net36 0.00324f
C7951 _256_/a_651_413# _001_ 0.00442f
C7952 _256_/a_1283_21# net46 0.00891f
C7953 VPWR pmu_inst/dc_inst.net3 0.00265f
C7954 clknet_0_clk_regs net41 0.00377f
C7955 _274_/a_27_47# net11 0
C7956 _294_/a_1283_21# _280_/a_1283_21# 0
C7957 net61 _265_/a_761_289# 0
C7958 _268_/a_761_289# net60 0
C7959 _296_/a_543_47# _040_ 0
C7960 _187_/a_113_47# _093_ 0
C7961 net46 net68 0
C7962 input3/a_27_47# net15 0.01573f
C7963 VPWR _285_/a_193_47# -0.05039f
C7964 genblk1\[11\].fa_inst.b _299_/a_1217_47# 0
C7965 genblk1\[1\].fa_inst.a net10 0
C7966 _276_/a_193_47# _290_/a_543_47# 0.00564f
C7967 _021_ _291_/a_193_47# 0
C7968 _292_/a_651_413# _277_/a_543_47# 0
C7969 _169_/a_47_47# _084_ 0.03055f
C7970 _260_/a_1283_21# genblk1\[5\].fa_inst.s 0
C7971 net59 _297_/a_1217_47# 0
C7972 genblk1\[4\].fa_inst.a _140_/a_68_297# 0.00253f
C7973 VPWR pmu_inst_64/HI 0.05234f
C7974 _289_/a_1108_47# net11 0.0085f
C7975 _304_/a_1283_21# net56 0.07308f
C7976 _290_/a_805_47# net12 0
C7977 net44 genblk1\[14\].fa_inst.s 0
C7978 clknet_0_clk_regs _263_/a_761_289# 0
C7979 net47 pmu_inst/dc_inst.x7.net15 0.00304f
C7980 _266_/a_193_47# net62 0
C7981 _274_/a_448_47# genblk1\[1\].fa_inst.a 0
C7982 genblk1\[2\].fa_inst.a genblk1\[2\].fa_inst.b 0.21451f
C7983 VPWR net2 2.22336f
C7984 _291_/a_1462_47# _036_ 0
C7985 net29 _280_/a_639_47# 0.00162f
C7986 genblk1\[8\].fa_inst.s _008_ 0.00425f
C7987 net33 _180_/a_68_297# 0
C7988 genblk1\[4\].fa_inst.b net16 0
C7989 genblk1\[0\].fa_inst.s net39 0
C7990 _258_/a_805_47# net48 0
C7991 _271_/a_543_47# net38 0
C7992 _271_/a_448_47# _016_ 0
C7993 _300_/a_27_47# net7 0.03851f
C7994 _273_/a_193_47# net9 0.00926f
C7995 net5 _280_/a_193_47# 0
C7996 _075_ _073_ 0.08891f
C7997 input33/a_27_47# input36/a_27_47# 0.00855f
C7998 _285_/a_651_413# net7 0.00692f
C7999 clknet_2_1__leaf_clk_regs net24 0.2633f
C8000 _160_/a_68_297# genblk1\[6\].fa_inst.a 0
C8001 VPWR input6/a_27_47# 0.092f
C8002 _294_/a_193_47# _279_/a_1283_21# 0
C8003 _302_/a_27_47# _286_/a_27_47# 0
C8004 _267_/a_27_47# clknet_2_3__leaf_clk_regs 0.22233f
C8005 _163_/a_27_413# _077_ 0
C8006 net29 _283_/a_27_47# 0.02023f
C8007 genblk1\[12\].fa_inst.s net42 0
C8008 net60 _299_/a_805_47# 0
C8009 _282_/a_1108_47# _296_/a_193_47# 0
C8010 _282_/a_27_47# _296_/a_448_47# 0
C8011 _282_/a_543_47# _296_/a_543_47# 0.00106f
C8012 _282_/a_193_47# _296_/a_1108_47# 0
C8013 clknet_0_clk net51 0
C8014 _276_/a_761_289# clknet_2_1__leaf_clk_regs 0
C8015 net16 _295_/a_193_47# 0.00716f
C8016 _287_/a_27_47# net60 0.03809f
C8017 _268_/a_1217_47# clknet_2_3__leaf_clk_regs 0
C8018 b[9] b[10] 0.07915f
C8019 net33 genblk1\[11\].fa_inst.b 0.04946f
C8020 VPWR pmu_inst/dc_inst.x2.net17 0.01107f
C8021 _026_ _295_/a_543_47# 0
C8022 _281_/a_543_47# _040_ 0.0012f
C8023 _281_/a_1283_21# net30 0.00103f
C8024 genblk1\[3\].fa_inst.a _304_/a_193_47# 0.01505f
C8025 net17 _295_/a_1108_47# 0
C8026 _149_/a_377_297# _068_ 0.00143f
C8027 _267_/a_761_289# net60 0
C8028 _293_/a_761_289# genblk1\[7\].fa_inst.a 0
C8029 VPWR _284_/a_193_47# -0.28067f
C8030 net26 b[2] 0
C8031 _275_/a_805_47# genblk1\[3\].fa_inst.a 0
C8032 _291_/a_651_413# _290_/a_193_47# 0
C8033 VPWR input35/a_27_47# 0.08392f
C8034 _300_/a_1108_47# VPWR 0.06228f
C8035 clknet_0_clk_regs _005_ 0.05688f
C8036 VPWR pmu_inst/dc_inst.x1.net5 0.01096f
C8037 _294_/a_1283_21# net58 0.00758f
C8038 net33 _299_/a_761_289# 0
C8039 net47 pmu_inst/_24_/a_651_413# 0
C8040 _096_ _182_/a_113_47# 0
C8041 _268_/a_761_289# _013_ 0.00222f
C8042 VPWR _285_/a_1462_47# 0
C8043 net46 pmu_inst/dc_inst.x6.x10/a_27_47# 0.00651f
C8044 net5 net30 0.0372f
C8045 VPWR net71 0.31672f
C8046 net17 _280_/a_193_47# 0
C8047 net46 pmu_inst/dc_inst.x2.net4 0
C8048 _159_/a_47_47# genblk1\[6\].fa_inst.s 0.00719f
C8049 _199_/a_47_47# _102_ 0
C8050 _180_/a_68_297# net35 0.02211f
C8051 net24 net11 0
C8052 net24 _279_/a_193_47# 0
C8053 VPWR _262_/a_651_413# 0
C8054 net61 net60 0.04469f
C8055 _291_/a_27_47# net36 0.01558f
C8056 genblk1\[2\].fa_inst.s _304_/a_193_47# 0
C8057 net61 _268_/a_448_47# 0
C8058 genblk1\[2\].fa_inst.a _018_ 0
C8059 _019_ genblk1\[1\].fa_inst.a 0.04355f
C8060 _199_/a_129_47# _108_ -0.00111f
C8061 net7 _284_/a_651_413# 0.00348f
C8062 net29 genblk1\[8\].fa_inst.a 0
C8063 genblk1\[0\].fa_inst.s _055_ 0
C8064 _130_/a_215_297# _134_/a_47_47# 0.00145f
C8065 _276_/a_761_289# net11 0.00133f
C8066 _259_/a_193_47# genblk1\[4\].fa_inst.s 0.05886f
C8067 _168_/a_215_297# _164_/a_47_47# 0
C8068 s[9] VPWR 0.37243f
C8069 _287_/a_639_47# clknet_2_3__leaf_clk_regs 0
C8070 VPWR genblk1\[14\].fa_inst.s 1.87593f
C8071 _273_/a_1462_47# net9 0
C8072 VPWR _075_ 0.07907f
C8073 net46 pmu_inst/dc_inst.x5.x6/a_27_47# 0.0066f
C8074 _304_/a_1283_21# _055_ 0.00733f
C8075 genblk1\[10\].fa_inst.b _298_/a_1270_413# 0
C8076 _287_/a_193_47# _287_/a_543_47# -0.00424f
C8077 genblk1\[11\].fa_inst.b net35 0.09255f
C8078 _274_/a_543_47# clknet_2_0__leaf_clk_regs 0.03345f
C8079 VPWR pmu_inst/dc_inst.x4.net6 0
C8080 VPWR _266_/a_448_47# -0
C8081 net46 pmu_inst/_17_/a_27_93# 0
C8082 _274_/a_193_47# VPWR 0.01197f
C8083 _304_/a_651_413# net33 0
C8084 net58 _278_/a_193_47# 0.02887f
C8085 net33 net59 0.08914f
C8086 VPWR _069_ 0.41784f
C8087 _282_/a_27_47# _041_ 0
C8088 _027_ _296_/a_27_47# 0
C8089 _282_/a_193_47# net31 0.03255f
C8090 net3 _023_ 0.02442f
C8091 _287_/a_1217_47# net60 0
C8092 net70 pmu_inst/dc_inst.x6.net6 0
C8093 _072_ genblk1\[5\].fa_inst.b 0
C8094 _293_/a_805_47# clknet_2_1__leaf_clk_regs 0.00209f
C8095 clknet_2_2__leaf_clk_regs net30 0.04587f
C8096 net17 net30 0
C8097 VPWR pmu_inst/dc_inst.x4.net2 0.0152f
C8098 genblk1\[13\].fa_inst.a _191_/a_113_47# 0
C8099 clknet_2_3__leaf_clk_regs net34 0.08488f
C8100 VPWR _289_/a_448_47# 0
C8101 _292_/a_193_47# net3 0
C8102 _279_/a_27_47# _278_/a_27_47# 0.00298f
C8103 _293_/a_543_47# genblk1\[7\].fa_inst.a 0
C8104 _302_/a_448_47# genblk1\[14\].fa_inst.b 0
C8105 VPWR _284_/a_1462_47# 0.00209f
C8106 _292_/a_27_47# _292_/a_761_289# -0.01198f
C8107 _076_ _154_/a_47_47# 0
C8108 clknet_2_2__leaf_clk_regs _088_ 0.03913f
C8109 _272_/a_448_47# _288_/a_193_47# 0
C8110 _257_/a_448_47# genblk1\[2\].fa_inst.s 0.00158f
C8111 _257_/a_761_289# net47 0
C8112 _257_/a_1108_47# _002_ 0.02078f
C8113 _291_/a_761_289# _035_ 0
C8114 _259_/a_1108_47# net36 0.00283f
C8115 _178_/a_27_413# _092_ 0
C8116 _096_ genblk1\[10\].fa_inst.b 0
C8117 VPWR input33/a_27_47# 0.10192f
C8118 net20 VPWR 1.3035f
C8119 _300_/a_193_47# _285_/a_1108_47# 0
C8120 _300_/a_543_47# _285_/a_543_47# 0
C8121 _300_/a_761_289# _285_/a_1283_21# 0
C8122 net26 b[1] 0
C8123 _108_ genblk1\[13\].fa_inst.b 0
C8124 net47 pmu_inst/_25_/a_1270_413# 0
C8125 _259_/a_27_47# _003_ 0
C8126 b[13] net36 0
C8127 net47 pmu_inst/dc_inst.x8/a_27_47# 0
C8128 _268_/a_805_47# net43 0
C8129 net47 pmu_inst/dc_inst.x9/a_247_21# 0.00263f
C8130 net4 _279_/a_27_47# 0.03631f
C8131 net4 _282_/a_448_47# 0.01244f
C8132 clknet_2_3__leaf_clk_regs _043_ 0
C8133 VPWR _286_/a_193_47# 0.01181f
C8134 net17 _280_/a_1462_47# 0
C8135 net61 _267_/a_448_47# 0
C8136 clknet_2_1__leaf_clk_regs _278_/a_805_47# 0.00214f
C8137 _294_/a_27_47# net36 0
C8138 pmu_inst/_17_/a_174_21# cout_next 0
C8139 fanout56/a_27_47# net17 0.00659f
C8140 _302_/a_1283_21# _301_/a_193_47# 0
C8141 _302_/a_1108_47# _301_/a_27_47# 0
C8142 VPWR pmu_inst/dc_inst.x5.x2/a_27_47# 0
C8143 _291_/a_1217_47# net36 0
C8144 _277_/a_651_413# VPWR 0.00131f
C8145 _294_/a_1108_47# _279_/a_1108_47# 0
C8146 VPWR _296_/a_27_47# 0.08883f
C8147 _043_ net32 0
C8148 net61 _013_ 0.06833f
C8149 genblk1\[4\].fa_inst.a _146_/a_113_47# 0
C8150 _054_ _135_/a_298_297# 0.01401f
C8151 _283_/a_543_47# clknet_2_2__leaf_clk_regs 0
C8152 VPWR _196_/a_113_47# -0
C8153 net25 net15 0.02497f
C8154 VPWR _140_/a_68_297# 0.02173f
C8155 _080_ _173_/a_298_297# 0
C8156 _282_/a_761_289# clknet_2_2__leaf_clk_regs 0
C8157 net59 net35 0.05091f
C8158 clknet_2_0__leaf_clk_regs _260_/a_1108_47# 0
C8159 _300_/a_27_47# net6 0
C8160 net36 net56 0.08942f
C8161 net35 _298_/a_27_47# 0
C8162 net60 net36 0
C8163 clknet_2_3__leaf_clk_regs genblk1\[15\].fa_inst.s 0.17586f
C8164 _199_/a_47_47# cout_next 0
C8165 _189_/a_47_47# genblk1\[12\].fa_inst.b 0
C8166 VPWR _011_ 0.04184f
C8167 VPWR _260_/a_543_47# 0.02202f
C8168 _274_/a_1462_47# VPWR 0
C8169 net58 _278_/a_1462_47# 0
C8170 net27 net26 0
C8171 _275_/a_193_47# _273_/a_193_47# 0
C8172 _294_/a_1108_47# net62 0.01053f
C8173 _007_ _262_/a_1283_21# 0.04922f
C8174 net39 pmu_inst/dc_inst.x5.net9 0.00532f
C8175 genblk1\[1\].fa_inst.a _033_ 0
C8176 _054_ genblk1\[1\].fa_inst.s 0
C8177 net7 _296_/a_448_47# 0.0044f
C8178 VPWR b[5] 0.23765f
C8179 _183_/a_382_47# _096_ 0.00102f
C8180 net47 pmu_inst/_14_/a_535_374# 0
C8181 _298_/a_543_47# _043_ 0
C8182 _298_/a_1283_21# net18 0
C8183 _200_/a_145_75# genblk1\[15\].fa_inst.b 0.00121f
C8184 _199_/a_47_47# _107_ 0.03015f
C8185 genblk1\[0\].fa_inst.b _050_ 0.03562f
C8186 VPWR _034_ 0.06628f
C8187 net28 genblk1\[5\].fa_inst.b 0
C8188 _179_/a_285_47# _089_ 0
C8189 _047_ genblk1\[14\].fa_inst.b 0.00575f
C8190 b[14] net36 0
C8191 genblk1\[2\].fa_inst.s _050_ 0.00202f
C8192 clknet_2_0__leaf_clk_regs _288_/a_543_47# 0.00393f
C8193 _017_ _288_/a_193_47# 0
C8194 VPWR net65 0.51236f
C8195 genblk1\[2\].fa_inst.s _002_ 0
C8196 _294_/a_761_289# genblk1\[6\].fa_inst.b 0
C8197 _300_/a_27_47# _030_ 0
C8198 net20 _285_/a_193_47# 0
C8199 _045_ _285_/a_27_47# 0
C8200 net39 pmu_inst/dc_inst.x6.net7 0.01497f
C8201 _127_/a_113_47# genblk1\[0\].fa_inst.b 0
C8202 net46 pmu_inst/dc_inst.x7.net9 0
C8203 net47 pmu_inst/clkload0/a_27_47# 0.00276f
C8204 genblk1\[5\].fa_inst.a net12 0
C8205 net36 _298_/a_193_47# 0
C8206 net46 pmu_inst/dc_inst.x2.net5 0
C8207 clkbuf_2_1__f_clk_regs/a_110_47# _261_/a_543_47# 0
C8208 clknet_2_1__leaf_clk_regs _076_ 0.03022f
C8209 VPWR _281_/a_27_47# 0.05826f
C8210 _108_ _201_/a_61_47# 0.00275f
C8211 _266_/a_27_47# _266_/a_193_47# -0.05244f
C8212 VPWR _288_/a_193_47# 0.04862f
C8213 net47 pmu_inst/dc_inst.net2 0.00457f
C8214 genblk1\[4\].fa_inst.a _066_ 0.00841f
C8215 _039_ genblk1\[7\].fa_inst.a 0
C8216 _285_/a_1283_21# genblk1\[13\].fa_inst.a 0.00292f
C8217 net47 pmu_inst/_13_/a_27_297# 0.00312f
C8218 genblk1\[6\].fa_inst.b _160_/a_68_297# 0
C8219 net4 _027_ 0
C8220 _297_/a_27_47# net30 0.02678f
C8221 VPWR _286_/a_1462_47# 0
C8222 pmu_inst/dc_inst.x1.net6 cout_next 0
C8223 _270_/a_1108_47# net62 0.00126f
C8224 net61 _012_ 0.04577f
C8225 VPWR b[10] 0.23762f
C8226 _302_/a_27_47# net21 0.03896f
C8227 net22 _301_/a_27_47# 0
C8228 _262_/a_761_289# _262_/a_193_47# -0.0089f
C8229 VPWR _296_/a_1217_47# 0
C8230 _301_/a_193_47# net7 0.02263f
C8231 _108_ genblk1\[14\].fa_inst.b 0
C8232 net62 net50 0.03133f
C8233 genblk1\[2\].fa_inst.s _139_/a_285_47# 0.00619f
C8234 _277_/a_543_47# clknet_2_1__leaf_clk_regs 0
C8235 _158_/a_27_413# _073_ 0
C8236 _162_/a_113_47# _077_ 0
C8237 _256_/a_193_47# net57 0.01023f
C8238 net47 pmu_inst/dc_inst.x3.x3/a_27_47# 0.00264f
C8239 genblk1\[4\].fa_inst.b _068_ 0
C8240 VPWR _278_/a_27_47# 0.04066f
C8241 _302_/a_448_47# clknet_2_2__leaf_clk_regs 0.01417f
C8242 net39 pmu_inst/dc_inst.x2.x9/a_27_47# -0
C8243 _287_/a_448_47# genblk1\[15\].fa_inst.a 0
C8244 net59 _295_/a_543_47# 0.0015f
C8245 genblk1\[12\].fa_inst.s _098_ 0
C8246 net2 _296_/a_27_47# 0.03551f
C8247 net39 pmu_inst/dc_inst.x5.x3/a_27_47# -0
C8248 clknet_0_clk_regs _265_/a_639_47# 0
C8249 clknet_2_0__leaf_clk_regs net9 0.02969f
C8250 _159_/a_47_47# _073_ 0.01566f
C8251 _258_/a_1283_21# net57 0.00382f
C8252 _283_/a_193_47# _297_/a_761_289# 0
C8253 _283_/a_27_47# _297_/a_543_47# 0
C8254 _283_/a_543_47# _297_/a_27_47# 0
C8255 net7 _041_ 0.00112f
C8256 _282_/a_193_47# _297_/a_193_47# 0.00128f
C8257 _282_/a_27_47# _297_/a_761_289# 0
C8258 VPWR net4 2.36783f
C8259 _255_/a_27_47# genblk1\[1\].fa_inst.s 0
C8260 VPWR pmu_inst/dc_inst.x6.x11/a_27_47# 0
C8261 _280_/a_448_47# net15 0.00196f
C8262 _301_/a_448_47# VPWR 0.00219f
C8263 _194_/a_47_47# _104_ 0.0289f
C8264 _131_/a_68_297# genblk1\[1\].fa_inst.a 0.0668f
C8265 _291_/a_543_47# clknet_2_1__leaf_clk_regs 0.002f
C8266 _290_/a_193_47# net36 0.00403f
C8267 VPWR _204_/a_225_47# -0.00195f
C8268 _300_/a_1283_21# _045_ 0.05555f
C8269 _300_/a_1108_47# net20 0
C8270 _292_/a_1283_21# genblk1\[4\].fa_inst.b 0.00127f
C8271 _303_/a_1283_21# VPWR 0.02397f
C8272 VPWR _060_ 0.28365f
C8273 _004_ clknet_2_0__leaf_clk_regs 0.00522f
C8274 VPWR net57 2.85372f
C8275 _269_/a_27_47# clknet_2_3__leaf_clk_regs 0.03813f
C8276 _274_/a_27_47# input10/a_75_212# 0
C8277 _277_/a_1283_21# net36 0
C8278 _276_/a_651_413# VPWR 0
C8279 VPWR _281_/a_1217_47# 0
C8280 VPWR _288_/a_1462_47# 0
C8281 _129_/a_129_47# _052_ 0
C8282 _297_/a_1217_47# net30 0
C8283 cin_q clknet_2_0__leaf_clk_regs 0.11396f
C8284 _186_/a_113_47# genblk1\[11\].fa_inst.b 0
C8285 net39 pmu_inst/dc_inst.x2.net9 0.00106f
C8286 net39 pmu_inst/dc_inst.x5.net1 0.00604f
C8287 _274_/a_27_47# _274_/a_761_289# -0.01661f
C8288 _185_/a_68_297# genblk1\[11\].fa_inst.b 0.02469f
C8289 _276_/a_543_47# net12 0
C8290 _291_/a_1108_47# net58 0
C8291 _149_/a_47_47# genblk1\[5\].fa_inst.s 0
C8292 VPWR _158_/a_27_413# 0.03057f
C8293 net2 _281_/a_27_47# 0.02604f
C8294 _269_/a_1283_21# _268_/a_1283_21# 0
C8295 _269_/a_543_47# _268_/a_1108_47# 0
C8296 _269_/a_193_47# _268_/a_651_413# 0
C8297 _269_/a_651_413# _268_/a_193_47# 0
C8298 pmu_inst/dc_inst.x5.x2/a_27_47# net71 0
C8299 net27 _294_/a_761_289# 0.01315f
C8300 clk _262_/a_1108_47# 0.06062f
C8301 clknet_2_1__leaf_clk_regs net15 0.11327f
C8302 clknet_2_2__leaf_clk_regs _087_ 0.34354f
C8303 a[15] net16 0
C8304 _256_/a_1462_47# net57 0
C8305 net26 input26/a_75_212# 0.00211f
C8306 net56 _134_/a_47_47# 0
C8307 VPWR _278_/a_1217_47# 0
C8308 _047_ clknet_2_2__leaf_clk_regs 0
C8309 net46 pmu_inst/dc_inst.x6.x1/a_27_47# 0.00145f
C8310 net3 _280_/a_27_47# 0.02006f
C8311 net7 _026_ 0.02627f
C8312 _032_ genblk1\[15\].fa_inst.a 0.00161f
C8313 net47 output48/a_27_47# 0
C8314 _290_/a_1283_21# net25 0
C8315 _290_/a_543_47# _035_ 0.00131f
C8316 _146_/a_113_47# VPWR -0
C8317 _068_ _154_/a_129_47# 0
C8318 _185_/a_150_297# _299_/a_193_47# 0
C8319 VPWR _159_/a_47_47# 0.03294f
C8320 genblk1\[15\].fa_inst.a _112_ 0
C8321 clknet_0_clk_regs net40 0.03926f
C8322 _275_/a_639_47# clknet_2_1__leaf_clk_regs 0
C8323 _275_/a_1283_21# genblk1\[1\].fa_inst.a 0.00668f
C8324 genblk1\[3\].fa_inst.a _273_/a_1283_21# 0
C8325 _293_/a_27_47# _278_/a_1283_21# 0
C8326 clkload2/X VPWR 0.01633f
C8327 _167_/a_113_47# _088_ 0
C8328 _301_/a_27_47# _300_/a_27_47# 0
C8329 _025_ net15 0.00426f
C8330 _112_ genblk1\[15\].fa_inst.s 0.00114f
C8331 _108_ _111_ 0
C8332 _284_/a_1283_21# genblk1\[12\].fa_inst.a 0.00292f
C8333 net2 _278_/a_27_47# 0.02128f
C8334 _264_/a_805_47# _009_ 0
C8335 _199_/a_285_47# _106_ 0
C8336 _046_ VPWR 0.05641f
C8337 VPWR _170_/a_68_297# 0.03669f
C8338 _290_/a_1462_47# net36 0
C8339 VPWR _070_ 0.11171f
C8340 _052_ _128_/a_113_47# 0
C8341 _049_ _143_/a_27_413# 0
C8342 net33 _143_/a_215_297# 0
C8343 _149_/a_47_47# net58 0
C8344 b[2] b[3] 0.06434f
C8345 _265_/a_193_47# net62 0
C8346 _098_ _093_ 0
C8347 net17 _058_ 0
C8348 _269_/a_1217_47# clknet_2_3__leaf_clk_regs 0
C8349 net20 _286_/a_193_47# 0.0072f
C8350 _300_/a_27_47# _031_ 0.00186f
C8351 _274_/a_651_413# net10 0
C8352 _068_ _144_/a_47_47# 0
C8353 _148_/a_382_47# _063_ 0
C8354 _271_/a_193_47# net44 0.54888f
C8355 _266_/a_543_47# net41 0
C8356 net15 _279_/a_193_47# 0
C8357 net2 net4 3.27159f
C8358 net37 rst 0.05672f
C8359 _097_ _094_ 0
C8360 _169_/a_129_47# genblk1\[8\].fa_inst.s 0
C8361 genblk1\[14\].fa_inst.a _285_/a_1283_21# 0
C8362 _065_ _072_ 0.00266f
C8363 _283_/a_193_47# net59 0.00114f
C8364 _256_/a_193_47# _255_/a_761_289# 0
C8365 _256_/a_27_47# _255_/a_543_47# 0.00244f
C8366 _256_/a_543_47# _255_/a_27_47# 0
C8367 _160_/a_150_297# _077_ 0
C8368 net27 _295_/a_27_47# 0.01592f
C8369 _282_/a_27_47# net59 0.01578f
C8370 net28 _293_/a_805_47# 0
C8371 net61 clknet_0_clk_regs 1.12272f
C8372 _293_/a_27_47# net17 0.04054f
C8373 _283_/a_27_47# _298_/a_193_47# 0
C8374 _283_/a_193_47# _298_/a_27_47# 0
C8375 _199_/a_47_47# _204_/a_33_297# 0
C8376 input2/a_27_47# a[9] 0
C8377 _066_ VPWR 0.18131f
C8378 _184_/a_377_297# clknet_2_3__leaf_clk_regs 0.00379f
C8379 genblk1\[12\].fa_inst.s VPWR 0.32992f
C8380 genblk1\[12\].fa_inst.s _100_ 0.0064f
C8381 _285_/a_651_413# net31 0
C8382 _275_/a_639_47# net11 0
C8383 net26 net58 0.00912f
C8384 _014_ _268_/a_761_289# 0
C8385 _269_/a_761_289# _013_ 0
C8386 _293_/a_193_47# clknet_2_1__leaf_clk_regs 0.02704f
C8387 _076_ _072_ 0.00678f
C8388 _290_/a_761_289# genblk1\[2\].fa_inst.b 0
C8389 clk _264_/a_543_47# 0.01546f
C8390 _270_/a_193_47# cout_next 0
C8391 _304_/a_761_289# _057_ 0
C8392 net47 pmu_inst/dc_inst.x7.net2 0.00328f
C8393 net61 _269_/a_448_47# 0
C8394 net4 _284_/a_193_47# 0.04352f
C8395 _302_/a_193_47# clknet_2_3__leaf_clk_regs 0.01596f
C8396 clk _266_/a_193_47# 0.04216f
C8397 clknet_2_1__leaf_clk_regs _038_ 0.42471f
C8398 _298_/a_639_47# net30 0.0017f
C8399 _255_/a_761_289# VPWR 0.01119f
C8400 _289_/a_543_47# genblk1\[1\].fa_inst.b 0
C8401 _188_/a_27_413# _094_ 0.01921f
C8402 genblk1\[3\].fa_inst.b genblk1\[5\].fa_inst.a 0.00192f
C8403 _134_/a_47_47# _055_ 0.0065f
C8404 _027_ _297_/a_651_413# 0
C8405 net3 _283_/a_761_289# 0.01993f
C8406 net3 _282_/a_193_47# 0.02207f
C8407 b[15] net23 0.00225f
C8408 output47/a_27_47# s[2] 0.01008f
C8409 genblk1\[7\].fa_inst.b _295_/a_761_289# 0
C8410 net7 _297_/a_761_289# 0
C8411 _301_/a_761_289# genblk1\[13\].fa_inst.b 0
C8412 _275_/a_193_47# clknet_2_0__leaf_clk_regs 0
C8413 _144_/a_47_47# _139_/a_47_47# 0
C8414 _302_/a_543_47# net60 0.00526f
C8415 _300_/a_193_47# clknet_2_2__leaf_clk_regs 0.00481f
C8416 _292_/a_193_47# genblk1\[5\].fa_inst.a 0
C8417 net20 _286_/a_1462_47# 0
C8418 _050_ _135_/a_27_413# 0
C8419 _293_/a_1217_47# clknet_2_1__leaf_clk_regs 0
C8420 _261_/a_761_289# net51 0
C8421 _261_/a_448_47# genblk1\[6\].fa_inst.s 0.0056f
C8422 _261_/a_1108_47# _006_ 0.00818f
C8423 _283_/a_1462_47# net59 0
C8424 net46 pmu_inst/dc_inst.x4.net8 0
C8425 _291_/a_1283_21# VPWR 0.01929f
C8426 VPWR _265_/a_448_47# 0
C8427 _143_/a_298_297# net36 0
C8428 _271_/a_193_47# VPWR -0.29525f
C8429 genblk1\[13\].fa_inst.a _193_/a_27_413# 0
C8430 _274_/a_1283_21# genblk1\[2\].fa_inst.a 0.0024f
C8431 _281_/a_27_47# _296_/a_27_47# 0
C8432 _272_/a_805_47# net56 0.00217f
C8433 net47 pmu_inst/dc_inst.x7.net11 0.00685f
C8434 _268_/a_1108_47# net62 0
C8435 net35 net30 0.00133f
C8436 VPWR _297_/a_651_413# 0.0015f
C8437 _057_ _132_/a_113_47# 0
C8438 _004_ _259_/a_27_47# -0
C8439 genblk1\[4\].fa_inst.s fanout57/a_27_47# 0
C8440 _165_/a_68_297# genblk1\[7\].fa_inst.b 0
C8441 clknet_2_2__leaf_clk_regs _264_/a_1283_21# 0
C8442 _083_ _173_/a_298_297# 0
C8443 _169_/a_285_47# _082_ 0
C8444 _091_ _090_ 0.16848f
C8445 a[14] net16 0
C8446 VPWR net63 0.27323f
C8447 net46 pmu_inst/dc_inst.x2.x2/a_27_47# 0
C8448 _290_/a_1283_21# clknet_2_1__leaf_clk_regs 0
C8449 _050_ _053_ 0.07131f
C8450 _294_/a_193_47# net5 0
C8451 genblk1\[11\].fa_inst.a clknet_2_3__leaf_clk_regs 0.02546f
C8452 VPWR pmu_inst/dc_inst.x1.net17 0.00196f
C8453 net27 _280_/a_651_413# 0
C8454 VPWR pmu_inst/dc_inst.x8/a_247_21# 0
C8455 net59 net62 0.00231f
C8456 _184_/a_47_47# _092_ 0
C8457 net61 _014_ 0.29955f
C8458 _127_/a_113_47# _053_ 0
C8459 _258_/a_27_47# _258_/a_761_289# -0
C8460 _292_/a_1270_413# net58 0
C8461 clk _266_/a_1462_47# 0
C8462 _194_/a_47_47# genblk1\[13\].fa_inst.s 0.00773f
C8463 _194_/a_129_47# _103_ 0
C8464 net7 _299_/a_761_289# 0
C8465 clknet_2_0__leaf_clk_regs _304_/a_543_47# 0.03356f
C8466 _161_/a_113_47# _077_ 0
C8467 _302_/a_651_413# _287_/a_27_47# 0
C8468 _302_/a_1283_21# _287_/a_543_47# 0.00158f
C8469 _301_/a_448_47# net20 0.00903f
C8470 _046_ _300_/a_1108_47# 0
C8471 _301_/a_1108_47# _045_ 0
C8472 _093_ VPWR 0.29179f
C8473 _100_ _093_ 0
C8474 _304_/a_193_47# _136_/a_68_297# 0
C8475 net39 pmu_inst/dc_inst.x1.x11/a_27_47# 0.00826f
C8476 _258_/a_27_47# clknet_2_0__leaf_clk_regs 0.03125f
C8477 net3 _279_/a_448_47# 0
C8478 fanout58/a_27_47# net62 0.06842f
C8479 _304_/a_193_47# VPWR -0.01983f
C8480 _280_/a_193_47# _295_/a_543_47# 0
C8481 net36 _040_ 0
C8482 _280_/a_543_47# _295_/a_193_47# 0
C8483 _083_ genblk1\[8\].fa_inst.b 0
C8484 output45/a_27_47# net45 0.02041f
C8485 _301_/a_543_47# _286_/a_1283_21# 0
C8486 _301_/a_448_47# _286_/a_193_47# 0
C8487 b[8] clknet_2_3__leaf_clk_regs 0
C8488 net46 pmu_inst/dc_inst.net1 0.01492f
C8489 _067_ _153_/a_215_297# 0
C8490 net55 pmu_inst/dc_inst.x5.net14 0
C8491 _293_/a_761_289# genblk1\[6\].fa_inst.a 0.0434f
C8492 input34/a_27_47# net34 0.00594f
C8493 b[8] net32 0
C8494 _275_/a_805_47# VPWR 0
C8495 _163_/a_215_297# _074_ 0.0035f
C8496 net4 _296_/a_27_47# 0.01734f
C8497 _178_/a_382_47# genblk1\[9\].fa_inst.b 0
C8498 net39 pmu_inst/dc_inst.x5.x7/a_27_47# 0
C8499 _148_/a_298_297# VPWR -0
C8500 _158_/a_215_297# genblk1\[5\].fa_inst.b 0
C8501 _158_/a_27_413# _069_ 0.01607f
C8502 _159_/a_47_47# _075_ 0.06803f
C8503 _294_/a_761_289# net58 0.00235f
C8504 clknet_0_clk_regs net52 0.02728f
C8505 _068_ _153_/a_215_297# 0.04409f
C8506 _260_/a_27_47# _005_ 0.00393f
C8507 _037_ clknet_2_1__leaf_clk_regs 0
C8508 _290_/a_1283_21# net11 0.00256f
C8509 _276_/a_27_47# net17 0
C8510 genblk1\[6\].fa_inst.s _006_ 0
C8511 _286_/a_1283_21# genblk1\[14\].fa_inst.a 0.00127f
C8512 _286_/a_651_413# _031_ -0
C8513 _256_/a_1108_47# net39 0.00409f
C8514 _256_/a_639_47# genblk1\[0\].fa_inst.s 0
C8515 net46 _255_/a_1108_47# 0
C8516 VPWR pmu_inst/dc_inst.x6.x16/a_27_47# 0.00674f
C8517 VPWR net72 0.72901f
C8518 VPWR pmu_inst/dc_inst.x1.x6/a_27_47# 0.00225f
C8519 _294_/a_193_47# net17 0
C8520 VPWR _299_/a_651_413# 0.00817f
C8521 VPWR _010_ 0.12095f
C8522 _054_ _052_ 0
C8523 net47 pmu_inst/_23_/a_1283_21# 0.00511f
C8524 clknet_2_1__leaf_clk_regs _261_/a_1108_47# 0
C8525 net7 net59 0.01191f
C8526 _275_/a_448_47# net8 0
C8527 _289_/a_193_47# net12 0.03694f
C8528 net24 _278_/a_193_47# 0
C8529 _277_/a_448_47# net36 0
C8530 clknet_2_0__leaf_clk_regs clkbuf_2_1__f_clk_regs/a_110_47# 0
C8531 _274_/a_805_47# net9 0
C8532 net7 _298_/a_27_47# 0.03599f
C8533 VPWR input3/a_27_47# 0.0923f
C8534 genblk1\[2\].fa_inst.a genblk1\[1\].fa_inst.b 0.03835f
C8535 _257_/a_448_47# VPWR 0
C8536 clkbuf_1_0__f_clk/a_110_47# net51 0
C8537 _295_/a_543_47# net30 0.03744f
C8538 _295_/a_761_289# _040_ 0.0047f
C8539 VPWR _178_/a_27_413# 0.06745f
C8540 _070_ _069_ 0.18669f
C8541 net5 net14 0.23063f
C8542 _296_/a_1108_47# _041_ 0.00597f
C8543 _296_/a_448_47# net31 0.03161f
C8544 _301_/a_27_47# _301_/a_193_47# -0
C8545 VPWR pmu_inst/dc_inst.x6.net15 0.01223f
C8546 net29 net5 0.03723f
C8547 _023_ _024_ 0.00301f
C8548 net8 net56 0
C8549 net58 _261_/a_651_413# 0
C8550 _287_/a_543_47# net7 0.02659f
C8551 _302_/a_193_47# _032_ 0
C8552 _047_ _287_/a_193_47# 0
C8553 _046_ net20 0
C8554 net4 _281_/a_27_47# 0.03085f
C8555 net3 _024_ 0.02671f
C8556 _173_/a_215_297# _082_ 0.09021f
C8557 _173_/a_27_413# _081_ 0.04911f
C8558 VPWR fanout59/a_27_47# 0.11709f
C8559 _303_/a_639_47# net23 0
C8560 net27 _279_/a_761_289# 0.01558f
C8561 _301_/a_193_47# _031_ 0.0266f
C8562 net21 _286_/a_761_289# 0
C8563 VPWR pmu_inst/dc_inst.x6.net5 0.00346f
C8564 _143_/a_215_297# _059_ 0.01033f
C8565 genblk1\[3\].fa_inst.a _136_/a_150_297# 0
C8566 _293_/a_543_47# genblk1\[6\].fa_inst.a 0.03376f
C8567 net58 _295_/a_27_47# 0.00592f
C8568 VPWR _298_/a_1108_47# 0.03812f
C8569 clk _263_/a_1108_47# 0.00386f
C8570 _259_/a_761_289# clknet_2_0__leaf_clk_regs 0
C8571 clknet_0_clk_regs net51 0.02656f
C8572 _301_/a_193_47# b[12] 0
C8573 a[12] a[13] 0.06871f
C8574 _286_/a_1270_413# clknet_2_2__leaf_clk_regs 0
C8575 _154_/a_377_297# genblk1\[5\].fa_inst.s 0.0013f
C8576 net25 _279_/a_27_47# 0
C8577 net4 _278_/a_27_47# 0.03543f
C8578 genblk1\[7\].fa_inst.b genblk1\[8\].fa_inst.a 0.21134f
C8579 net54 net53 0.00184f
C8580 _285_/a_543_47# clknet_2_3__leaf_clk_regs 0.00494f
C8581 net36 b[0] 0
C8582 _143_/a_215_297# _064_ 0.0152f
C8583 clknet_2_1__leaf_clk_regs genblk1\[6\].fa_inst.s 0.10283f
C8584 _294_/a_651_413# net62 0.0015f
C8585 _026_ _296_/a_1108_47# 0
C8586 _281_/a_1108_47# _041_ 0
C8587 _028_ _043_ 0
C8588 VPWR _287_/a_1270_413# 0
C8589 net29 net17 0.02347f
C8590 VPWR pmu_inst/dc_inst.x6.x14/a_27_47# 0.00237f
C8591 net29 clknet_2_2__leaf_clk_regs 0.04392f
C8592 net5 input29/a_75_212# 0.00552f
C8593 _292_/a_639_47# clknet_2_0__leaf_clk_regs 0.00432f
C8594 _271_/a_543_47# cout_next 0.00281f
C8595 _273_/a_543_47# clknet_2_1__leaf_clk_regs 0
C8596 _273_/a_193_47# _018_ 0
C8597 VPWR _050_ 1.0203f
C8598 _292_/a_761_289# _277_/a_193_47# 0
C8599 _259_/a_1108_47# fanout57/a_27_47# 0.00129f
C8600 net17 _061_ 0
C8601 _002_ VPWR 0.26718f
C8602 _292_/a_651_413# VPWR 0.00146f
C8603 input26/a_75_212# b[3] 0.01391f
C8604 _270_/a_1108_47# clk 0
C8605 _285_/a_1108_47# net60 0.00216f
C8606 input9/a_75_212# net9 0.00223f
C8607 net47 pmu_inst/dc_inst.x7.x2/a_27_47# 0.00227f
C8608 genblk1\[15\].fa_inst.a _202_/a_109_297# 0.002f
C8609 VPWR _127_/a_113_47# -0
C8610 _022_ _291_/a_1108_47# 0
C8611 net31 _041_ 0.00703f
C8612 net28 _042_ 0.03983f
C8613 _092_ _086_ 0.06026f
C8614 _275_/a_27_47# _274_/a_27_47# 0
C8615 net12 a[7] 0
C8616 _263_/a_543_47# _008_ 0
C8617 _263_/a_27_47# net53 0
C8618 clk net50 0.08509f
C8619 _259_/a_805_47# net57 0
C8620 net33 _058_ 0.03123f
C8621 _290_/a_1108_47# VPWR 0.01625f
C8622 _258_/a_193_47# net36 0.01282f
C8623 clknet_2_1__leaf_clk_regs _280_/a_1108_47# 0
C8624 _303_/a_193_47# _303_/a_651_413# -0.00701f
C8625 genblk1\[15\].fa_inst.b net23 0.00112f
C8626 clkload2/a_27_47# clk 0.02361f
C8627 net39 pmu_inst/_17_/a_574_297# 0
C8628 _276_/a_448_47# net12 0
C8629 clknet_2_2__leaf_clk_regs _263_/a_448_47# 0.00156f
C8630 VPWR _139_/a_285_47# 0.00313f
C8631 net58 _295_/a_1217_47# 0
C8632 VPWR net18 0.73508f
C8633 net46 pmu_inst/dc_inst.x2.net19 0
C8634 _259_/a_1217_47# clknet_2_0__leaf_clk_regs 0
C8635 net28 _293_/a_193_47# -0.00529f
C8636 clkload0/Y _260_/a_1283_21# 0.00179f
C8637 _281_/a_543_47# net16 0
C8638 genblk1\[8\].fa_inst.a _173_/a_27_413# 0
C8639 _277_/a_193_47# net13 0
C8640 _293_/a_27_47# net33 0.03028f
C8641 _281_/a_761_289# genblk1\[9\].fa_inst.a 0
C8642 _281_/a_1108_47# _026_ 0.00797f
C8643 _047_ net35 0
C8644 _273_/a_543_47# net11 0
C8645 net47 net66 0.00108f
C8646 _283_/a_193_47# net30 0.03283f
C8647 _284_/a_543_47# clknet_2_3__leaf_clk_regs 0.001f
C8648 _282_/a_27_47# net30 0.02486f
C8649 net28 _298_/a_1283_21# 0
C8650 net28 _038_ 0.02889f
C8651 _276_/a_193_47# net24 0
C8652 _280_/a_761_289# genblk1\[8\].fa_inst.a 0
C8653 _280_/a_1108_47# _025_ 0.00928f
C8654 _264_/a_761_289# net59 0
C8655 genblk1\[0\].fa_inst.s _129_/a_377_297# 0
C8656 clkbuf_regs_0_clk/a_110_47# clk_regs 0.00984f
C8657 net6 input25/a_75_212# 0.01946f
C8658 _285_/a_543_47# net19 0.00596f
C8659 net72 net71 0.07038f
C8660 _284_/a_1108_47# net60 0
C8661 net39 pmu_inst/dc_inst.x1.x7/a_27_47# 0.00198f
C8662 genblk1\[4\].fa_inst.b clknet_2_0__leaf_clk_regs 0.19831f
C8663 _300_/a_639_47# net60 0
C8664 _275_/a_1108_47# net10 0
C8665 _273_/a_639_47# genblk1\[1\].fa_inst.a 0
C8666 net47 pmu_inst/dc_inst.x3.net17 0.00604f
C8667 _277_/a_1108_47# fanout56/a_27_47# 0.0029f
C8668 _259_/a_543_47# VPWR 0.02806f
C8669 net73 pmu_inst_73/HI 0.00428f
C8670 net6 _298_/a_27_47# 0
C8671 _160_/a_150_297# genblk1\[7\].fa_inst.a 0
C8672 net39 pmu_inst/dc_inst.x5.x18/a_27_47# 0.00147f
C8673 _277_/a_761_289# _291_/a_761_289# 0
C8674 net62 _295_/a_1108_47# 0
C8675 net60 genblk1\[13\].fa_inst.b 0.03192f
C8676 _022_ net26 0
C8677 _301_/a_448_47# _046_ 0
C8678 _276_/a_1108_47# _290_/a_1283_21# 0
C8679 VPWR _261_/a_448_47# 0
C8680 clknet_2_1__leaf_clk_regs _079_ 0
C8681 b[7] net6 0.22255f
C8682 _263_/a_1217_47# net53 0
C8683 net29 _297_/a_27_47# 0.02129f
C8684 _269_/a_761_289# _014_ 0.00424f
C8685 _284_/a_448_47# net59 0
C8686 _283_/a_193_47# _283_/a_543_47# -0.00535f
C8687 genblk1\[11\].fa_inst.b _029_ 0
C8688 _051_ hold1/a_49_47# 0
C8689 _270_/a_27_47# net45 0
C8690 _270_/a_543_47# _015_ 0
C8691 net33 _300_/a_193_47# 0
C8692 net39 pmu_inst/dc_inst.x6.net3 0
C8693 _135_/a_215_297# _053_ 0.00997f
C8694 _258_/a_1462_47# net36 0
C8695 _292_/a_651_413# net2 0.00211f
C8696 net25 VPWR 1.78555f
C8697 _284_/a_543_47# _298_/a_543_47# 0
C8698 _284_/a_193_47# _298_/a_1108_47# 0
C8699 _284_/a_27_47# _298_/a_448_47# 0
C8700 genblk1\[8\].fa_inst.a _040_ 0
C8701 clknet_2_2__leaf_clk_regs _008_ -0
C8702 _293_/a_1270_413# genblk1\[5\].fa_inst.b 0
C8703 net29 _294_/a_639_47# 0.00126f
C8704 _039_ _294_/a_448_47# -0
C8705 cin_q _054_ 0.10099f
C8706 VPWR pmu_inst/dc_inst.x7.x4/a_27_47# 0.00213f
C8707 _278_/a_761_289# genblk1\[6\].fa_inst.a 0
C8708 _285_/a_193_47# net18 0.03497f
C8709 clkload0/a_361_47# net50 0.00194f
C8710 _275_/a_27_47# _288_/a_27_47# 0
C8711 _274_/a_1108_47# net56 0
C8712 clknet_2_1__leaf_clk_regs a[4] 0.04036f
C8713 clknet_2_1__leaf_clk_regs _279_/a_27_47# 0.0237f
C8714 genblk1\[7\].fa_inst.s net58 0
C8715 _283_/a_1462_47# net30 0
C8716 input23/a_75_212# clknet_2_3__leaf_clk_regs 0.01338f
C8717 net39 pmu_inst/dc_inst.x7.net6 0
C8718 genblk1\[4\].fa_inst.a net11 0.00144f
C8719 _168_/a_27_413# _084_ 0
C8720 _282_/a_1217_47# net30 0
C8721 _300_/a_651_413# net19 0.00455f
C8722 _056_ genblk1\[1\].fa_inst.s 0.01878f
C8723 _130_/a_27_413# _054_ 0
C8724 _158_/a_27_413# _070_ 0.00771f
C8725 net61 _264_/a_1108_47# 0.00244f
C8726 net47 pmu_inst_72/HI 0
C8727 pmu_inst/dc_inst.x3.net9 net67 0
C8728 _286_/a_543_47# clknet_2_3__leaf_clk_regs 0.03397f
C8729 VPWR pmu_inst/dc_inst.x4.x14/a_27_47# 0
C8730 net6 input24/a_27_47# 0.02114f
C8731 clk _265_/a_193_47# 0.03708f
C8732 net61 _266_/a_543_47# 0.00104f
C8733 clk_regs clkbuf_0_clk_regs/a_110_47# 0.0944f
C8734 _021_ _062_ 0
C8735 _277_/a_1217_47# VPWR 0
C8736 net47 pmu_inst/dc_inst.x3.net11 0.02382f
C8737 _286_/a_1108_47# net60 0
C8738 net58 _279_/a_761_289# 0.00348f
C8739 _300_/a_193_47# net35 0
C8740 genblk1\[1\].fa_inst.a _272_/a_193_47# 0
C8741 _275_/a_1108_47# _019_ 0
C8742 _275_/a_761_289# genblk1\[2\].fa_inst.a 0.00372f
C8743 VPWR _154_/a_47_47# 0.05054f
C8744 VPWR _006_ 0.14333f
C8745 net7 _280_/a_193_47# 0.02655f
C8746 _269_/a_1108_47# net62 0.00136f
C8747 net39 pmu_inst/_18_/a_439_47# 0
C8748 clknet_2_0__leaf_clk_regs genblk1\[2\].fa_inst.b 0
C8749 _290_/a_27_47# _289_/a_27_47# 0.00132f
C8750 _294_/a_543_47# _279_/a_761_289# 0
C8751 input34/a_27_47# delay_sel[0] 0.00919f
C8752 _098_ _097_ 0.52554f
C8753 _255_/a_761_289# net57 0
C8754 _158_/a_215_297# _076_ 0.0111f
C8755 _164_/a_285_47# net62 0.0037f
C8756 _029_ net59 0.02114f
C8757 _273_/a_1108_47# net1 0
C8758 _273_/a_1283_21# VPWR 0.01161f
C8759 VPWR output50/a_27_47# 0.09272f
C8760 clknet_2_1__leaf_clk_regs _073_ 0
C8761 net46 pmu_inst/dc_inst.x6.net7 0
C8762 a[4] net11 0.00467f
C8763 VPWR _295_/a_805_47# 0
C8764 _270_/a_1217_47# net45 0
C8765 _279_/a_27_47# _279_/a_193_47# -0.00487f
C8766 _284_/a_27_47# _043_ 0
C8767 _303_/a_805_47# genblk1\[15\].fa_inst.b 0
C8768 _199_/a_47_47# _112_ 0.01005f
C8769 net60 _194_/a_285_47# 0.0443f
C8770 _029_ _298_/a_27_47# 0
C8771 _284_/a_193_47# net18 0.01881f
C8772 VPWR pmu_inst/dc_inst.x6.net4 0.00324f
C8773 net60 genblk1\[14\].fa_inst.b 0.0079f
C8774 _289_/a_193_47# a[6] 0
C8775 _066_ _146_/a_113_47# 0
C8776 _268_/a_27_47# genblk1\[13\].fa_inst.s 0.14877f
C8777 clkload2/a_27_47# _265_/a_27_47# 0.0012f
C8778 net49 clknet_2_0__leaf_clk_regs 0
C8779 _293_/a_651_413# genblk1\[5\].fa_inst.b 0
C8780 _159_/a_377_297# _076_ 0.00143f
C8781 _273_/a_27_47# net8 0.04053f
C8782 _163_/a_27_413# genblk1\[6\].fa_inst.a 0
C8783 _294_/a_193_47# net33 0
C8784 _161_/a_113_47# genblk1\[7\].fa_inst.a 0
C8785 net26 net24 0
C8786 _275_/a_1108_47# _288_/a_448_47# 0
C8787 VPWR pmu_inst/dc_inst.x6.x13/a_27_47# 0.00233f
C8788 clkbuf_2_1__f_clk_regs/a_110_47# _260_/a_193_47# 0
C8789 net59 _296_/a_1108_47# 0.02923f
C8790 net25 net2 0.02258f
C8791 pmu_inst/dc_inst.x1.x6/a_27_47# net65 0
C8792 VPWR _280_/a_448_47# 0
C8793 VPWR pmu_inst/dc_inst.x1.net12 0.00545f
C8794 net15 _278_/a_193_47# 0
C8795 _184_/a_377_297# genblk1\[11\].fa_inst.s 0
C8796 net7 net30 0.27015f
C8797 _166_/a_113_47# genblk1\[9\].fa_inst.a 0
C8798 _286_/a_543_47# net19 0.03569f
C8799 clk _265_/a_1462_47# 0
C8800 _188_/a_27_413# _098_ 0
C8801 net46 pmu_inst/dc_inst.x7.net4 0
C8802 clknet_2_2__leaf_clk_regs _297_/a_543_47# 0.03582f
C8803 tdo net55 0.82025f
C8804 genblk1\[3\].fa_inst.a _140_/a_150_297# 0
C8805 _288_/a_1108_47# net56 0.00271f
C8806 VPWR pmu_inst/dc_inst.x6.x12/a_27_47# 0.00242f
C8807 _294_/a_27_47# net5 0
C8808 _284_/a_1270_413# net35 0
C8809 _256_/a_27_47# genblk1\[1\].fa_inst.s 0.04029f
C8810 _259_/a_1283_21# _003_ 0
C8811 _270_/a_193_47# clknet_2_3__leaf_clk_regs 0.58998f
C8812 _018_ clknet_2_0__leaf_clk_regs 0.00761f
C8813 input15/a_75_212# a[9] 0.00306f
C8814 _263_/a_1283_21# net59 0.01977f
C8815 _304_/a_639_47# genblk1\[1\].fa_inst.b 0.00136f
C8816 _059_ _058_ 0.40494f
C8817 _039_ genblk1\[6\].fa_inst.b 0.00122f
C8818 VPWR _135_/a_215_297# 0.01484f
C8819 clknet_2_1__leaf_clk_regs VPWR 4.9133f
C8820 _258_/a_1283_21# genblk1\[3\].fa_inst.s 0
C8821 _282_/a_1283_21# genblk1\[10\].fa_inst.a 0.00292f
C8822 net55 pmu_inst/dc_inst.x5.net2 0
C8823 genblk1\[4\].fa_inst.a _072_ 0
C8824 _281_/a_1108_47# net59 0.02069f
C8825 net7 _283_/a_543_47# 0.01768f
C8826 VPWR s[10] 0.37243f
C8827 _080_ _076_ 0.03809f
C8828 net7 _282_/a_761_289# 0.00498f
C8829 clk net59 0.09108f
C8830 net47 clknet_1_0__leaf_clk 0.00799f
C8831 clknet_2_3__leaf_clk_regs b[11] 0
C8832 net46 pmu_inst/dc_inst.x2.net9 -0
C8833 b[13] clknet_2_2__leaf_clk_regs 0
C8834 _286_/a_193_47# net18 0
C8835 net46 pmu_inst/dc_inst.x5.net1 0
C8836 genblk1\[3\].fa_inst.a _288_/a_761_289# 0.01414f
C8837 VPWR genblk1\[3\].fa_inst.s 1.31084f
C8838 _171_/a_113_47# genblk1\[9\].fa_inst.b 0
C8839 _064_ _058_ 0.00546f
C8840 _303_/a_448_47# clknet_2_3__leaf_clk_regs 0.01407f
C8841 net59 net31 0
C8842 _294_/a_27_47# net17 0
C8843 VPWR _025_ 0.04122f
C8844 _184_/a_47_47# VPWR 0.03017f
C8845 net39 pmu_inst/dc_inst.x2.x13/a_27_47# 0.00738f
C8846 clk fanout58/a_27_47# 0.01267f
C8847 _189_/a_285_47# genblk1\[11\].fa_inst.b 0
C8848 a[6] a[7] 0.07915f
C8849 _293_/a_193_47# _278_/a_193_47# 0.00248f
C8850 _298_/a_27_47# net31 0.02466f
C8851 net33 _061_ 0.01974f
C8852 net5 _298_/a_193_47# 0
C8853 genblk1\[13\].fa_inst.a _195_/a_68_297# 0
C8854 _097_ _198_/a_382_47# 0
C8855 VPWR pmu_inst/dc_inst.x2.net12 0
C8856 VPWR _283_/a_1270_413# 0
C8857 _255_/a_27_47# _255_/a_1283_21# -0
C8858 VPWR net11 1.82986f
C8859 VPWR _279_/a_193_47# 0.03867f
C8860 VPWR _282_/a_651_413# 0.00129f
C8861 _265_/a_27_47# _265_/a_193_47# -0.07655f
C8862 _097_ VPWR 0.7448f
C8863 VPWR pmu_inst/dc_inst.x5.net13 0
C8864 net17 net56 0.24316f
C8865 net2 _280_/a_448_47# 0.01244f
C8866 _100_ _097_ 0.14746f
C8867 genblk1\[0\].fa_inst.b _288_/a_761_289# 0
C8868 _054_ _304_/a_543_47# 0
C8869 _257_/a_448_47# net57 0.00182f
C8870 _302_/a_27_47# VPWR 0.04525f
C8871 net60 clknet_2_2__leaf_clk_regs 0
C8872 clk _267_/a_1108_47# 0
C8873 _189_/a_47_47# clknet_2_3__leaf_clk_regs 0
C8874 _276_/a_805_47# clknet_2_1__leaf_clk_regs 0
C8875 _276_/a_193_47# _291_/a_543_47# 0
C8876 _271_/a_1108_47# fanout62/a_110_47# 0.00181f
C8877 net47 pmu_inst/dc_inst.x3.net15 0.00834f
C8878 genblk1\[4\].fa_inst.s _149_/a_285_47# 0.00119f
C8879 VPWR pmu_inst/_15_/a_372_413# 0
C8880 genblk1\[4\].fa_inst.a _276_/a_1108_47# 0.00131f
C8881 clknet_1_0__leaf_clk net36 -0
C8882 clknet_2_2__leaf_clk_regs genblk1\[10\].fa_inst.b 0
C8883 _271_/a_761_289# net45 0
C8884 _035_ _289_/a_1108_47# 0
C8885 net25 _289_/a_448_47# 0
C8886 _290_/a_448_47# net24 0
C8887 _290_/a_1108_47# _034_ 0
C8888 net6 _280_/a_193_47# 0
C8889 net3 _041_ 0.02088f
C8890 _297_/a_27_47# _297_/a_543_47# -0.00482f
C8891 _288_/a_1108_47# _055_ 0
C8892 _276_/a_1217_47# _035_ 0
C8893 net27 _296_/a_761_289# 0.00481f
C8894 _028_ genblk1\[11\].fa_inst.a 0.1926f
C8895 net33 _303_/a_27_47# 0
C8896 net27 _277_/a_761_289# 0
C8897 _023_ _278_/a_448_47# 0
C8898 _272_/a_639_47# clknet_2_0__leaf_clk_regs 0
C8899 _272_/a_1283_21# genblk1\[0\].fa_inst.a 0.00142f
C8900 _279_/a_543_47# genblk1\[7\].fa_inst.a 0
C8901 _279_/a_448_47# _024_ 0
C8902 clknet_0_clk_regs _264_/a_193_47# 0
C8903 net39 pmu_inst/dc_inst.x1.net10 0.02147f
C8904 _149_/a_47_47# _065_ 0.01328f
C8905 net3 _278_/a_448_47# 0
C8906 _168_/a_27_413# _078_ 0.02358f
C8907 clkload2/X _010_ 0
C8908 net29 net35 0
C8909 _272_/a_1270_413# net1 0
C8910 _272_/a_651_413# VPWR -0.00927f
C8911 clknet_2_2__leaf_clk_regs _298_/a_193_47# 0.00149f
C8912 _302_/a_1283_21# _047_ 0.00158f
C8913 _269_/a_193_47# cout_next 0
C8914 clkbuf_2_2__f_clk_regs/a_110_47# _089_ 0
C8915 b[11] net19 0.00228f
C8916 _020_ net17 0
C8917 clknet_2_1__leaf_clk_regs net2 0.0412f
C8918 _188_/a_27_413# VPWR 0.04842f
C8919 cin_q _304_/a_805_47# 0
C8920 _277_/a_639_47# net16 0.00136f
C8921 _048_ clknet_2_3__leaf_clk_regs 0.01352f
C8922 b[10] net18 0.00149f
C8923 _188_/a_27_413# _100_ 0
C8924 _273_/a_27_47# a[3] 0
C8925 net27 _039_ 0.03349f
C8926 _270_/a_651_413# net61 0.00151f
C8927 _286_/a_639_47# net36 0
C8928 net49 cout_next 0.52482f
C8929 VPWR pmu_inst/dc_inst.x4.net18 0.00114f
C8930 _071_ _150_/a_68_297# 0
C8931 net6 net30 0.01619f
C8932 _274_/a_543_47# _273_/a_761_289# 0.00181f
C8933 _274_/a_1283_21# _273_/a_193_47# 0.00301f
C8934 _274_/a_1108_47# _273_/a_27_47# 0
C8935 input31/a_75_212# b[8] 0.01391f
C8936 a[11] net16 0
C8937 VPWR pmu_inst/dc_inst.x7.net17 0
C8938 net49 _259_/a_27_47# 0
C8939 _084_ net59 0
C8940 VPWR _279_/a_1462_47# 0
C8941 net2 _025_ 0
C8942 net3 _026_ 0.02565f
C8943 _174_/a_47_47# _086_ 0.00112f
C8944 _265_/a_761_289# genblk1\[10\].fa_inst.s 0
C8945 _256_/a_761_289# VPWR 0.00983f
C8946 _002_ net57 0.15637f
C8947 input16/a_75_212# a[9] 0.01942f
C8948 _144_/a_47_47# _062_ 0
C8949 net27 _281_/a_761_289# 0.01516f
C8950 clknet_2_2__leaf_clk_regs _085_ 0.03258f
C8951 _302_/a_1217_47# VPWR 0
C8952 net13 _278_/a_1108_47# 0
C8953 _303_/a_543_47# net34 0.02967f
C8954 _303_/a_27_47# net35 0.03823f
C8955 genblk1\[6\].fa_inst.b _163_/a_27_413# 0.0016f
C8956 genblk1\[10\].fa_inst.a _090_ 0.22894f
C8957 _258_/a_651_413# clknet_2_0__leaf_clk_regs 0.00108f
C8958 net28 _279_/a_27_47# 0
C8959 VPWR pmu_inst_67/HI 0.05193f
C8960 _035_ net24 0
C8961 net4 net18 0.44064f
C8962 _301_/a_448_47# net18 0
C8963 net17 _055_ 0
C8964 _258_/a_1108_47# VPWR 0.01901f
C8965 net2 _279_/a_193_47# 0.01976f
C8966 _262_/a_27_47# net62 0.05505f
C8967 output44/a_27_47# s[15] 0
C8968 clknet_2_0__leaf_clk_regs genblk1\[0\].fa_inst.a 0.02701f
C8969 _276_/a_761_289# _035_ 0.01666f
C8970 VPWR rst 0.29479f
C8971 net74 net50 0.12036f
C8972 net27 _278_/a_761_289# 0.01408f
C8973 _047_ net7 0.18122f
C8974 VPWR _136_/a_150_297# 0
C8975 input21/a_75_212# b[13] 0.01461f
C8976 net13 a[9] 0
C8977 _277_/a_1283_21# net17 0.00549f
C8978 net29 _295_/a_543_47# 0.00213f
C8979 _303_/a_193_47# net36 0.03604f
C8980 clknet_1_0__leaf_clk net51 0
C8981 VPWR _072_ 0.6949f
C8982 VPWR _086_ 0.17071f
C8983 genblk1\[11\].fa_inst.b _299_/a_193_47# 0
C8984 cin_q _139_/a_377_297# 0
C8985 _006_ _260_/a_543_47# 0
C8986 genblk1\[14\].fa_inst.a net36 0
C8987 net59 _297_/a_193_47# 0.01745f
C8988 genblk1\[15\].fa_inst.b _287_/a_543_47# 0
C8989 net69 net67 -0.00971f
C8990 _290_/a_27_47# net12 0.03181f
C8991 _276_/a_1462_47# _035_ 0
C8992 genblk1\[12\].fa_inst.b _300_/a_1270_413# 0
C8993 net28 _073_ 0
C8994 net47 pmu_inst/dc_inst.x3.net5 0.00658f
C8995 s[9] s[10] 0
C8996 a[0] a[1] 0.58808f
C8997 _274_/a_193_47# clknet_2_1__leaf_clk_regs 0.03738f
C8998 net47 pmu_inst/dc_inst.x7.net16 0.00304f
C8999 clknet_2_1__leaf_clk_regs _069_ 0
C9000 VPWR pmu_inst/dc_inst.net4 0.01848f
C9001 _291_/a_543_47# net26 0.00284f
C9002 _291_/a_761_289# _036_ 0.00537f
C9003 genblk1\[14\].fa_inst.a _195_/a_68_297# 0.05185f
C9004 _255_/a_448_47# net39 0
C9005 _275_/a_543_47# net56 0
C9006 _255_/a_805_47# genblk1\[0\].fa_inst.s 0
C9007 _259_/a_543_47# net57 0.00104f
C9008 _039_ _295_/a_1270_413# 0
C9009 net58 _262_/a_193_47# 0.00111f
C9010 _265_/a_543_47# net40 0
C9011 _271_/a_543_47# clknet_2_3__leaf_clk_regs 0.0016f
C9012 net53 net34 0.02399f
C9013 _258_/a_543_47# _003_ 0.01002f
C9014 net12 net13 0
C9015 net25 net4 0.02257f
C9016 _074_ _155_/a_68_297# 0
C9017 _191_/a_113_47# _102_ 0
C9018 net46 pmu_inst/dc_inst.x1.x11/a_27_47# 0
C9019 clknet_2_1__leaf_clk_regs _289_/a_448_47# 0
C9020 net47 pmu_inst/dc_inst.x7.net12 0.02005f
C9021 genblk1\[8\].fa_inst.b _296_/a_761_289# 0
C9022 _051_ _033_ 0
C9023 _291_/a_1270_413# net56 0
C9024 net28 _027_ 0.00174f
C9025 _183_/a_215_297# _179_/a_47_47# 0
C9026 _029_ net30 0
C9027 _304_/a_27_47# _304_/a_761_289# -0.01661f
C9028 _052_ _056_ 0.02479f
C9029 net60 _299_/a_27_47# 0.04649f
C9030 genblk1\[12\].fa_inst.s _267_/a_805_47# 0
C9031 _297_/a_1270_413# _042_ -0
C9032 pmu_inst/dc_inst.x7.net13 net34 0
C9033 _268_/a_193_47# clknet_2_3__leaf_clk_regs 0.04664f
C9034 _039_ _280_/a_1283_21# 0
C9035 _281_/a_543_47# _295_/a_651_413# 0
C9036 net3 _297_/a_761_289# 0.00866f
C9037 _270_/a_639_47# genblk1\[15\].fa_inst.s 0.00114f
C9038 a[3] input11/a_75_212# 0
C9039 VPWR pmu_inst_71/HI 0.08741f
C9040 input10/a_75_212# a[4] 0.00367f
C9041 _262_/a_543_47# net62 0.01187f
C9042 input21/a_75_212# b[14] 0
C9043 b[13] input22/a_75_212# 0
C9044 _276_/a_1108_47# VPWR 0.02522f
C9045 net26 net15 0.02684f
C9046 net46 pmu_inst/dc_inst.x1.x1/a_27_47# 0
C9047 _259_/a_1462_47# net36 0
C9048 _095_ clknet_2_3__leaf_clk_regs 0.1423f
C9049 _256_/a_1270_413# _001_ 0
C9050 _256_/a_1108_47# net46 0.00385f
C9051 net39 pmu_inst/_19_/a_27_47# 0.00315f
C9052 _275_/a_27_47# genblk1\[3\].fa_inst.a 0
C9053 _275_/a_543_47# _020_ 0
C9054 _257_/a_27_47# _257_/a_193_47# -0
C9055 _294_/a_1283_21# _280_/a_1108_47# 0
C9056 _268_/a_543_47# net60 0.00168f
C9057 net45 net34 0.0271f
C9058 _274_/a_193_47# net11 0
C9059 _296_/a_1108_47# net30 0.00388f
C9060 net61 _265_/a_543_47# 0
C9061 net16 net36 0.01979f
C9062 VPWR _285_/a_761_289# 0.01466f
C9063 net39 pmu_inst/dc_inst.x1.x13/a_27_47# 0
C9064 genblk1\[11\].fa_inst.b _299_/a_1462_47# 0
C9065 genblk1\[7\].fa_inst.b net17 0
C9066 _276_/a_193_47# _290_/a_1283_21# 0
C9067 _021_ _291_/a_761_289# 0
C9068 _260_/a_1108_47# genblk1\[5\].fa_inst.s 0
C9069 _169_/a_377_297# _084_ 0
C9070 net49 _259_/a_448_47# 0
C9071 _048_ _032_ 0
C9072 _269_/a_27_47# genblk1\[13\].fa_inst.s 0
C9073 net28 VPWR 2.65336f
C9074 _304_/a_1108_47# net56 0.00477f
C9075 _289_/a_448_47# net11 0.00275f
C9076 clknet_0_clk_regs _263_/a_543_47# 0
C9077 _099_ genblk1\[11\].fa_inst.b 0
C9078 _274_/a_651_413# genblk1\[1\].fa_inst.a 0
C9079 _302_/a_27_47# net20 0
C9080 _000_ net39 0.06522f
C9081 net39 pmu_inst/dc_inst.x4.x6/a_27_47# 0.00178f
C9082 _300_/a_193_47# net7 0.03165f
C9083 net33 _180_/a_150_297# 0
C9084 _273_/a_761_289# net9 0
C9085 _258_/a_1217_47# net48 0
C9086 _271_/a_1283_21# net38 0.00291f
C9087 _271_/a_651_413# _016_ 0.00146f
C9088 _277_/a_761_289# net58 0.00822f
C9089 output45/a_27_47# VPWR 0.08278f
C9090 _302_/a_27_47# _286_/a_193_47# 0
C9091 _302_/a_193_47# _286_/a_27_47# 0
C9092 clknet_2_1__leaf_clk_regs _034_ 0
C9093 _064_ _061_ 0.12494f
C9094 _149_/a_129_47# _067_ 0.00284f
C9095 _160_/a_150_297# genblk1\[6\].fa_inst.a 0
C9096 _294_/a_193_47# _279_/a_1108_47# 0
C9097 _267_/a_193_47# clknet_2_3__leaf_clk_regs 0.17448f
C9098 _299_/a_639_47# net32 0
C9099 input22/a_75_212# b[14] 0.01461f
C9100 net29 _283_/a_193_47# 0.01778f
C9101 net60 _299_/a_1217_47# 0
C9102 _044_ _299_/a_639_47# 0.00177f
C9103 _277_/a_27_47# net36 0.00383f
C9104 net29 _282_/a_27_47# 0.03079f
C9105 _287_/a_193_47# net60 0.03322f
C9106 input13/a_75_212# a[8] 0
C9107 cout_next net68 0.06406f
C9108 clknet_2_1__leaf_clk_regs _281_/a_27_47# 0
C9109 _026_ _295_/a_1283_21# 0
C9110 _281_/a_1108_47# net30 0.01991f
C9111 _281_/a_1283_21# _040_ 0.00171f
C9112 _264_/a_27_47# genblk1\[9\].fa_inst.s 0.04956f
C9113 net45 genblk1\[15\].fa_inst.s 0
C9114 _149_/a_129_47# _068_ 0.00126f
C9115 _267_/a_543_47# net60 0
C9116 net39 pmu_inst/dc_inst.x4.net11 0.00332f
C9117 _126_/a_68_297# net56 0
C9118 net4 _280_/a_448_47# 0.01071f
C9119 _039_ net58 0.19863f
C9120 _294_/a_27_47# net33 0
C9121 VPWR _284_/a_761_289# 0.00924f
C9122 _294_/a_193_47# net62 0.03684f
C9123 _039_ _294_/a_543_47# 0
C9124 _300_/a_448_47# VPWR 0.00125f
C9125 net5 input32/a_75_212# 0.00552f
C9126 _275_/a_1217_47# genblk1\[3\].fa_inst.a 0
C9127 _004_ _259_/a_1283_21# 0.05555f
C9128 _183_/a_27_413# genblk1\[10\].fa_inst.b 0
C9129 _198_/a_27_413# genblk1\[13\].fa_inst.b 0
C9130 net33 _299_/a_543_47# 0
C9131 net31 net30 0.01549f
C9132 net72 pmu_inst/dc_inst.x6.net5 0
C9133 net47 pmu_inst/_24_/a_1270_413# -0
C9134 _268_/a_27_47# net43 0
C9135 _268_/a_543_47# _013_ 0.00137f
C9136 net26 _038_ 0
C9137 _293_/a_1270_413# _038_ -0
C9138 clknet_2_1__leaf_clk_regs _278_/a_27_47# 0.26864f
C9139 genblk1\[4\].fa_inst.s clkbuf_2_0__f_clk_regs/a_110_47# 0.00107f
C9140 _159_/a_377_297# genblk1\[6\].fa_inst.s 0
C9141 net3 net59 0
C9142 _180_/a_150_297# net35 0
C9143 net33 net56 0
C9144 _034_ net11 0.03652f
C9145 net39 pmu_inst/dc_inst.x6.x7/a_27_47# 0.00969f
C9146 genblk1\[2\].fa_inst.s _304_/a_761_289# 0
C9147 _291_/a_193_47# net36 0.01238f
C9148 net50 s[5] 0.00879f
C9149 net33 net60 0.23539f
C9150 net3 _298_/a_27_47# 0
C9151 net61 _268_/a_651_413# 0
C9152 _130_/a_298_297# _053_ 0.04416f
C9153 net7 _284_/a_1270_413# 0
C9154 net33 genblk1\[10\].fa_inst.b 0.38251f
C9155 clknet_2_0__leaf_clk_regs net75 0
C9156 VPWR input10/a_75_212# 0.08905f
C9157 VPWR pmu_inst/dc_inst.x5.x19/a_27_47# 0
C9158 VPWR pmu_inst/dc_inst.x7.x6/a_27_47# 0.00672f
C9159 clknet_2_1__leaf_clk_regs net4 0.04453f
C9160 clknet_0_clk_regs clknet_2_2__leaf_clk_regs 0.00106f
C9161 _287_/a_805_47# clknet_2_3__leaf_clk_regs 0
C9162 _304_/a_1108_47# _055_ 0
C9163 genblk1\[12\].fa_inst.b _193_/a_27_413# 0
C9164 _274_/a_1283_21# clknet_2_0__leaf_clk_regs 0.05525f
C9165 net28 net2 0
C9166 VPWR _266_/a_651_413# -0
C9167 b[13] net35 0
C9168 output39/a_27_47# VPWR 0.0938f
C9169 _283_/a_543_47# net31 0.00339f
C9170 _274_/a_761_289# VPWR 0.00814f
C9171 _304_/a_1270_413# net33 0
C9172 net58 _278_/a_761_289# 0.00339f
C9173 _294_/a_193_47# net7 0
C9174 _282_/a_193_47# _041_ 0
C9175 _060_ _135_/a_215_297# 0
C9176 net33 _298_/a_193_47# 0
C9177 _072_ _069_ 0.16599f
C9178 net17 _040_ 0
C9179 clkload0/a_27_47# clknet_0_clk_regs 0.00236f
C9180 net4 _025_ 0
C9181 _007_ net62 0
C9182 VPWR _289_/a_651_413# 0
C9183 _292_/a_761_289# net3 0
C9184 _279_/a_27_47# _278_/a_193_47# 0
C9185 _279_/a_193_47# _278_/a_27_47# 0
C9186 net71 pmu_inst_71/HI 0.00337f
C9187 _292_/a_193_47# _292_/a_761_289# -0.00839f
C9188 _292_/a_27_47# _292_/a_543_47# -0.0081f
C9189 genblk1\[9\].fa_inst.a _082_ 0.00202f
C9190 _045_ VPWR 0.09481f
C9191 _272_/a_1283_21# _288_/a_1283_21# 0.00102f
C9192 _257_/a_651_413# genblk1\[2\].fa_inst.s 0
C9193 _257_/a_543_47# net47 0
C9194 _257_/a_448_47# _002_ 0
C9195 _291_/a_543_47# _035_ 0
C9196 _178_/a_215_297# _092_ 0.004f
C9197 _300_/a_761_289# _285_/a_1108_47# 0
C9198 _300_/a_543_47# _285_/a_1283_21# 0
C9199 _300_/a_651_413# _285_/a_27_47# 0
C9200 net47 pmu_inst/_25_/a_639_47# 0.00122f
C9201 _108_ _101_ 0.05086f
C9202 net47 pmu_inst/dc_inst.x8/a_193_47# 0
C9203 clknet_2_1__leaf_clk_regs _158_/a_27_413# 0
C9204 net29 net62 0
C9205 _268_/a_1217_47# net43 0
C9206 _126_/a_68_297# _055_ 0
C9207 _080_ genblk1\[6\].fa_inst.s 0
C9208 net33 _287_/a_1283_21# 0.00145f
C9209 VPWR _286_/a_761_289# 0.02031f
C9210 net60 net35 0
C9211 net46 pmu_inst/dc_inst.x1.x7/a_27_47# 0.00692f
C9212 net47 pmu_inst/dc_inst.x9/a_277_47# 0.00339f
C9213 net4 _279_/a_193_47# 0.03347f
C9214 clknet_2_1__leaf_clk_regs _278_/a_1217_47# 0
C9215 net61 _267_/a_651_413# 0
C9216 net35 genblk1\[10\].fa_inst.b 0
C9217 _302_/a_1283_21# _301_/a_761_289# 0
C9218 _302_/a_543_47# _301_/a_543_47# 0
C9219 _302_/a_1108_47# _301_/a_193_47# 0
C9220 _302_/a_448_47# _301_/a_27_47# 0
C9221 pmu_inst/_17_/a_27_93# cout_next 0
C9222 _004_ net58 0
C9223 net46 pmu_inst/dc_inst.x5.x18/a_27_47# 0.00646f
C9224 _291_/a_1462_47# net36 0
C9225 VPWR _296_/a_193_47# 0.03182f
C9226 net33 _085_ 0.00283f
C9227 cin_q _056_ 0.002f
C9228 net13 _023_ 0
C9229 clknet_2_1__leaf_clk_regs _159_/a_47_47# 0
C9230 net22 net23 0
C9231 _169_/a_47_47# net59 0
C9232 _283_/a_1283_21# clknet_2_2__leaf_clk_regs 0
C9233 VPWR _194_/a_47_47# 0.05386f
C9234 _276_/a_651_413# net11 0.00151f
C9235 VPWR _140_/a_150_297# 0
C9236 _292_/a_27_47# _277_/a_1283_21# 0
C9237 net15 _295_/a_27_47# 0
C9238 _282_/a_543_47# clknet_2_2__leaf_clk_regs 0
C9239 _282_/a_193_47# _026_ 0
C9240 VPWR net54 5.03618f
C9241 _100_ _194_/a_47_47# 0
C9242 _035_ net15 0
C9243 clknet_2_0__leaf_clk_regs _260_/a_448_47# 0.00156f
C9244 net3 net13 0.02365f
C9245 _084_ _088_ 0.02496f
C9246 b[14] net35 0.008f
C9247 net39 pmu_inst/dc_inst.x2.x14/a_27_47# 0.00645f
C9248 _292_/a_193_47# net13 0
C9249 clknet_2_1__leaf_clk_regs _070_ 0
C9250 _039_ _294_/a_1270_413# -0
C9251 net5 b[0] 0
C9252 net46 pmu_inst/dc_inst.x6.net3 0.00444f
C9253 _130_/a_27_413# _056_ 0
C9254 VPWR _260_/a_1283_21# 0.03745f
C9255 _166_/a_113_47# genblk1\[8\].fa_inst.b 0
C9256 _037_ net26 0
C9257 net7 net14 0
C9258 _275_/a_543_47# _273_/a_27_47# 0
C9259 _275_/a_27_47# _273_/a_543_47# 0
C9260 _267_/a_27_47# net42 0
C9261 _267_/a_543_47# _012_ 0
C9262 net29 net7 0.90474f
C9263 clknet_2_0__leaf_clk_regs genblk1\[1\].fa_inst.b 0.02424f
C9264 net7 _296_/a_651_413# 0.0026f
C9265 _284_/a_193_47# _284_/a_761_289# -0.00517f
C9266 input11/a_75_212# a[5] 0
C9267 a[4] input12/a_75_212# 0
C9268 net47 pmu_inst/_14_/a_218_47# 0
C9269 VPWR _263_/a_27_47# 0.09887f
C9270 _298_/a_1108_47# net18 0
C9271 _298_/a_1283_21# _043_ 0.05555f
C9272 net46 pmu_inst/dc_inst.x7.net6 0
C9273 _067_ net36 0
C9274 clknet_0_clk net62 0.09878f
C9275 _294_/a_1283_21# VPWR 0.08209f
C9276 _141_/a_113_47# _062_ 0
C9277 _294_/a_651_413# net3 0.00523f
C9278 _017_ _288_/a_761_289# 0
C9279 clknet_2_0__leaf_clk_regs _288_/a_1283_21# 0
C9280 _127_/a_113_47# _050_ 0
C9281 cin_q _057_ 0.12236f
C9282 _300_/a_193_47# _030_ 0
C9283 net20 _285_/a_761_289# 0
C9284 _045_ _285_/a_193_47# 0
C9285 net47 net55 0.02086f
C9286 VPWR _288_/a_761_289# 0.01215f
C9287 VPWR _281_/a_193_47# 0.03836f
C9288 _108_ _201_/a_217_297# 0.03169f
C9289 genblk1\[8\].fa_inst.a net16 0
C9290 pmu_inst/dc_inst.x7.x4/a_27_47# net72 -0
C9291 a[6] net13 0.00225f
C9292 net47 pmu_inst/_13_/a_470_297# 0.00594f
C9293 _297_/a_193_47# net30 0.0317f
C9294 _285_/a_1108_47# genblk1\[13\].fa_inst.a 0
C9295 genblk1\[4\].fa_inst.a _276_/a_193_47# 0
C9296 _068_ net36 0.01214f
C9297 _293_/a_761_289# genblk1\[5\].fa_inst.b 0
C9298 _286_/a_27_47# _285_/a_543_47# 0
C9299 net43 net34 0.02886f
C9300 _277_/a_193_47# net14 0
C9301 _130_/a_27_413# _057_ 0
C9302 _047_ _301_/a_27_47# 0
C9303 _302_/a_27_47# _046_ 0
C9304 _302_/a_193_47# net21 0.04341f
C9305 _293_/a_639_47# _293_/a_27_47# -0.0015f
C9306 net17 b[0] 0.00149f
C9307 _301_/a_761_289# net7 0.00109f
C9308 _130_/a_298_297# VPWR -0.01274f
C9309 _259_/a_1108_47# clkbuf_2_0__f_clk_regs/a_110_47# 0
C9310 _294_/a_1108_47# _024_ 0
C9311 VPWR _296_/a_1462_47# 0.00209f
C9312 fanout60/a_27_47# net62 0.02619f
C9313 _094_ _089_ 0
C9314 _276_/a_1270_413# VPWR 0
C9315 pmu_inst/dc_inst.x3.net14 cout_next 0
C9316 _270_/a_27_47# VPWR 0.0228f
C9317 _303_/a_27_47# net7 0
C9318 _256_/a_761_289# net57 0.00442f
C9319 _277_/a_1108_47# _291_/a_27_47# 0
C9320 clknet_2_0__leaf_clk_regs _005_ 0.01607f
C9321 _079_ _080_ 0.16992f
C9322 net28 _296_/a_27_47# 0
C9323 VPWR _278_/a_193_47# 0.03704f
C9324 net7 _281_/a_651_413# 0.0075f
C9325 _302_/a_651_413# clknet_2_2__leaf_clk_regs 0.00126f
C9326 clknet_2_2__leaf_clk_regs genblk1\[9\].fa_inst.b 0.16122f
C9327 _047_ _031_ 0.00509f
C9328 net47 pmu_inst/dc_inst.x10/a_218_47# 0
C9329 _008_ net62 0
C9330 net2 _296_/a_193_47# 0.03161f
C9331 clknet_0_clk_regs _265_/a_805_47# 0
C9332 genblk1\[12\].fa_inst.s _097_ 0
C9333 _258_/a_1108_47# net57 0.00332f
C9334 net74 pmu_inst_74/HI 0.00428f
C9335 _294_/a_193_47# net6 0
C9336 _283_/a_543_47# _297_/a_193_47# 0
C9337 _283_/a_761_289# _297_/a_761_289# 0
C9338 _283_/a_193_47# _297_/a_543_47# 0
C9339 clknet_0_clk_regs genblk1\[10\].fa_inst.s 0
C9340 _282_/a_543_47# _297_/a_27_47# 0
C9341 _282_/a_193_47# _297_/a_761_289# 0
C9342 _282_/a_27_47# _297_/a_543_47# 0
C9343 net1 net9 0
C9344 VPWR a[2] 0.23766f
C9345 _258_/a_27_47# _259_/a_1283_21# 0
C9346 _264_/a_27_47# _009_ 0.01111f
C9347 _301_/a_651_413# VPWR 0.00109f
C9348 _255_/a_193_47# genblk1\[1\].fa_inst.s 0
C9349 VPWR pmu_inst/dc_inst.x7.net8 0.00989f
C9350 _004_ _258_/a_543_47# 0
C9351 _194_/a_377_297# _104_ 0.00143f
C9352 _290_/a_761_289# net36 0.00282f
C9353 _300_/a_1108_47# _045_ 0.00643f
C9354 _300_/a_448_47# net20 0.00252f
C9355 _138_/a_113_47# _058_ 0
C9356 _291_/a_1283_21# clknet_2_1__leaf_clk_regs 0
C9357 _292_/a_1270_413# _037_ -0
C9358 _292_/a_639_47# net27 0
C9359 _292_/a_1108_47# genblk1\[4\].fa_inst.b 0
C9360 net33 genblk1\[7\].fa_inst.b 0.03543f
C9361 net28 b[5] 0.00149f
C9362 _303_/a_1108_47# VPWR 0.00124f
C9363 clknet_2_0__leaf_clk_regs _145_/a_68_297# 0
C9364 net42 net34 0.03072f
C9365 net72 pmu_inst/dc_inst.x6.net4 -0
C9366 VPWR pmu_inst/dc_inst.x3.x20/a_27_47# 0
C9367 net34 _110_ 0
C9368 _269_/a_193_47# clknet_2_3__leaf_clk_regs 0.00961f
C9369 _300_/a_543_47# _286_/a_1283_21# 0
C9370 _274_/a_193_47# input10/a_75_212# 0
C9371 VPWR pmu_inst/dc_inst.x6.net9 0
C9372 VPWR _281_/a_1462_47# 0
C9373 fanout62/a_110_47# net62 0.00663f
C9374 _129_/a_129_47# net75 0.00128f
C9375 clk _262_/a_27_47# 0.21884f
C9376 _297_/a_1462_47# net30 0
C9377 net56 _059_ 0
C9378 _065_ _153_/a_27_413# 0.06603f
C9379 _293_/a_543_47# genblk1\[5\].fa_inst.b 0
C9380 _261_/a_27_47# _261_/a_193_47# -0.01782f
C9381 _015_ net62 0.25732f
C9382 genblk1\[13\].fa_inst.a genblk1\[13\].fa_inst.b 0.23438f
C9383 VPWR pmu_inst/dc_inst.x1.x10/a_27_47# 0
C9384 net28 _281_/a_27_47# 0
C9385 _274_/a_27_47# _274_/a_543_47# -0.00454f
C9386 _274_/a_193_47# _274_/a_761_289# -0.0105f
C9387 _269_/a_543_47# net60 0
C9388 _269_/a_1108_47# _268_/a_1283_21# 0
C9389 _269_/a_1283_21# _268_/a_1108_47# 0.00112f
C9390 _275_/a_27_47# a[4] 0.00142f
C9391 VPWR _158_/a_215_297# 0.00414f
C9392 net2 _281_/a_193_47# 0.02035f
C9393 net47 output47/a_27_47# 0.02077f
C9394 genblk1\[10\].fa_inst.a genblk1\[9\].fa_inst.a 0.13372f
C9395 VPWR input12/a_75_212# 0.09177f
C9396 VPWR _278_/a_1462_47# 0
C9397 _130_/a_215_297# hold1/a_49_47# 0.01281f
C9398 net3 _280_/a_193_47# 0.02212f
C9399 _054_ genblk1\[0\].fa_inst.a 0
C9400 _290_/a_1108_47# net25 0
C9401 _290_/a_1283_21# _035_ 0.01239f
C9402 _080_ _073_ 0.00181f
C9403 net41 cout_next 0.03072f
C9404 net28 _278_/a_27_47# 0
C9405 _275_/a_805_47# clknet_2_1__leaf_clk_regs 0
C9406 _275_/a_1108_47# genblk1\[1\].fa_inst.a 0
C9407 _022_ _277_/a_761_289# 0
C9408 _277_/a_1108_47# net56 0
C9409 _293_/a_27_47# _278_/a_1108_47# 0
C9410 _301_/a_193_47# _300_/a_27_47# 0
C9411 output55/a_27_47# tdo 0.03293f
C9412 _159_/a_47_47# _072_ 0
C9413 net33 _173_/a_27_413# 0
C9414 _110_ genblk1\[15\].fa_inst.s 0.08257f
C9415 VPWR pmu_inst/dc_inst.x4.net7 0
C9416 _264_/a_1217_47# _009_ 0
C9417 _199_/a_47_47# genblk1\[13\].fa_inst.s 0
C9418 _284_/a_1108_47# genblk1\[12\].fa_inst.a 0
C9419 _284_/a_1270_413# _029_ -0
C9420 net2 _278_/a_193_47# 0.01976f
C9421 s[9] net54 0.09627f
C9422 net29 net6 0.01621f
C9423 _184_/a_47_47# _093_ 0.00838f
C9424 net70 pmu_inst/dc_inst.x5.net14 -0
C9425 VPWR _170_/a_150_297# 0
C9426 net20 _045_ 0.00443f
C9427 _185_/a_68_297# net60 0
C9428 genblk1\[9\].fa_inst.b _297_/a_27_47# 0
C9429 net28 net4 0.01912f
C9430 net46 pmu_inst/dc_inst.x2.x13/a_27_47# 0
C9431 net27 genblk1\[4\].fa_inst.b 0
C9432 _072_ _070_ 0.00239f
C9433 _086_ _170_/a_68_297# 0
C9434 _049_ _143_/a_215_297# 0
C9435 net39 pmu_inst/dc_inst.x5.x16/a_27_47# 0.00296f
C9436 net47 pmu_inst/clkbuf_1_0__f_clk/a_110_47# 0.03375f
C9437 _269_/a_1462_47# clknet_2_3__leaf_clk_regs 0
C9438 net20 _286_/a_761_289# 0.00415f
C9439 _300_/a_193_47# _031_ 0
C9440 _274_/a_1270_413# net10 0
C9441 clkbuf_2_1__f_clk_regs/a_110_47# genblk1\[5\].fa_inst.s 0
C9442 _271_/a_761_289# net44 0.01859f
C9443 _266_/a_1283_21# net41 0.00184f
C9444 _169_/a_285_47# genblk1\[8\].fa_inst.s 0.00995f
C9445 _092_ _089_ 0.11466f
C9446 _097_ _093_ 0
C9447 clk _262_/a_543_47# 0.01763f
C9448 _256_/a_193_47# _255_/a_543_47# 0
C9449 _256_/a_543_47# _255_/a_193_47# 0
C9450 _256_/a_27_47# _255_/a_1283_21# 0.01005f
C9451 net3 net30 0.42901f
C9452 _283_/a_761_289# net59 0
C9453 _286_/a_27_47# _286_/a_543_47# -0.00835f
C9454 net27 _295_/a_193_47# 0.02232f
C9455 _282_/a_193_47# net59 0.01187f
C9456 _099_ _193_/a_215_297# 0.00994f
C9457 b[4] input28/a_75_212# 0
C9458 _283_/a_761_289# _298_/a_27_47# 0
C9459 _283_/a_27_47# _298_/a_761_289# 0
C9460 _283_/a_193_47# _298_/a_193_47# 0
C9461 _199_/a_47_47# _204_/a_561_297# 0
C9462 _272_/a_27_47# net56 0.22827f
C9463 _269_/a_543_47# _013_ 0
C9464 _014_ _268_/a_543_47# 0
C9465 _276_/a_193_47# VPWR 0.03425f
C9466 genblk1\[3\].fa_inst.b fanout56/a_27_47# 0
C9467 _036_ net58 0.00714f
C9468 _059_ _055_ 0
C9469 _066_ _072_ 0
C9470 net33 _071_ 0
C9471 _200_/a_59_75# net34 0
C9472 _103_ genblk1\[13\].fa_inst.b 0
C9473 _130_/a_382_47# _051_ 0
C9474 net6 input29/a_75_212# 0.01946f
C9475 genblk1\[13\].fa_inst.a genblk1\[14\].fa_inst.b 0
C9476 genblk1\[15\].fa_inst.a _105_ 0
C9477 _290_/a_543_47# genblk1\[2\].fa_inst.b 0
C9478 _080_ VPWR 0.61967f
C9479 _296_/a_27_47# _296_/a_193_47# -0
C9480 clk _264_/a_1283_21# 0.00121f
C9481 _304_/a_543_47# _057_ 0
C9482 net26 _279_/a_27_47# 0.0352f
C9483 net33 _040_ 0
C9484 net46 pmu_inst/dc_inst.x1.net10 0.00471f
C9485 net4 _284_/a_761_289# 0
C9486 _298_/a_805_47# net30 0
C9487 clk _266_/a_761_289# 0.00617f
C9488 _289_/a_1283_21# genblk1\[1\].fa_inst.b 0.00127f
C9489 _255_/a_543_47# VPWR 0.01437f
C9490 VPWR pmu_inst/dc_inst.x5.x20/a_27_47# 0.00307f
C9491 _292_/a_543_47# _277_/a_1108_47# 0
C9492 _189_/a_47_47# _104_ 0
C9493 _188_/a_27_413# _093_ 0.05491f
C9494 _188_/a_215_297# _094_ 0.00847f
C9495 net3 _283_/a_543_47# 0.02604f
C9496 net3 _282_/a_761_289# 0.00761f
C9497 genblk1\[11\].fa_inst.s _095_ 0
C9498 _294_/a_27_47# net62 0.04153f
C9499 genblk1\[7\].fa_inst.b _295_/a_543_47# 0
C9500 net7 _297_/a_543_47# 0.01531f
C9501 _301_/a_543_47# genblk1\[13\].fa_inst.b 0
C9502 _275_/a_761_289# clknet_2_0__leaf_clk_regs 0
C9503 _302_/a_1283_21# net60 0.03396f
C9504 net46 s[1] 0.09627f
C9505 _300_/a_761_289# clknet_2_2__leaf_clk_regs 0
C9506 _275_/a_27_47# VPWR 0.05887f
C9507 _200_/a_59_75# genblk1\[15\].fa_inst.a 0.05072f
C9508 _285_/a_639_47# clknet_2_2__leaf_clk_regs 0
C9509 _094_ genblk1\[11\].fa_inst.a 0.18575f
C9510 clknet_0_clk_regs net35 0
C9511 VPWR pmu_inst/_20_/a_79_21# 0.01026f
C9512 _021_ net58 0
C9513 _261_/a_543_47# net51 0
C9514 _261_/a_651_413# genblk1\[6\].fa_inst.s 0.00211f
C9515 fanout61/a_27_47# net61 0.06922f
C9516 genblk1\[0\].fa_inst.b _135_/a_298_297# 0
C9517 pmu_inst/dc_inst.x6.net9 net71 0
C9518 _277_/a_193_47# _291_/a_27_47# 0
C9519 genblk1\[14\].fa_inst.a genblk1\[13\].fa_inst.b 0.02707f
C9520 net39 pmu_inst/dc_inst.x1.net9 0.0013f
C9521 _291_/a_1108_47# VPWR 0.01109f
C9522 _277_/a_1283_21# _277_/a_1108_47# 0
C9523 _009_ _263_/a_761_289# 0
C9524 _282_/a_1462_47# net59 0
C9525 VPWR _265_/a_651_413# 0
C9526 _271_/a_761_289# VPWR 0.00663f
C9527 net60 net62 0.96808f
C9528 _274_/a_1270_413# _019_ -0
C9529 _274_/a_1108_47# genblk1\[2\].fa_inst.a 0.00182f
C9530 _143_/a_382_47# net36 0
C9531 _259_/a_761_289# net58 0
C9532 _272_/a_1217_47# net56 0
C9533 _281_/a_193_47# _296_/a_27_47# 0
C9534 _281_/a_27_47# _296_/a_193_47# 0
C9535 _274_/a_27_47# net9 0.0301f
C9536 VPWR _297_/a_1270_413# 0
C9537 _165_/a_150_297# genblk1\[7\].fa_inst.b 0
C9538 clknet_2_2__leaf_clk_regs _264_/a_1108_47# 0
C9539 net5 genblk1\[13\].fa_inst.a 0
C9540 VPWR pmu_inst/_07_ 0
C9541 _169_/a_285_47# _081_ 0
C9542 _290_/a_1108_47# clknet_2_1__leaf_clk_regs 0
C9543 pmu_inst/dc_inst.x7.net11 net35 0
C9544 VPWR _268_/a_27_47# 0.02556f
C9545 genblk1\[2\].fa_inst.s genblk1\[1\].fa_inst.s 0
C9546 net39 pmu_inst_70/HI 0.0017f
C9547 net27 _280_/a_1270_413# 0
C9548 _294_/a_27_47# net7 0
C9549 clknet_2_0__leaf_clk_regs genblk1\[0\].fa_inst.s 0.09162f
C9550 _051_ _134_/a_129_47# 0
C9551 _302_/a_761_289# net19 0
C9552 _302_/a_193_47# _287_/a_651_413# 0
C9553 _302_/a_1283_21# _287_/a_1283_21# 0
C9554 _302_/a_651_413# _287_/a_193_47# 0
C9555 _302_/a_1108_47# _287_/a_543_47# 0
C9556 _301_/a_651_413# net20 0
C9557 _194_/a_377_297# genblk1\[13\].fa_inst.s 0
C9558 _194_/a_285_47# _103_ 0.00598f
C9559 net7 _299_/a_543_47# 0
C9560 clknet_2_0__leaf_clk_regs _304_/a_1283_21# 0.04019f
C9561 _303_/a_27_47# b[15] 0.00411f
C9562 _149_/a_47_47# VPWR 0.03652f
C9563 net3 _279_/a_651_413# 0.00573f
C9564 _304_/a_761_289# VPWR -0
C9565 _280_/a_543_47# _295_/a_761_289# 0
C9566 _280_/a_761_289# _295_/a_543_47# 0
C9567 _280_/a_1283_21# _295_/a_193_47# 0
C9568 _178_/a_215_297# _174_/a_47_47# 0
C9569 _301_/a_543_47# _286_/a_1108_47# 0
C9570 _286_/a_27_47# b[11] 0.00391f
C9571 net7 net60 0.13959f
C9572 _077_ _081_ 0
C9573 _079_ _160_/a_68_297# 0
C9574 _275_/a_1217_47# VPWR 0
C9575 _158_/a_298_297# genblk1\[5\].fa_inst.b 0
C9576 _158_/a_215_297# _069_ 0.03625f
C9577 net4 _296_/a_193_47# 0.02025f
C9578 genblk1\[13\].fa_inst.a clknet_2_2__leaf_clk_regs 0
C9579 _148_/a_382_47# VPWR -0
C9580 _281_/a_27_47# _281_/a_193_47# -0.02346f
C9581 net7 genblk1\[10\].fa_inst.b 0
C9582 _288_/a_27_47# _288_/a_543_47# -0.00482f
C9583 net5 input28/a_75_212# 0.00552f
C9584 net39 pmu_inst/dc_inst.x5.net6 0.0199f
C9585 _290_/a_1108_47# net11 0.00747f
C9586 _068_ _153_/a_298_297# 0.00362f
C9587 _260_/a_193_47# _005_ 0.00741f
C9588 net39 pmu_inst/dc_inst.x4.net16 0.01604f
C9589 _256_/a_805_47# genblk1\[0\].fa_inst.s 0
C9590 _286_/a_1108_47# genblk1\[14\].fa_inst.a 0
C9591 net24 a[13] 0
C9592 _054_ net75 0.06838f
C9593 net47 pmu_inst/_23_/a_1108_47# 0.00314f
C9594 _293_/a_1270_413# VPWR -0
C9595 clk _007_ 0.28199f
C9596 _280_/a_27_47# _280_/a_193_47# -0.00487f
C9597 net26 VPWR 1.56126f
C9598 input36/a_27_47# net34 0.02529f
C9599 VPWR pmu_inst/dc_inst.x5.x9/a_27_47# 0
C9600 _028_ _298_/a_651_413# 0
C9601 genblk1\[11\].fa_inst.a _298_/a_1283_21# 0
C9602 _289_/a_761_289# net12 0.00224f
C9603 _143_/a_27_413# _143_/a_215_297# 0
C9604 clknet_2_1__leaf_clk_regs _261_/a_448_47# 0.00191f
C9605 clkbuf_regs_0_clk/a_110_47# net52 0
C9606 _013_ net62 0
C9607 clkbuf_2_3__f_clk_regs/a_110_47# net61 0.00503f
C9608 _294_/a_761_289# _279_/a_27_47# 0
C9609 net33 genblk1\[9\].fa_inst.b 0.03552f
C9610 _274_/a_1217_47# net9 0
C9611 net39 pmu_inst/dc_inst.x1.net4 0
C9612 _257_/a_639_47# clknet_2_0__leaf_clk_regs 0
C9613 VPWR _267_/a_27_47# 0.07142f
C9614 _277_/a_193_47# net56 0.00184f
C9615 net7 _298_/a_193_47# 0.03315f
C9616 net44 net34 0.0271f
C9617 _137_/a_113_47# genblk1\[2\].fa_inst.b 0
C9618 _259_/a_543_47# genblk1\[3\].fa_inst.s 0
C9619 net13 _279_/a_448_47# 0
C9620 _257_/a_651_413# VPWR 0
C9621 net25 clknet_2_1__leaf_clk_regs 0.20687f
C9622 _295_/a_543_47# _040_ 0.00261f
C9623 _295_/a_1283_21# net30 0.00165f
C9624 VPWR _178_/a_215_297# 0
C9625 genblk1\[14\].fa_inst.a genblk1\[14\].fa_inst.b 0.64602f
C9626 genblk1\[4\].fa_inst.a _035_ 0
C9627 _276_/a_27_47# net12 0.00835f
C9628 _296_/a_448_47# _041_ -0
C9629 net29 net31 1.46221f
C9630 _301_/a_27_47# _301_/a_761_289# -0
C9631 pmu_inst/dc_inst.net4 net72 -0
C9632 _178_/a_27_413# _086_ 0.03282f
C9633 genblk1\[4\].fa_inst.b net58 0.00145f
C9634 VPWR pmu_inst/dc_inst.x9/a_1290_413# 0
C9635 _276_/a_543_47# _290_/a_27_47# 0
C9636 net46 pmu_inst/_19_/a_27_47# 0.01616f
C9637 VPWR _132_/a_113_47# -0
C9638 VPWR pmu_inst/dc_inst.x6.x19/a_27_47# 0.00293f
C9639 _047_ _287_/a_761_289# 0
C9640 _046_ _045_ 0
C9641 input5/a_27_47# a[13] 0.01944f
C9642 net58 _261_/a_1270_413# 0
C9643 _287_/a_1283_21# net7 0
C9644 net4 _281_/a_193_47# 0.02413f
C9645 _173_/a_298_297# _082_ 0.00166f
C9646 _173_/a_215_297# _081_ 0.08541f
C9647 _303_/a_805_47# net23 0
C9648 net46 pmu_inst/dc_inst.x1.x13/a_27_47# 0.00239f
C9649 clkbuf_2_0__f_clk_regs/a_110_47# clknet_0_clk_regs 0.0076f
C9650 net27 _279_/a_543_47# 0.00533f
C9651 _280_/a_27_47# net30 0
C9652 _301_/a_761_289# _031_ 0.01692f
C9653 _143_/a_298_297# _059_ 0
C9654 net58 _295_/a_193_47# 0.00535f
C9655 _257_/a_761_289# _001_ 0
C9656 net49 _259_/a_1283_21# 0.00184f
C9657 _278_/a_27_47# _278_/a_193_47# -0.05059f
C9658 clk _263_/a_448_47# 0.00903f
C9659 VPWR _298_/a_448_47# 0
C9660 clkload0/a_27_47# _260_/a_27_47# 0.00444f
C9661 _080_ _075_ 0.0012f
C9662 _286_/a_639_47# clknet_2_2__leaf_clk_regs 0
C9663 net14 a[9] 0
C9664 net25 net11 0
C9665 net47 pmu_inst/dc_inst.x7.x11/a_27_47# 0.00293f
C9666 _300_/a_193_47# _299_/a_193_47# 0
C9667 _012_ net62 0.00808f
C9668 net44 genblk1\[15\].fa_inst.s 0
C9669 _001_ net39 0.00209f
C9670 net46 _000_ 0
C9671 net46 pmu_inst/dc_inst.x4.x6/a_27_47# 0.00583f
C9672 net47 pmu_inst/dc_inst.x7.x18/a_27_47# 0.00248f
C9673 net25 _279_/a_193_47# 0
C9674 _077_ genblk1\[8\].fa_inst.a 0
C9675 genblk1\[8\].fa_inst.b _082_ 0.08789f
C9676 net61 genblk1\[9\].fa_inst.s 0
C9677 _276_/a_1283_21# fanout56/a_27_47# 0
C9678 net4 _278_/a_193_47# 0.03382f
C9679 clk clknet_0_clk 0.02151f
C9680 VPWR _287_/a_639_47# 0
C9681 _285_/a_1283_21# clknet_2_3__leaf_clk_regs 0.00387f
C9682 _293_/a_651_413# VPWR 0
C9683 clknet_2_1__leaf_clk_regs _006_ 0.00101f
C9684 fanout58/a_27_47# _262_/a_1108_47# 0.01235f
C9685 _281_/a_651_413# net31 0
C9686 _271_/a_1283_21# cout_next 0
C9687 _292_/a_805_47# clknet_2_0__leaf_clk_regs 0.00209f
C9688 _273_/a_1283_21# clknet_2_1__leaf_clk_regs 0
C9689 _273_/a_761_289# _018_ 0
C9690 genblk1\[7\].fa_inst.s genblk1\[6\].fa_inst.s 0
C9691 _292_/a_1270_413# VPWR 0
C9692 _292_/a_543_47# _277_/a_193_47# 0
C9693 _293_/a_27_47# _023_ 0.0023f
C9694 _270_/a_448_47# clk 0
C9695 net26 net2 0.03367f
C9696 _054_ genblk1\[1\].fa_inst.b 0.09959f
C9697 net58 _262_/a_1462_47# 0
C9698 _096_ _090_ 0.04489f
C9699 input19/a_75_212# b[11] 0.0165f
C9700 net47 pmu_inst/_03_ 0.02671f
C9701 clkbuf_2_2__f_clk_regs/a_110_47# _091_ 0.01781f
C9702 net12 net14 0
C9703 net46 pmu_inst/dc_inst.x4.net11 0
C9704 _275_/a_27_47# _274_/a_193_47# 0
C9705 _275_/a_193_47# _274_/a_27_47# 0
C9706 _273_/a_27_47# _272_/a_27_47# 0
C9707 _294_/a_27_47# net6 0
C9708 _269_/a_1283_21# _269_/a_1108_47# -0
C9709 _263_/a_1283_21# _008_ 0.05464f
C9710 _263_/a_193_47# net53 0
C9711 VPWR net34 19.92366f
C9712 genblk1\[2\].fa_inst.a net17 0.03111f
C9713 _054_ _288_/a_1283_21# 0
C9714 net47 pmu_inst_66/HI 0
C9715 _049_ _058_ 0
C9716 _290_/a_448_47# VPWR 0.00107f
C9717 a[10] a[11] 0.07915f
C9718 net39 pmu_inst/_17_/a_478_47# 0.00176f
C9719 _258_/a_761_289# net36 0.00634f
C9720 clknet_2_1__leaf_clk_regs _280_/a_448_47# 0
C9721 _301_/a_543_47# clknet_2_2__leaf_clk_regs 0
C9722 genblk1\[7\].fa_inst.b net62 0
C9723 net27 genblk1\[10\].fa_inst.a 0
C9724 hold1/a_49_47# _055_ 0.04285f
C9725 _294_/a_761_289# VPWR 0.01366f
C9726 clk _008_ 0.00785f
C9727 _268_/a_27_47# genblk1\[14\].fa_inst.s 0
C9728 VPWR _043_ 0.10096f
C9729 clknet_2_0__leaf_clk_regs net36 0.05226f
C9730 _281_/a_1283_21# net16 0
C9731 genblk1\[8\].fa_inst.a _173_/a_215_297# 0
C9732 clkload0/Y _260_/a_1108_47# 0.00166f
C9733 VPWR pmu_inst/dc_inst.x5.net8 0
C9734 net46 pmu_inst/dc_inst.x6.x7/a_27_47# 0
C9735 _144_/a_47_47# _063_ 0.00706f
C9736 _281_/a_543_47# genblk1\[9\].fa_inst.a 0
C9737 _281_/a_448_47# _026_ 0
C9738 _284_/a_1283_21# clknet_2_3__leaf_clk_regs 0
C9739 genblk1\[14\].fa_inst.a clknet_2_2__leaf_clk_regs 0
C9740 _288_/a_639_47# net17 0
C9741 VPWR _160_/a_68_297# 0.02713f
C9742 _283_/a_761_289# net30 0.01709f
C9743 _282_/a_193_47# net30 0.03131f
C9744 net49 net58 0
C9745 _293_/a_193_47# _293_/a_761_289# -0.0105f
C9746 _280_/a_543_47# genblk1\[8\].fa_inst.a 0
C9747 _280_/a_448_47# _025_ 0
C9748 _264_/a_543_47# net59 0.00165f
C9749 _289_/a_27_47# net56 0
C9750 net58 _280_/a_1270_413# 0
C9751 VPWR genblk1\[15\].fa_inst.a 0.48076f
C9752 genblk1\[13\].fa_inst.a _299_/a_27_47# 0
C9753 _285_/a_1283_21# net19 0.01543f
C9754 tdo net70 0.26645f
C9755 _026_ _041_ 0
C9756 net40 cout_next 0.02886f
C9757 net5 net16 0
C9758 VPWR pmu_inst/dc_inst.x6.net6 0.00277f
C9759 input2/a_27_47# net13 0
C9760 VPWR genblk1\[15\].fa_inst.s 1.47287f
C9761 _300_/a_805_47# net60 0
C9762 _275_/a_448_47# net10 0.00197f
C9763 _273_/a_805_47# genblk1\[1\].fa_inst.a 0
C9764 genblk1\[2\].fa_inst.b _057_ 0
C9765 net47 pmu_inst/dc_inst.x7.net19 0.00743f
C9766 _293_/a_761_289# _038_ -0.00655f
C9767 net6 _298_/a_193_47# 0
C9768 _277_/a_761_289# _291_/a_543_47# 0
C9769 _015_ clk 0
C9770 _030_ net60 0.01908f
C9771 _022_ _036_ 0
C9772 net60 _101_ 0
C9773 genblk1\[7\].fa_inst.b net7 0
C9774 VPWR _261_/a_651_413# 0
C9775 _083_ VPWR 0.25048f
C9776 _273_/a_1108_47# _272_/a_448_47# 0
C9777 net29 _297_/a_193_47# 0.01977f
C9778 _269_/a_543_47# _014_ 0.00231f
C9779 _269_/a_27_47# net44 0
C9780 clkbuf_1_0__f_clk/a_110_47# net62 0.0069f
C9781 _263_/a_1462_47# net53 0
C9782 net46 pmu_inst/dc_inst.x2.net18 0
C9783 _284_/a_651_413# net59 0
C9784 _144_/a_47_47# _057_ 0
C9785 _270_/a_1283_21# _015_ 0.03789f
C9786 _270_/a_193_47# net45 0
C9787 _035_ VPWR 0.17494f
C9788 _079_ genblk1\[7\].fa_inst.s 0.00465f
C9789 VPWR _295_/a_27_47# 0.08423f
C9790 _284_/a_193_47# _298_/a_448_47# 0
C9791 net10 net56 0
C9792 _135_/a_298_297# _053_ 0.0148f
C9793 a[7] input15/a_75_212# 0
C9794 input14/a_75_212# a[8] 0.00367f
C9795 clknet_2_1__leaf_clk_regs _025_ -0
C9796 _303_/a_27_47# genblk1\[15\].fa_inst.b 0
C9797 VPWR output41/a_27_47# 0.07863f
C9798 _278_/a_543_47# genblk1\[6\].fa_inst.a 0
C9799 net61 cout_next 0.02963f
C9800 clknet_2_2__leaf_clk_regs net16 0.01122f
C9801 _285_/a_761_289# net18 0.00498f
C9802 net17 net16 0.02347f
C9803 _275_/a_193_47# _288_/a_27_47# 0
C9804 _275_/a_27_47# _288_/a_193_47# 0
C9805 clknet_2_1__leaf_clk_regs net11 0.09142f
C9806 s[3] VPWR 0.38857f
C9807 clknet_2_1__leaf_clk_regs _279_/a_193_47# 0.00202f
C9808 _168_/a_215_297# _084_ 0.00267f
C9809 genblk1\[12\].fa_inst.a _299_/a_27_47# 0
C9810 _284_/a_1283_21# net19 0
C9811 _300_/a_1270_413# net19 0
C9812 _053_ genblk1\[1\].fa_inst.s 0.00188f
C9813 _158_/a_215_297# _070_ 0.00143f
C9814 net61 _264_/a_448_47# 0
C9815 _293_/a_543_47# _293_/a_193_47# -0.01017f
C9816 net7 _295_/a_448_47# 0.0067f
C9817 clknet_0_clk_regs net62 0.95211f
C9818 net46 pmu_inst/dc_inst.x2.x14/a_27_47# 0
C9819 net33 _074_ 0
C9820 _286_/a_1283_21# clknet_2_3__leaf_clk_regs 0
C9821 clk _265_/a_761_289# 0.00617f
C9822 _029_ net60 0
C9823 net61 _266_/a_1283_21# 0.02464f
C9824 a[10] net36 0
C9825 _020_ net10 0
C9826 _293_/a_1108_47# genblk1\[6\].fa_inst.a 0.03993f
C9827 VPWR pmu_inst/dc_inst.x1.net14 0.00273f
C9828 _135_/a_382_47# _057_ 0.00106f
C9829 cout_next net73 0
C9830 _293_/a_543_47# _038_ -0
C9831 net26 _296_/a_27_47# 0.00185f
C9832 _259_/a_639_47# net36 0
C9833 _259_/a_193_47# clknet_2_0__leaf_clk_regs 0.04258f
C9834 cout_next _205_/a_47_47# 0
C9835 input35/a_27_47# net34 0.00599f
C9836 VPWR pmu_inst/dc_inst.x5.net10 0
C9837 net58 _279_/a_543_47# 0
C9838 _294_/a_193_47# net3 0.02974f
C9839 net7 _280_/a_761_289# 0.00964f
C9840 _273_/a_651_413# clknet_2_0__leaf_clk_regs 0
C9841 _275_/a_543_47# genblk1\[2\].fa_inst.a 0.0027f
C9842 net47 cout_next 0.02535f
C9843 _276_/a_805_47# _035_ 0
C9844 _294_/a_543_47# _279_/a_543_47# 0
C9845 _297_/a_543_47# net31 0.0029f
C9846 VPWR _089_ 0.04717f
C9847 _154_/a_47_47# _072_ 0.04748f
C9848 genblk1\[8\].fa_inst.b genblk1\[10\].fa_inst.a 0
C9849 _255_/a_543_47# net57 0
C9850 net47 pmu_inst/dc_inst.x3.x14/a_27_47# 0.00177f
C9851 _158_/a_298_297# _076_ 0.00465f
C9852 b[14] b[15] 0.07915f
C9853 _273_/a_1108_47# VPWR 0.01753f
C9854 _270_/a_1462_47# net45 0
C9855 VPWR _295_/a_1217_47# 0
C9856 _199_/a_47_47# _110_ 0.0411f
C9857 _107_ _205_/a_47_47# 0
C9858 _284_/a_193_47# _043_ 0
C9859 _029_ _298_/a_193_47# 0
C9860 _272_/a_193_47# _272_/a_761_289# -0.00517f
C9861 _272_/a_27_47# _272_/a_543_47# -0.00482f
C9862 net48 output48/a_27_47# 0.01331f
C9863 _303_/a_1217_47# genblk1\[15\].fa_inst.b 0
C9864 VPWR _269_/a_27_47# 0.073f
C9865 _304_/a_27_47# _288_/a_543_47# 0
C9866 genblk1\[4\].fa_inst.a _153_/a_27_413# 0
C9867 net33 genblk1\[13\].fa_inst.a 0.26165f
C9868 clkload2/a_27_47# _265_/a_193_47# 0
C9869 _163_/a_27_413# _076_ 0
C9870 _268_/a_193_47# genblk1\[13\].fa_inst.s 0.08962f
C9871 input34/a_27_47# delay_sel[2] 0.00686f
C9872 delay_sel[0] input36/a_27_47# 0.00347f
C9873 net39 pmu_inst/dc_inst.x5.net3 0.0082f
C9874 _052_ genblk1\[0\].fa_inst.b 0.00455f
C9875 clknet_2_0__leaf_clk_regs _134_/a_47_47# 0
C9876 _159_/a_129_47# _076_ 0.00126f
C9877 _273_/a_193_47# net8 0.06404f
C9878 net39 pmu_inst/dc_inst.x6.x9/a_27_47# 0.002f
C9879 _163_/a_215_297# genblk1\[6\].fa_inst.a 0
C9880 _036_ net24 0
C9881 _019_ net56 0.01527f
C9882 _143_/a_27_413# _058_ 0.01344f
C9883 a[13] net15 0.12625f
C9884 net2 _295_/a_27_47# 0.0267f
C9885 VPWR _280_/a_651_413# 0.00128f
C9886 _291_/a_27_47# a[9] 0
C9887 _266_/a_543_47# net35 0
C9888 net39 pmu_inst/dc_inst.x2.x15/a_27_47# 0.00127f
C9889 _080_ _159_/a_47_47# 0
C9890 net61 _009_ 0.00364f
C9891 fanout59/a_27_47# net54 0.0398f
C9892 _177_/a_113_47# _090_ 0
C9893 _276_/a_761_289# _036_ 0
C9894 net7 _040_ 0.00118f
C9895 net26 _281_/a_27_47# 0.04106f
C9896 _301_/a_27_47# net60 0.01296f
C9897 b[12] b[13] 0.06434f
C9898 b[8] b[9] 0.07915f
C9899 VPWR b[3] 0.23717f
C9900 _286_/a_1283_21# net19 0.05641f
C9901 _138_/a_113_47# net56 0
C9902 input17/a_27_47# b[0] 0.014f
C9903 clknet_2_2__leaf_clk_regs _297_/a_1283_21# 0.04925f
C9904 net71 pmu_inst/dc_inst.x6.net6 -0
C9905 _259_/a_27_47# net36 0.00508f
C9906 _188_/a_27_413# _097_ 0
C9907 _288_/a_448_47# net56 0
C9908 _256_/a_193_47# genblk1\[1\].fa_inst.s 0.06368f
C9909 _062_ net36 0.08943f
C9910 _031_ net60 0.0372f
C9911 clk net60 0.02588f
C9912 net3 net14 0.0229f
C9913 input33/a_27_47# net34 0.01444f
C9914 _270_/a_761_289# clknet_2_3__leaf_clk_regs 0.04309f
C9915 _014_ net62 0
C9916 _020_ _019_ 0
C9917 _291_/a_27_47# net12 0.00149f
C9918 genblk1\[3\].fa_inst.b _061_ 0.11506f
C9919 _292_/a_193_47# net14 0
C9920 net26 _278_/a_27_47# 0.03299f
C9921 _294_/a_1462_47# VPWR 0.00209f
C9922 _263_/a_1108_47# net59 0.00207f
C9923 _304_/a_805_47# genblk1\[1\].fa_inst.b 0
C9924 net52 _262_/a_761_289# 0
C9925 net3 _296_/a_651_413# 0.00523f
C9926 net29 net3 0.10157f
C9927 _199_/a_47_47# _105_ 0.00259f
C9928 _107_ _195_/a_68_297# 0
C9929 net33 genblk1\[12\].fa_inst.a 0.17318f
C9930 _018_ net1 0
C9931 VPWR _135_/a_298_297# 0
C9932 _258_/a_1108_47# genblk1\[3\].fa_inst.s 0
C9933 _021_ net24 0
C9934 clknet_2_1__leaf_clk_regs _072_ 0
C9935 _282_/a_1270_413# _027_ -0
C9936 _282_/a_1108_47# genblk1\[10\].fa_inst.a 0
C9937 genblk1\[14\].fa_inst.s genblk1\[15\].fa_inst.s 0
C9938 net52 cout_next 0.02886f
C9939 net46 pmu_inst/dc_inst.x4.x3/a_27_47# 0
C9940 genblk1\[10\].fa_inst.b net31 0
C9941 net7 _282_/a_543_47# 0.01647f
C9942 genblk1\[7\].fa_inst.s VPWR 0.12984f
C9943 net26 net4 0.02181f
C9944 _290_/a_27_47# a[7] 0.00386f
C9945 _276_/a_761_289# _021_ 0
C9946 genblk1\[3\].fa_inst.a _288_/a_543_47# 0.03909f
C9947 fanout60/a_27_47# _268_/a_1283_21# 0
C9948 net39 pmu_inst/dc_inst.x2.net8 0.0029f
C9949 cin_q _304_/a_27_47# 0
C9950 VPWR genblk1\[1\].fa_inst.s 0.58417f
C9951 net59 _041_ 0.28072f
C9952 _303_/a_651_413# clknet_2_3__leaf_clk_regs 0
C9953 _184_/a_377_297# VPWR -0
C9954 clknet_1_0__leaf_clk net35 0
C9955 genblk1\[4\].fa_inst.b genblk1\[5\].fa_inst.b 0.00203f
C9956 a[11] a[12] 0.07915f
C9957 net62 _279_/a_1270_413# 0
C9958 _298_/a_193_47# net31 0.02233f
C9959 net13 a[7] 0.02825f
C9960 _301_/a_1217_47# net60 0
C9961 _184_/a_285_47# _090_ 0
C9962 VPWR delay_sel[0] 0.24726f
C9963 _303_/a_639_47# net60 0
C9964 _054_ genblk1\[0\].fa_inst.s 0
C9965 VPWR _283_/a_639_47# 0
C9966 _255_/a_27_47# _255_/a_1108_47# -0
C9967 net39 pmu_inst/dc_inst.x4.net14 0.00397f
C9968 VPWR _279_/a_761_289# 0.01072f
C9969 VPWR _282_/a_1270_413# 0
C9970 _033_ net56 0.04215f
C9971 genblk1\[2\].fa_inst.a net33 0.02888f
C9972 _257_/a_651_413# net57 0.00442f
C9973 net3 _281_/a_651_413# 0.00348f
C9974 _302_/a_193_47# VPWR -0.0659f
C9975 genblk1\[0\].fa_inst.b _288_/a_543_47# 0
C9976 net39 pmu_inst/dc_inst.x6.net11 0.00175f
C9977 _054_ _304_/a_1283_21# 0
C9978 pmu_inst/dc_inst.x3.net10 cout_next 0
C9979 genblk1\[8\].fa_inst.a genblk1\[7\].fa_inst.a 0.09479f
C9980 clk _267_/a_448_47# 0.00484f
C9981 genblk1\[12\].fa_inst.a net35 0.09443f
C9982 VPWR pmu_inst/dc_inst.x1.x9/a_27_47# 0
C9983 _276_/a_1108_47# clknet_2_1__leaf_clk_regs 0
C9984 net2 b[3] 0
C9985 VPWR pmu_inst/_15_/a_788_316# 0.00274f
C9986 net4 _298_/a_448_47# 0
C9987 clk _013_ 0
C9988 cout_next net51 0.02886f
C9989 _130_/a_298_297# _050_ 0.00258f
C9990 net27 _296_/a_543_47# 0.00324f
C9991 _028_ genblk1\[10\].fa_inst.a 0
C9992 net33 _303_/a_193_47# 0
C9993 net46 pmu_inst/dc_inst.x5.x16/a_27_47# 0
C9994 net39 pmu_inst/dc_inst.x2.x6/a_27_47# 0.0015f
C9995 _037_ _277_/a_761_289# 0
C9996 _293_/a_27_47# genblk1\[5\].fa_inst.a 0
C9997 input4/a_27_47# net13 0
C9998 _279_/a_1283_21# genblk1\[7\].fa_inst.a 0.00293f
C9999 _272_/a_1270_413# _017_ -0
C10000 _272_/a_805_47# clknet_2_0__leaf_clk_regs 0
C10001 _272_/a_1108_47# genblk1\[0\].fa_inst.a 0
C10002 _026_ net59 0.20739f
C10003 clknet_0_clk_regs _264_/a_761_289# 0
C10004 net35 input18/a_75_212# 0.00264f
C10005 net12 net56 0
C10006 _272_/a_1270_413# VPWR -0
C10007 _259_/a_27_47# _259_/a_193_47# -0.02346f
C10008 net3 _278_/a_651_413# 0.00573f
C10009 net28 clknet_2_1__leaf_clk_regs 0.07812f
C10010 _168_/a_215_297# _078_ 0.0035f
C10011 net33 genblk1\[14\].fa_inst.a 0.28758f
C10012 _302_/a_1108_47# _047_ 0.00595f
C10013 _302_/a_448_47# net22 0.00196f
C10014 clknet_2_2__leaf_clk_regs _298_/a_761_289# 0
C10015 _302_/a_651_413# net7 0.00573f
C10016 net7 genblk1\[9\].fa_inst.b 0
C10017 cin_q _304_/a_1217_47# 0
C10018 _277_/a_651_413# _035_ 0
C10019 _188_/a_215_297# VPWR 0.00239f
C10020 net6 input32/a_75_212# 0.02109f
C10021 VPWR _153_/a_27_413# 0.0513f
C10022 _188_/a_215_297# _100_ 0.01819f
C10023 _273_/a_193_47# a[3] 0
C10024 _273_/a_27_47# net10 0
C10025 _259_/a_448_47# net36 0.00113f
C10026 _270_/a_1270_413# net61 0
C10027 _276_/a_1108_47# net11 0
C10028 _205_/a_47_47# _204_/a_33_297# 0
C10029 _269_/a_27_47# genblk1\[14\].fa_inst.s 0.04053f
C10030 net28 _025_ 0
C10031 _274_/a_448_47# _273_/a_27_47# 0
C10032 _274_/a_543_47# _273_/a_543_47# 0.00125f
C10033 _274_/a_1108_47# _273_/a_193_47# 0.00171f
C10034 _274_/a_1283_21# _273_/a_761_289# 0.0016f
C10035 genblk1\[15\].fa_inst.b net60 0.05761f
C10036 VPWR _174_/a_129_47# -0
C10037 VPWR genblk1\[11\].fa_inst.a 1.0501f
C10038 _100_ genblk1\[11\].fa_inst.a 0
C10039 _255_/a_27_47# genblk1\[0\].fa_inst.s 0.07041f
C10040 _292_/a_27_47# net16 0.03418f
C10041 _271_/a_193_47# _271_/a_761_289# -0.00517f
C10042 _265_/a_543_47# genblk1\[10\].fa_inst.s 0.00118f
C10043 _302_/a_1462_47# VPWR 0
C10044 genblk1\[11\].fa_inst.b _180_/a_68_297# 0.037f
C10045 _256_/a_543_47# VPWR 0.01627f
C10046 net46 pmu_inst/dc_inst.x7.net1 0
C10047 _063_ _141_/a_113_47# 0
C10048 _292_/a_1283_21# net17 0.01038f
C10049 net13 _278_/a_448_47# 0.00196f
C10050 net27 _281_/a_543_47# 0.00531f
C10051 _179_/a_129_47# genblk1\[10\].fa_inst.s 0
C10052 _016_ fanout62/a_110_47# 0.00308f
C10053 clk _012_ 0.00199f
C10054 _131_/a_68_297# net56 0
C10055 genblk1\[6\].fa_inst.b _163_/a_215_297# 0.00115f
C10056 _303_/a_1283_21# net34 0.03506f
C10057 _303_/a_193_47# net35 0.01426f
C10058 net28 _279_/a_193_47# 0
C10059 _094_ _181_/a_113_47# 0
C10060 _035_ _034_ 0.00115f
C10061 net24 _295_/a_193_47# 0
C10062 VPWR pmu_inst/dc_inst.x1.x4/a_27_47# 0.0065f
C10063 _294_/a_761_289# net4 0
C10064 net4 _043_ 0
C10065 genblk1\[12\].fa_inst.s _267_/a_27_47# 0.10434f
C10066 VPWR b[8] 0.23717f
C10067 cin_q genblk1\[2\].fa_inst.s 0
C10068 _258_/a_448_47# VPWR 0
C10069 _281_/a_27_47# _295_/a_27_47# 0
C10070 a[12] net36 0
C10071 _277_/a_543_47# _036_ 0.0021f
C10072 clkbuf_2_1__f_clk_regs/a_110_47# _076_ 0.00337f
C10073 net25 _281_/a_193_47# 0
C10074 genblk1\[0\].fa_inst.a net1 0
C10075 net22 _047_ 0.00427f
C10076 net72 pmu_inst/dc_inst.x5.x20/a_27_47# -0
C10077 net50 pmu_inst_74/HI 0.04894f
C10078 net27 _278_/a_543_47# 0.00531f
C10079 net46 pmu_inst/dc_inst.x1.net9 0.02004f
C10080 clkbuf_2_0__f_clk_regs/a_110_47# _260_/a_27_47# 0
C10081 _303_/a_761_289# net36 0.00151f
C10082 _277_/a_27_47# _292_/a_27_47# 0
C10083 _169_/a_47_47# _168_/a_215_297# 0
C10084 genblk1\[11\].fa_inst.b _299_/a_761_289# 0
C10085 net39 pmu_inst/_16_/a_27_93# 0.00327f
C10086 clknet_2_1__leaf_clk_regs input10/a_75_212# 0.00354f
C10087 _261_/a_1283_21# _005_ 0
C10088 net59 _297_/a_761_289# 0.00527f
C10089 clknet_2_0__leaf_clk_regs net8 0
C10090 net69 net66 -0.00973f
C10091 _290_/a_193_47# net12 0.03017f
C10092 VPWR pmu_inst_63/HI 0.03483f
C10093 VPWR pmu_inst/dc_inst.x3.x2/a_27_47# 0
C10094 net25 _278_/a_193_47# 0
C10095 input34/a_27_47# delay_sel[1] 0.07465f
C10096 delay_sel[0] input35/a_27_47# 0
C10097 genblk1\[12\].fa_inst.b genblk1\[13\].fa_inst.b 0
C10098 net1 a[1] 0.10511f
C10099 a[0] net8 0
C10100 _274_/a_27_47# _018_ 0.00124f
C10101 _274_/a_761_289# clknet_2_1__leaf_clk_regs 0.00172f
C10102 _019_ _273_/a_27_47# 0.00532f
C10103 genblk1\[14\].fa_inst.a _195_/a_150_297# 0
C10104 _275_/a_1283_21# net56 0.01847f
C10105 _291_/a_27_47# genblk1\[3\].fa_inst.b -0
C10106 _291_/a_543_47# _036_ 0.00438f
C10107 net29 _280_/a_27_47# 0.02765f
C10108 _265_/a_1283_21# net40 0.00589f
C10109 _094_ _095_ 0.01102f
C10110 _255_/a_651_413# net39 0
C10111 _255_/a_1217_47# genblk1\[0\].fa_inst.s 0
C10112 _277_/a_1283_21# net12 0
C10113 _271_/a_1283_21# clknet_2_3__leaf_clk_regs 0
C10114 _258_/a_193_47# net48 0.00114f
C10115 _258_/a_1283_21# _003_ 0.00487f
C10116 net4 _295_/a_27_47# 0.01821f
C10117 net24 genblk1\[2\].fa_inst.b 0
C10118 genblk1\[8\].fa_inst.b _296_/a_543_47# 0
C10119 net75 _056_ 0.20961f
C10120 _304_/a_193_47# _304_/a_761_289# -0.0105f
C10121 _304_/a_27_47# _304_/a_543_47# -0.00454f
C10122 net60 _299_/a_193_47# 0.03887f
C10123 genblk1\[12\].fa_inst.s _267_/a_1217_47# 0
C10124 pmu_inst/dc_inst.x7.net12 net35 0
C10125 net6 b[0] 0.04303f
C10126 _297_/a_639_47# _042_ -0
C10127 _003_ VPWR 0.27402f
C10128 _270_/a_805_47# genblk1\[15\].fa_inst.s 0
C10129 _268_/a_761_289# clknet_2_3__leaf_clk_regs 0.00298f
C10130 _131_/a_68_297# _055_ 0
C10131 _039_ _280_/a_1108_47# 0
C10132 net3 _297_/a_543_47# 0.01231f
C10133 _276_/a_651_413# _035_ 0.00829f
C10134 net39 pmu_inst/_19_/a_109_297# 0.00131f
C10135 net46 pmu_inst/dc_inst.x5.net6 0.02103f
C10136 _256_/a_448_47# net46 0
C10137 net46 pmu_inst/dc_inst.x4.net16 0
C10138 _275_/a_1283_21# _020_ 0.05555f
C10139 _275_/a_193_47# genblk1\[3\].fa_inst.a 0
C10140 net61 _265_/a_1283_21# 0.01734f
C10141 _268_/a_1283_21# net60 0
C10142 _274_/a_761_289# net11 0
C10143 clk clkbuf_1_0__f_clk/a_110_47# 0.08492f
C10144 VPWR _285_/a_543_47# 0.02949f
C10145 net46 net69 0.00204f
C10146 _169_/a_129_47# _084_ 0.00183f
C10147 _077_ net17 0
C10148 net46 pmu_inst/dc_inst.x1.net4 0
C10149 _276_/a_193_47# _290_/a_1108_47# 0
C10150 _021_ _291_/a_543_47# 0
C10151 _260_/a_448_47# genblk1\[5\].fa_inst.s 0.00158f
C10152 _186_/a_113_47# genblk1\[12\].fa_inst.a 0
C10153 _293_/a_448_47# net17 0.00336f
C10154 _074_ _156_/a_113_47# 0
C10155 _264_/a_1108_47# net62 0
C10156 net62 _074_ 0
C10157 _304_/a_448_47# net56 0
C10158 _289_/a_651_413# net11 0.00739f
C10159 _104_ _191_/a_113_47# 0
C10160 _284_/a_193_47# genblk1\[11\].fa_inst.a 0
C10161 net75 _057_ 0
C10162 clknet_0_clk_regs _263_/a_1283_21# 0.00159f
C10163 input30/a_75_212# clknet_2_3__leaf_clk_regs 0
C10164 input33/a_27_47# delay_sel[0] 0
C10165 cin input34/a_27_47# 0
C10166 _185_/a_68_297# genblk1\[12\].fa_inst.a 0.0831f
C10167 VPWR pmu_inst/dc_inst.x4.net13 0
C10168 output46/a_27_47# s[2] 0
C10169 genblk1\[2\].fa_inst.a _059_ 0.02316f
C10170 clknet_2_3__leaf_clk_regs net40 0
C10171 _302_/a_193_47# net20 0
C10172 _144_/a_285_47# _061_ 0
C10173 _271_/a_1108_47# net38 0
C10174 _271_/a_1270_413# _016_ 0
C10175 VPWR _199_/a_47_47# 0.01057f
C10176 _273_/a_543_47# net9 0.00193f
C10177 _258_/a_1462_47# net48 0
C10178 _293_/a_761_289# VPWR 0.00842f
C10179 _287_/a_27_47# clknet_2_3__leaf_clk_regs 0.02974f
C10180 net39 pmu_inst/dc_inst.x1.x2/a_27_47# 0
C10181 genblk1\[4\].fa_inst.b _065_ 0.22609f
C10182 clknet_2_0__leaf_clk_regs fanout57/a_27_47# 0.00159f
C10183 _294_/a_27_47# net3 0.02531f
C10184 _285_/a_639_47# net7 0.00118f
C10185 _299_/a_805_47# net32 0
C10186 clk clknet_0_clk_regs 0.15203f
C10187 genblk1\[3\].fa_inst.b net56 0.15239f
C10188 _149_/a_285_47# _067_ 0.00422f
C10189 _294_/a_1283_21# clknet_2_1__leaf_clk_regs 0
C10190 _267_/a_761_289# clknet_2_3__leaf_clk_regs 0.0028f
C10191 _163_/a_298_297# _077_ 0
C10192 _084_ genblk1\[7\].fa_inst.b 0.01924f
C10193 _282_/a_1108_47# _296_/a_543_47# 0
C10194 _282_/a_1283_21# _296_/a_1283_21# 0
C10195 net29 _282_/a_193_47# 0.02411f
C10196 _044_ _299_/a_805_47# 0
C10197 net60 _299_/a_1462_47# 0
C10198 net13 input15/a_75_212# 0.00967f
C10199 _287_/a_761_289# net60 0.01157f
C10200 clknet_2_1__leaf_clk_regs _281_/a_193_47# 0
C10201 _091_ _092_ 0.23068f
C10202 net59 _298_/a_27_47# 0.00131f
C10203 _026_ _295_/a_1108_47# 0
C10204 _281_/a_1108_47# _040_ 0
C10205 _264_/a_193_47# genblk1\[9\].fa_inst.s 0.08049f
C10206 _149_/a_285_47# _068_ 0.00633f
C10207 _267_/a_1283_21# net60 0.01892f
C10208 _158_/a_215_297# _154_/a_47_47# 0
C10209 VPWR _284_/a_543_47# 0.00977f
C10210 _001_ net46 0.00481f
C10211 net39 pmu_inst/dc_inst.x1.x16/a_27_47# 0
C10212 net47 net70 0
C10213 _300_/a_651_413# VPWR 0.00174f
C10214 _275_/a_1462_47# genblk1\[3\].fa_inst.a 0
C10215 _183_/a_215_297# genblk1\[10\].fa_inst.b 0
C10216 b[7] _298_/a_27_47# 0
C10217 net61 clknet_2_3__leaf_clk_regs 0.1402f
C10218 VPWR pmu_inst/dc_inst.x1.net6 0.00431f
C10219 _041_ net30 0.02506f
C10220 _198_/a_215_297# genblk1\[13\].fa_inst.b 0
C10221 _198_/a_27_413# _101_ 0.02827f
C10222 net33 _299_/a_1283_21# 0.01935f
C10223 net47 pmu_inst/_24_/a_639_47# 0
C10224 net47 pmu_inst/dc_inst.x8/a_27_413# 0
C10225 _039_ _279_/a_27_47# 0
C10226 _268_/a_193_47# net43 0
C10227 _268_/a_1283_21# _013_ 0.00675f
C10228 VPWR pmu_inst/dc_inst.x6.net2 0.01822f
C10229 net39 pmu_inst/dc_inst.x1.net18 0
C10230 _276_/a_193_47# net25 0
C10231 _005_ genblk1\[5\].fa_inst.s 0
C10232 net17 _280_/a_543_47# 0
C10233 _095_ _092_ 0
C10234 clknet_2_1__leaf_clk_regs _278_/a_193_47# 0.02829f
C10235 _049_ net56 0.23276f
C10236 _304_/a_543_47# genblk1\[0\].fa_inst.b 0
C10237 _291_/a_761_289# net36 0.00544f
C10238 clknet_1_0__leaf_clk net62 0.00201f
C10239 VPWR _262_/a_193_47# -0.06909f
C10240 clknet_2_0__leaf_clk_regs a[3] 0
C10241 genblk1\[2\].fa_inst.s _304_/a_543_47# 0
C10242 fanout60/a_27_47# _269_/a_1283_21# 0
C10243 _165_/a_68_297# genblk1\[9\].fa_inst.a 0
C10244 net3 _298_/a_193_47# 0
C10245 net61 _268_/a_1270_413# 0
C10246 net7 _284_/a_639_47# 0.00176f
C10247 _293_/a_543_47# VPWR 0.01626f
C10248 _084_ _173_/a_27_413# 0.00214f
C10249 _287_/a_1217_47# clknet_2_3__leaf_clk_regs 0
C10250 _287_/a_27_47# _287_/a_448_47# -0.00297f
C10251 genblk1\[13\].fa_inst.a net7 0
C10252 _274_/a_1108_47# clknet_2_0__leaf_clk_regs 0.05682f
C10253 net14 _279_/a_448_47# 0.00196f
C10254 _294_/a_193_47# _024_ 0
C10255 genblk1\[1\].fa_inst.b _057_ 0
C10256 _052_ VPWR 0.15723f
C10257 _096_ clknet_2_3__leaf_clk_regs 0.09662f
C10258 net33 _067_ 0
C10259 net58 _278_/a_543_47# 0
C10260 genblk1\[11\].fa_inst.s net41 0.00143f
C10261 _274_/a_543_47# VPWR 0.00965f
C10262 _304_/a_1270_413# _049_ -0
C10263 _282_/a_761_289# _041_ 0
C10264 _027_ _296_/a_761_289# 0
C10265 _282_/a_543_47# net31 0.01283f
C10266 _054_ _134_/a_47_47# 0
C10267 net58 _005_ 0.06171f
C10268 net59 _298_/a_1217_47# 0
C10269 VPWR pmu_inst/dc_inst.x4.net3 0.00771f
C10270 _129_/a_47_47# hold1/a_285_47# 0
C10271 a[8] net36 0
C10272 _026_ net30 0.11007f
C10273 VPWR _289_/a_1270_413# 0
C10274 _292_/a_543_47# net3 0
C10275 clkload0/a_361_47# clknet_0_clk_regs 0.0793f
C10276 _279_/a_193_47# _278_/a_193_47# 0.00169f
C10277 _279_/a_761_289# _278_/a_27_47# 0
C10278 _102_ genblk1\[13\].fa_inst.b 0.04724f
C10279 _292_/a_193_47# _292_/a_543_47# -0.009f
C10280 _076_ _154_/a_129_47# 0
C10281 genblk1\[9\].fa_inst.a _081_ 0
C10282 VPWR input23/a_75_212# 0.08873f
C10283 _013_ _267_/a_1283_21# 0
C10284 _272_/a_1283_21# _288_/a_1108_47# 0
C10285 _272_/a_1108_47# _288_/a_1283_21# 0
C10286 genblk1\[3\].fa_inst.a _021_ 0
C10287 clk _014_ 0
C10288 cin_q _135_/a_27_413# 0.00193f
C10289 _257_/a_1270_413# genblk1\[2\].fa_inst.s 0
C10290 _257_/a_1283_21# net47 0.01021f
C10291 _036_ _290_/a_1283_21# 0
C10292 _300_/a_543_47# _285_/a_1108_47# 0
C10293 _300_/a_651_413# _285_/a_193_47# 0
C10294 net39 pmu_inst/dc_inst.x6.net14 0
C10295 net47 pmu_inst/_25_/a_805_47# 0
C10296 net57 genblk1\[1\].fa_inst.s 0.0256f
C10297 net47 pmu_inst/dc_inst.x8/a_668_97# 0
C10298 net47 pmu_inst/capture_q 0.00955f
C10299 net33 _287_/a_1108_47# 0
C10300 _268_/a_1462_47# net43 0
C10301 net47 pmu_inst/dc_inst.x9/a_923_363# 0
C10302 VPWR _286_/a_543_47# 0.01147f
C10303 clknet_2_1__leaf_clk_regs input12/a_75_212# 0.00491f
C10304 _148_/a_27_413# net36 0.01182f
C10305 _277_/a_1283_21# genblk1\[3\].fa_inst.b 0
C10306 net4 _279_/a_761_289# 0.00345f
C10307 clknet_2_1__leaf_clk_regs _278_/a_1462_47# 0.00197f
C10308 _270_/a_1283_21# _014_ 0
C10309 _145_/a_68_297# net58 0
C10310 _302_/a_27_47# _301_/a_651_413# 0
C10311 _302_/a_1283_21# _301_/a_543_47# 0.00113f
C10312 _277_/a_1108_47# net16 0.0016f
C10313 VPWR _296_/a_761_289# 0.01357f
C10314 clknet_2_3__leaf_clk_regs net36 1.46963f
C10315 net24 a[15] 0
C10316 cin_q _053_ 0.11089f
C10317 _277_/a_761_289# VPWR 0.01463f
C10318 net7 genblk1\[12\].fa_inst.a 0
C10319 _283_/a_1108_47# clknet_2_2__leaf_clk_regs 0
C10320 _292_/a_193_47# _277_/a_1283_21# 0
C10321 net15 _295_/a_193_47# 0
C10322 _282_/a_1283_21# clknet_2_2__leaf_clk_regs 0
C10323 net36 net32 0.02714f
C10324 clknet_2_0__leaf_clk_regs _260_/a_651_413# 0.00166f
C10325 clk_regs net53 0.25429f
C10326 _049_ _055_ 0
C10327 _287_/a_27_47# _032_ 0.00167f
C10328 _130_/a_27_413# _053_ 0.0457f
C10329 net13 input16/a_75_212# 0
C10330 net14 _024_ 0.00426f
C10331 net35 _298_/a_761_289# 0
C10332 _302_/a_1283_21# genblk1\[14\].fa_inst.a 0
C10333 _302_/a_651_413# _031_ 0
C10334 _189_/a_47_47# _098_ 0
C10335 VPWR _260_/a_1108_47# 0.02463f
C10336 clknet_0_clk_regs _265_/a_27_47# 0.00198f
C10337 _275_/a_543_47# _273_/a_193_47# 0
C10338 _275_/a_193_47# _273_/a_543_47# 0
C10339 _275_/a_1283_21# _273_/a_27_47# 0
C10340 _021_ _290_/a_1283_21# 0
C10341 _039_ VPWR 0.06344f
C10342 _277_/a_448_47# net12 0.00197f
C10343 _267_/a_193_47# net42 0
C10344 _267_/a_1283_21# _012_ 0.05555f
C10345 _284_/a_193_47# _284_/a_543_47# -0.01294f
C10346 genblk1\[9\].fa_inst.b net31 0
C10347 b[2] net36 0
C10348 net47 pmu_inst/_14_/a_439_47# 0
C10349 _290_/a_27_47# net13 0.00242f
C10350 VPWR _263_/a_193_47# 0.03754f
C10351 _298_/a_448_47# net18 0.00252f
C10352 _298_/a_1108_47# _043_ 0.00643f
C10353 _199_/a_47_47# genblk1\[14\].fa_inst.s 0.00681f
C10354 _199_/a_129_47# _107_ 0.00152f
C10355 _277_/a_27_47# _277_/a_1108_47# -0
C10356 _259_/a_27_47# fanout57/a_27_47# 0
C10357 _017_ _288_/a_543_47# 0
C10358 clknet_2_0__leaf_clk_regs _288_/a_1108_47# 0.00115f
C10359 _157_/a_113_47# _074_ 0
C10360 net26 net25 0
C10361 net27 input27/a_75_212# 0.0021f
C10362 net20 _285_/a_543_47# 0
C10363 _300_/a_761_289# _030_ 0
C10364 VPWR _281_/a_761_289# 0.01007f
C10365 VPWR _288_/a_543_47# 0.01699f
C10366 _276_/a_193_47# clknet_2_1__leaf_clk_regs 0.00343f
C10367 net39 pmu_inst/dc_inst.x4.net9 0.00906f
C10368 net47 pmu_inst/_13_/a_470_47# 0.00475f
C10369 _297_/a_761_289# net30 0.01557f
C10370 _194_/a_285_47# _102_ 0
C10371 _285_/a_448_47# genblk1\[13\].fa_inst.a 0
C10372 clkbuf_0_clk/a_110_47# VPWR 0.05565f
C10373 genblk1\[9\].fa_inst.a genblk1\[8\].fa_inst.a 0
C10374 _179_/a_47_47# _088_ 0
C10375 _294_/a_27_47# _280_/a_27_47# 0
C10376 _190_/a_68_297# genblk1\[13\].fa_inst.b 0.04622f
C10377 net71 pmu_inst/dc_inst.x6.net2 -0
C10378 net48 clknet_1_0__leaf_clk 0.05726f
C10379 clknet_2_1__leaf_clk_regs _080_ 0
C10380 genblk1\[10\].fa_inst.b _175_/a_68_297# 0.03029f
C10381 _047_ _301_/a_193_47# 0
C10382 _302_/a_193_47# _046_ 0
C10383 _302_/a_761_289# net21 0.00445f
C10384 VPWR input20/a_75_212# 0.09161f
C10385 _301_/a_543_47# net7 0.01565f
C10386 _130_/a_382_47# net56 0
C10387 _093_ _089_ 0
C10388 _108_ _106_ 0.00117f
C10389 net36 net19 0.02355f
C10390 VPWR pmu_inst/dc_inst.x6.x20/a_27_47# 0.00304f
C10391 _007_ _262_/a_1108_47# -0.00453f
C10392 VPWR a[13] 0.21831f
C10393 _158_/a_298_297# _073_ 0
C10394 _270_/a_193_47# VPWR 0.03236f
C10395 _303_/a_193_47# net7 0
C10396 _276_/a_1283_21# net56 0.0253f
C10397 _078_ genblk1\[7\].fa_inst.b 0.10766f
C10398 net38 cout 0.00871f
C10399 _256_/a_543_47# net57 0.00368f
C10400 _277_/a_1108_47# _291_/a_193_47# 0
C10401 net28 _296_/a_193_47# 0
C10402 _302_/a_1270_413# clknet_2_2__leaf_clk_regs 0
C10403 genblk1\[7\].fa_inst.b net3 0
C10404 input2/a_27_47# net14 0
C10405 VPWR _278_/a_761_289# 0.01065f
C10406 _287_/a_1217_47# _032_ 0
C10407 _304_/a_27_47# genblk1\[2\].fa_inst.b 0
C10408 _155_/a_68_297# genblk1\[6\].fa_inst.a 0.0558f
C10409 net59 _295_/a_1108_47# 0.00172f
C10410 _163_/a_27_413# _073_ 0.05912f
C10411 genblk1\[14\].fa_inst.a net7 0
C10412 clknet_0_clk_regs _265_/a_1217_47# 0
C10413 _275_/a_27_47# clknet_2_1__leaf_clk_regs 0.04674f
C10414 _283_/a_1108_47# _297_/a_27_47# 0
C10415 _283_/a_193_47# _297_/a_1283_21# 0
C10416 _283_/a_543_47# _297_/a_761_289# 0
C10417 _283_/a_761_289# _297_/a_543_47# 0
C10418 net16 net62 0
C10419 VPWR pmu_inst/dc_inst.x4.x15/a_27_47# 0
C10420 _276_/a_193_47# net11 0.06344f
C10421 _282_/a_193_47# _297_/a_543_47# 0.00126f
C10422 _282_/a_543_47# _297_/a_193_47# 0
C10423 _282_/a_761_289# _297_/a_761_289# 0
C10424 _205_/a_47_47# _112_ 0.03981f
C10425 _255_/a_761_289# genblk1\[1\].fa_inst.s 0
C10426 net46 pmu_inst/dc_inst.x6.x9/a_27_47# 0.00695f
C10427 VPWR net9 0.72845f
C10428 _264_/a_193_47# _009_ 0.0058f
C10429 _301_/a_1270_413# VPWR 0
C10430 VPWR b[11] 0.21646f
C10431 _194_/a_129_47# _104_ 0.00126f
C10432 net39 pmu_inst/dc_inst.net6 0
C10433 net18 _043_ 0.00443f
C10434 _290_/a_543_47# net36 0.00316f
C10435 b[1] net36 0
C10436 _291_/a_1108_47# clknet_2_1__leaf_clk_regs 0
C10437 _292_/a_805_47# net27 0
C10438 _292_/a_639_47# _037_ -0
C10439 _292_/a_448_47# genblk1\[4\].fa_inst.b 0
C10440 net33 _077_ 0.00585f
C10441 _303_/a_448_47# VPWR -0.00266f
C10442 net46 pmu_inst/dc_inst.x2.x15/a_27_47# 0.00702f
C10443 clknet_2_0__leaf_clk_regs net17 0.73784f
C10444 _293_/a_448_47# net33 0.00138f
C10445 _039_ net2 0
C10446 _269_/a_761_289# clknet_2_3__leaf_clk_regs 0
C10447 net8 input9/a_75_212# 0.00154f
C10448 _148_/a_215_297# _144_/a_47_47# 0
C10449 clkbuf_2_1__f_clk_regs/a_110_47# genblk1\[6\].fa_inst.s 0.01201f
C10450 net28 _294_/a_1283_21# 0
C10451 _273_/a_639_47# net56 0
C10452 _129_/a_285_47# net75 0.01716f
C10453 _004_ VPWR 0.06215f
C10454 clknet_2_2__leaf_clk_regs _172_/a_113_47# 0
C10455 _030_ genblk1\[13\].fa_inst.a 0.1871f
C10456 _065_ _153_/a_215_297# 0.09446f
C10457 genblk1\[13\].fa_inst.a _101_ 0.17104f
C10458 clknet_2_2__leaf_clk_regs _090_ 0
C10459 _078_ _173_/a_27_413# 0
C10460 net28 _281_/a_193_47# 0
C10461 _274_/a_193_47# _274_/a_543_47# -0.01017f
C10462 cin_q VPWR 0.24844f
C10463 net6 input28/a_75_212# 0.02109f
C10464 _269_/a_1283_21# net60 0
C10465 _189_/a_47_47# VPWR 0.04886f
C10466 _275_/a_193_47# a[4] 0
C10467 _275_/a_27_47# net11 0
C10468 clkload0/a_27_47# clknet_2_0__leaf_clk_regs 0.0327f
C10469 VPWR _158_/a_298_297# 0
C10470 _032_ net36 0
C10471 _189_/a_47_47# _100_ 0.03115f
C10472 net24 a[14] 0
C10473 _066_ _153_/a_27_413# 0.02144f
C10474 clknet_2_2__leaf_clk_regs genblk1\[9\].fa_inst.s 0.4014f
C10475 _303_/a_1462_47# net7 0
C10476 _158_/a_215_297# _072_ 0.01846f
C10477 net7 net16 0.02173f
C10478 net17 genblk1\[7\].fa_inst.a 0.02905f
C10479 net28 _296_/a_1462_47# 0
C10480 _130_/a_27_413# VPWR 0.03668f
C10481 net3 _280_/a_761_289# 0.01158f
C10482 net27 net36 0.02773f
C10483 _130_/a_215_297# hold1/a_285_47# 0
C10484 _290_/a_448_47# net25 0.00206f
C10485 _290_/a_1108_47# _035_ 0.01683f
C10486 _163_/a_27_413# VPWR 0.05273f
C10487 _283_/a_27_47# clknet_2_3__leaf_clk_regs 0
C10488 net59 net30 0.6277f
C10489 _107_ _201_/a_61_47# 0.0502f
C10490 VPWR _159_/a_129_47# -0
C10491 _298_/a_27_47# net30 0.02975f
C10492 _193_/a_27_413# _104_ 0
C10493 net2 a[13] 0
C10494 _275_/a_1217_47# clknet_2_1__leaf_clk_regs 0
C10495 genblk1\[3\].fa_inst.a genblk1\[2\].fa_inst.b 0.44938f
C10496 _003_ net57 0.0328f
C10497 net33 _173_/a_215_297# 0
C10498 net59 _088_ 0.26183f
C10499 _283_/a_27_47# net32 0.03549f
C10500 _301_/a_761_289# _300_/a_27_47# 0.00112f
C10501 _301_/a_193_47# _300_/a_193_47# 0
C10502 _301_/a_27_47# _300_/a_761_289# 0
C10503 net6 input18/a_75_212# 0.02122f
C10504 _199_/a_377_297# genblk1\[13\].fa_inst.s 0
C10505 _284_/a_448_47# genblk1\[12\].fa_inst.a 0
C10506 genblk1\[0\].fa_inst.s _056_ 0
C10507 _264_/a_1462_47# _009_ 0
C10508 _264_/a_639_47# net54 0
C10509 VPWR pmu_inst/dc_inst.x7.x15/a_27_47# 0
C10510 net46 pmu_inst/dc_inst.x6.net19 0
C10511 b[7] net30 0.0015f
C10512 _107_ genblk1\[14\].fa_inst.b 0.00588f
C10513 genblk1\[9\].fa_inst.b _297_/a_193_47# 0
C10514 _037_ genblk1\[4\].fa_inst.b 0
C10515 input5/a_27_47# a[14] 0
C10516 a[13] input6/a_27_47# 0
C10517 net26 clknet_2_1__leaf_clk_regs 2.71584f
C10518 _048_ VPWR 0.00871f
C10519 pmu_inst/dc_inst.x1.net6 net65 0
C10520 net33 _143_/a_382_47# 0
C10521 genblk1\[5\].fa_inst.a net56 0
C10522 genblk1\[4\].fa_inst.a _036_ 0
C10523 _277_/a_193_47# net16 0.03464f
C10524 _271_/a_543_47# net44 0.02967f
C10525 net20 _286_/a_543_47# 0.00162f
C10526 _266_/a_1108_47# net41 0.00142f
C10527 _276_/a_543_47# _291_/a_27_47# 0
C10528 genblk1\[1\].fa_inst.a net56 0.58017f
C10529 net39 pmu_inst/dc_inst.x6.net12 0
C10530 net3 _040_ 0.02108f
C10531 _283_/a_543_47# net59 0
C10532 _256_/a_193_47# _255_/a_1283_21# 0
C10533 _256_/a_27_47# _255_/a_1108_47# 0
C10534 _068_ _064_ 0.01021f
C10535 net27 _295_/a_761_289# 0.0058f
C10536 _282_/a_761_289# net59 0.00243f
C10537 _286_/a_193_47# _286_/a_543_47# -0.00424f
C10538 net28 _281_/a_1462_47# 0
C10539 net46 pmu_inst/dc_inst.x6.net11 0.01807f
C10540 net47 pmu_inst/dc_inst.x3.net6 0.00813f
C10541 _277_/a_639_47# net58 0
C10542 _166_/a_113_47# VPWR -0
C10543 _283_/a_761_289# _298_/a_193_47# 0
C10544 _283_/a_193_47# _298_/a_761_289# 0
C10545 _283_/a_543_47# _298_/a_27_47# 0
C10546 _283_/a_27_47# _298_/a_543_47# 0
C10547 _272_/a_193_47# net56 0.02623f
C10548 net26 _025_ 0
C10549 _184_/a_285_47# clknet_2_3__leaf_clk_regs 0.00662f
C10550 net39 pmu_inst/dc_inst.x5.net17 0.01385f
C10551 _014_ _268_/a_1283_21# 0
C10552 _269_/a_1283_21# _013_ 0
C10553 output43/a_27_47# net43 0.0207f
C10554 net39 pmu_inst/dc_inst.x2.x10/a_27_47# 0.00278f
C10555 _103_ _101_ 0.06666f
C10556 genblk1\[2\].fa_inst.a _289_/a_27_47# 0.00143f
C10557 _290_/a_1283_21# genblk1\[2\].fa_inst.b 0.00291f
C10558 clk _264_/a_1108_47# 0.00193f
C10559 _270_/a_543_47# cout_next 0
C10560 _304_/a_1283_21# _057_ 0.00259f
C10561 net25 _035_ 0.00442f
C10562 net26 net11 0.00417f
C10563 _139_/a_47_47# _059_ 0
C10564 _277_/a_27_47# _277_/a_193_47# -0.04831f
C10565 net26 _279_/a_193_47# 0.01413f
C10566 _294_/a_651_413# _280_/a_193_47# 0
C10567 genblk1\[14\].fa_inst.a net6 0
C10568 clk _266_/a_543_47# 0.01546f
C10569 net4 _284_/a_543_47# 0
C10570 _298_/a_1217_47# net30 0
C10571 _302_/a_543_47# clknet_2_3__leaf_clk_regs 0
C10572 _020_ genblk1\[1\].fa_inst.a 0.03861f
C10573 _255_/a_1283_21# VPWR 0.0111f
C10574 _289_/a_1108_47# genblk1\[1\].fa_inst.b 0
C10575 genblk1\[4\].fa_inst.a _021_ 0.1746f
C10576 _292_/a_1283_21# _277_/a_1108_47# 0
C10577 VPWR _176_/a_113_47# -0
C10578 _188_/a_215_297# _093_ 0.04329f
C10579 _029_ genblk1\[12\].fa_inst.a 0.18619f
C10580 clkbuf_2_3__f_clk_regs/a_110_47# genblk1\[10\].fa_inst.s 0
C10581 net3 _282_/a_543_47# 0.00516f
C10582 net3 _283_/a_1283_21# 0
C10583 _270_/a_193_47# genblk1\[14\].fa_inst.s 0
C10584 _098_ _193_/a_298_297# 0
C10585 genblk1\[7\].fa_inst.b _295_/a_1283_21# 0.00292f
C10586 _275_/a_543_47# clknet_2_0__leaf_clk_regs 0
C10587 _301_/a_1283_21# genblk1\[13\].fa_inst.b 0.00127f
C10588 _302_/a_1108_47# net60 0.02638f
C10589 _181_/a_113_47# VPWR -0
C10590 _259_/a_1283_21# net36 0.00348f
C10591 _300_/a_543_47# clknet_2_2__leaf_clk_regs 0
C10592 _275_/a_193_47# VPWR 0.04746f
C10593 clknet_0_clk_regs _261_/a_27_47# 0
C10594 cout_next _111_ 0.22403f
C10595 genblk1\[2\].fa_inst.a net10 0
C10596 VPWR pmu_inst/_20_/a_470_297# 0
C10597 genblk1\[6\].fa_inst.b _155_/a_68_297# 0.02494f
C10598 _093_ genblk1\[11\].fa_inst.a 0.00104f
C10599 genblk1\[6\].fa_inst.b genblk1\[8\].fa_inst.a 0
C10600 genblk1\[12\].fa_inst.b net33 0.08192f
C10601 a[15] net15 0
C10602 _261_/a_1270_413# genblk1\[6\].fa_inst.s 0
C10603 _261_/a_1283_21# net51 0.00589f
C10604 net20 input20/a_75_212# 0.00207f
C10605 input10/a_75_212# a[2] 0
C10606 a[3] input9/a_75_212# 0
C10607 _256_/a_27_47# genblk1\[0\].fa_inst.s 0.00647f
C10608 _291_/a_448_47# VPWR 0.00188f
C10609 _277_/a_193_47# _291_/a_193_47# 0.00127f
C10610 genblk1\[14\].fa_inst.a _101_ 0
C10611 _271_/a_543_47# VPWR 0.01866f
C10612 _274_/a_448_47# genblk1\[2\].fa_inst.a 0
C10613 _107_ _111_ 0
C10614 VPWR _091_ 0.27808f
C10615 _272_/a_1462_47# net56 0.0022f
C10616 a[7] net14 0.00201f
C10617 _276_/a_543_47# net56 0.00368f
C10618 _281_/a_27_47# _296_/a_761_289# 0
C10619 _281_/a_193_47# _296_/a_193_47# 0
C10620 _281_/a_761_289# _296_/a_27_47# 0
C10621 VPWR _297_/a_639_47# 0
C10622 _274_/a_193_47# net9 -0.00508f
C10623 genblk1\[1\].fa_inst.a _055_ 0.00317f
C10624 clknet_2_2__leaf_clk_regs _264_/a_448_47# 0.00124f
C10625 genblk1\[10\].fa_inst.s _090_ 0
C10626 net22 b[13] 0.03392f
C10627 _290_/a_448_47# clknet_2_1__leaf_clk_regs 0
C10628 _294_/a_27_47# _024_ 0.00116f
C10629 net17 _062_ 0
C10630 net6 net16 0
C10631 _050_ genblk1\[1\].fa_inst.s 0
C10632 genblk1\[2\].fa_inst.a _289_/a_1217_47# 0
C10633 _277_/a_1283_21# genblk1\[5\].fa_inst.a 0.00293f
C10634 clkload1/a_110_47# clkload1/Y -0
C10635 net29 _296_/a_448_47# 0.0121f
C10636 VPWR _268_/a_193_47# 0.02524f
C10637 clknet_2_0__leaf_clk_regs _000_ 0
C10638 _051_ _134_/a_285_47# 0
C10639 _293_/a_1108_47# genblk1\[5\].fa_inst.b 0.02128f
C10640 clk clknet_1_0__leaf_clk 0.09866f
C10641 _294_/a_761_289# clknet_2_1__leaf_clk_regs 0
C10642 net63 pmu_inst_63/HI 0.01111f
C10643 _023_ _279_/a_1270_413# 0
C10644 clknet_2_0__leaf_clk_regs _304_/a_1108_47# 0.05675f
C10645 net24 genblk1\[1\].fa_inst.b 0
C10646 _302_/a_1283_21# _287_/a_1108_47# 0
C10647 _046_ _300_/a_651_413# 0
C10648 _095_ VPWR 0.03438f
C10649 genblk1\[10\].fa_inst.a _042_ 0
C10650 _100_ _095_ 0
C10651 _303_/a_27_47# net23 0.13566f
C10652 _303_/a_193_47# b[15] 0
C10653 _304_/a_543_47# VPWR 0.01395f
C10654 _280_/a_543_47# _295_/a_543_47# 0
C10655 _280_/a_1108_47# _295_/a_193_47# 0
C10656 _149_/a_47_47# _072_ 0.00114f
C10657 output53/a_27_47# s[8] 0.00932f
C10658 _286_/a_193_47# b[11] 0
C10659 genblk1\[1\].fa_inst.b _288_/a_27_47# 0
C10660 _258_/a_27_47# VPWR 0.03688f
C10661 input4/a_27_47# net14 0
C10662 genblk1\[11\].fa_inst.s net61 0
C10663 net3 genblk1\[9\].fa_inst.b 0
C10664 _275_/a_1462_47# VPWR 0
C10665 clknet_0_clk_regs _261_/a_1217_47# 0
C10666 _163_/a_382_47# _074_ 0
C10667 _163_/a_27_413# _075_ 0.00114f
C10668 net38 net62 0.2551f
C10669 _158_/a_298_297# _069_ 0.00776f
C10670 _063_ net36 0.02753f
C10671 _068_ _153_/a_382_47# 0
C10672 _159_/a_129_47# _075_ 0.00287f
C10673 genblk1\[12\].fa_inst.a net31 0
C10674 _290_/a_448_47# net11 0.00275f
C10675 _260_/a_761_289# _005_ 0.00424f
C10676 _150_/a_68_297# genblk1\[6\].fa_inst.a 0
C10677 net29 _294_/a_1108_47# 0
C10678 net58 _262_/a_805_47# 0
C10679 _256_/a_1217_47# genblk1\[0\].fa_inst.s 0
C10680 _036_ VPWR 0.04126f
C10681 net59 _087_ 0.0145f
C10682 _286_/a_448_47# genblk1\[14\].fa_inst.a 0
C10683 _286_/a_639_47# _031_ -0
C10684 net47 pmu_inst/_23_/a_448_47# 0.00256f
C10685 genblk1\[4\].fa_inst.a genblk1\[4\].fa_inst.b 0.18451f
C10686 VPWR _299_/a_639_47# 0.00402f
C10687 _019_ genblk1\[2\].fa_inst.a 0.03989f
C10688 net58 net36 0.00621f
C10689 net22 b[14] 0.01951f
C10690 _289_/a_543_47# net12 0.0097f
C10691 _294_/a_761_289# _279_/a_193_47# 0
C10692 net29 _281_/a_448_47# 0
C10693 _109_ _201_/a_61_47# 0
C10694 clknet_2_0__leaf_clk_regs _126_/a_68_297# 0
C10695 _292_/a_27_47# clknet_2_0__leaf_clk_regs 0.26086f
C10696 _162_/a_113_47# VPWR -0
C10697 net55 pmu_inst_70/HI 0
C10698 _274_/a_1462_47# net9 0
C10699 _257_/a_805_47# clknet_2_0__leaf_clk_regs 0
C10700 net7 _298_/a_761_289# 0.00289f
C10701 VPWR _267_/a_193_47# 0.03602f
C10702 net39 pmu_inst/dc_inst.x4.x10/a_27_47# 0.00268f
C10703 VPWR pmu_inst/dc_inst.x1.x19/a_27_47# 0
C10704 _039_ net4 0
C10705 clknet_2_2__leaf_clk_regs _009_ 0
C10706 input34/a_27_47# net36 0
C10707 _035_ clknet_2_1__leaf_clk_regs 0.02512f
C10708 clknet_2_1__leaf_clk_regs _295_/a_27_47# 0.02944f
C10709 genblk1\[11\].fa_inst.s _096_ 0.00508f
C10710 _257_/a_1270_413# VPWR -0
C10711 VPWR clkbuf_2_1__f_clk_regs/a_110_47# 0.12374f
C10712 _295_/a_1283_21# _040_ 0.00291f
C10713 _295_/a_1108_47# net30 0.00203f
C10714 VPWR _178_/a_298_297# -0
C10715 net27 genblk1\[8\].fa_inst.a 0
C10716 net29 _041_ 0
C10717 _178_/a_215_297# _086_ 0.08652f
C10718 _183_/a_27_413# _090_ 0.05109f
C10719 VPWR _193_/a_298_297# -0
C10720 genblk1\[14\].fa_inst.b _109_ 0
C10721 genblk1\[2\].fa_inst.a _138_/a_113_47# 0
C10722 _165_/a_68_297# genblk1\[8\].fa_inst.b 0.0162f
C10723 _100_ _193_/a_298_297# 0.01109f
C10724 VPWR pmu_inst/dc_inst.x9/a_1478_413# 0
C10725 net14 _278_/a_448_47# 0
C10726 net46 pmu_inst/_19_/a_109_297# 0.00133f
C10727 _276_/a_543_47# _290_/a_193_47# 0
C10728 output40/a_27_47# s[11] 0
C10729 clknet_2_0__leaf_clk_regs net33 0.05378f
C10730 _302_/a_543_47# _032_ 0
C10731 _047_ _287_/a_543_47# 0
C10732 _287_/a_1108_47# net7 0
C10733 _173_/a_382_47# _082_ 0.00297f
C10734 _173_/a_298_297# _081_ 0.03373f
C10735 _303_/a_1217_47# net23 0
C10736 VPWR pmu_inst/dc_inst.x6.net17 0.01834f
C10737 net36 _057_ 0
C10738 a[13] _278_/a_27_47# 0
C10739 _280_/a_27_47# _040_ 0
C10740 _280_/a_193_47# net30 0
C10741 _025_ _295_/a_27_47# 0.00166f
C10742 net58 net52 0.18122f
C10743 genblk1\[10\].fa_inst.a _092_ 0
C10744 _301_/a_27_47# genblk1\[14\].fa_inst.a 0
C10745 net21 _286_/a_1283_21# 0
C10746 _301_/a_543_47# _031_ 0.00932f
C10747 genblk1\[1\].fa_inst.b _288_/a_1217_47# 0
C10748 net58 _295_/a_761_289# 0.00103f
C10749 _021_ VPWR 0.5651f
C10750 clk _263_/a_651_413# 0.00455f
C10751 VPWR _298_/a_651_413# 0.00145f
C10752 b[10] b[11] 0.06871f
C10753 clkload0/a_361_47# _260_/a_27_47# 0.00157f
C10754 clkload0/a_27_47# _260_/a_193_47# 0.00574f
C10755 fanout58/a_27_47# _262_/a_27_47# 0.00141f
C10756 net33 _090_ 0
C10757 VPWR input13/a_75_212# 0.09177f
C10758 _259_/a_761_289# VPWR 0.0024f
C10759 _286_/a_805_47# clknet_2_2__leaf_clk_regs 0
C10760 clkbuf_2_3__f_clk_regs/a_110_47# net35 0
C10761 VPWR pmu_inst/dc_inst.x4.net17 0
C10762 _035_ net11 0.09267f
C10763 _154_/a_285_47# genblk1\[5\].fa_inst.s 0.00166f
C10764 net4 _278_/a_761_289# 0.00326f
C10765 a[14] net15 0.01389f
C10766 genblk1\[8\].fa_inst.b _081_ 0.09617f
C10767 _031_ genblk1\[14\].fa_inst.a 0.00993f
C10768 net33 genblk1\[7\].fa_inst.a 0.88726f
C10769 _285_/a_1283_21# _299_/a_448_47# 0
C10770 _285_/a_1108_47# clknet_2_3__leaf_clk_regs 0
C10771 net46 pmu_inst/dc_inst.x1.x2/a_27_47# 0.00243f
C10772 _143_/a_382_47# _064_ 0.00136f
C10773 pmu_inst/dc_inst.x7.x11/a_27_47# net35 0
C10774 VPWR _287_/a_805_47# 0
C10775 genblk1\[0\].fa_inst.a genblk1\[0\].fa_inst.b 0.48146f
C10776 net29 _026_ 0.00111f
C10777 net39 pmu_inst/dc_inst.x6.net10 0.00391f
C10778 _292_/a_1217_47# clknet_2_0__leaf_clk_regs 0
C10779 _271_/a_1108_47# cout_next 0
C10780 _273_/a_1108_47# clknet_2_1__leaf_clk_regs 0
C10781 _273_/a_27_47# genblk1\[1\].fa_inst.a 0.00168f
C10782 _300_/a_27_47# net60 0.00161f
C10783 net39 pmu_inst/dc_inst.x2.x17/a_27_47# 0
C10784 _028_ net36 0
C10785 _292_/a_639_47# VPWR 0
C10786 genblk1\[4\].fa_inst.a genblk1\[2\].fa_inst.b 0
C10787 _270_/a_651_413# clk 0
C10788 _273_/a_193_47# _272_/a_27_47# 0
C10789 _273_/a_27_47# _272_/a_193_47# 0
C10790 net33 _102_ 0
C10791 _275_/a_27_47# _274_/a_761_289# 0.00309f
C10792 _275_/a_761_289# _274_/a_27_47# 0
C10793 _275_/a_193_47# _274_/a_193_47# 0
C10794 VPWR pmu_inst/dc_inst.net7 0.00103f
C10795 net46 pmu_inst/dc_inst.x6.net16 0.00116f
C10796 _263_/a_761_289# net53 0
C10797 _263_/a_1108_47# _008_ 0.00818f
C10798 net46 pmu_inst/dc_inst.x1.x16/a_27_47# 0.00214f
C10799 clknet_0_clk net50 0.34978f
C10800 _204_/a_33_297# _111_ 0.09096f
C10801 VPWR pmu_inst/dc_inst.x1.x15/a_27_47# 0.00182f
C10802 _259_/a_193_47# net58 0.00236f
C10803 net58 net51 0.54261f
C10804 _290_/a_651_413# VPWR 0
C10805 _258_/a_543_47# net36 0.00767f
C10806 _280_/a_1217_47# _040_ 0
C10807 net46 pmu_inst/dc_inst.x1.net18 0.01029f
C10808 _077_ net62 0
C10809 hold1/a_285_47# _055_ 0.04423f
C10810 _268_/a_193_47# genblk1\[14\].fa_inst.s 0.00129f
C10811 _281_/a_1108_47# net16 0
C10812 genblk1\[8\].fa_inst.a _173_/a_298_297# 0
C10813 _281_/a_1283_21# genblk1\[9\].fa_inst.a 0.00293f
C10814 genblk1\[2\].fa_inst.a net12 0
C10815 _004_ net57 0.03395f
C10816 _293_/a_1283_21# _155_/a_68_297# 0
C10817 _111_ _109_ 0.23434f
C10818 _284_/a_1108_47# clknet_2_3__leaf_clk_regs 0
C10819 _288_/a_805_47# net17 0
C10820 _288_/a_639_47# _033_ -0
C10821 genblk1\[5\].fa_inst.a _071_ 0
C10822 VPWR _160_/a_150_297# 0
C10823 _283_/a_543_47# net30 0.01144f
C10824 _134_/a_47_47# _056_ 0.04096f
C10825 _282_/a_761_289# net30 0.01558f
C10826 cin_q _060_ 0
C10827 _280_/a_1283_21# genblk1\[8\].fa_inst.a 0.00292f
C10828 _264_/a_1283_21# net59 0.00305f
C10829 output43/a_27_47# s[14] 0
C10830 net39 pmu_inst/dc_inst.x4.x5/a_27_47# 0.0014f
C10831 net16 net31 0
C10832 genblk1\[13\].fa_inst.a _299_/a_193_47# 0
C10833 _285_/a_1108_47# net19 0.0159f
C10834 _289_/a_193_47# net56 0
C10835 net72 pmu_inst/dc_inst.x6.net2 0
C10836 _108_ _205_/a_285_47# 0
C10837 _284_/a_1108_47# _044_ 0
C10838 _273_/a_1217_47# genblk1\[1\].fa_inst.a 0
C10839 genblk1\[8\].fa_inst.b genblk1\[8\].fa_inst.a 0.26526f
C10840 _300_/a_1217_47# net60 0
C10841 VPWR pmu_inst/dc_inst.x6.net18 0.00276f
C10842 genblk1\[3\].fa_inst.a _141_/a_113_47# 0
C10843 genblk1\[4\].fa_inst.b VPWR 1.5496f
C10844 _186_/a_113_47# genblk1\[12\].fa_inst.b 0
C10845 clknet_2_1__leaf_clk_regs genblk1\[7\].fa_inst.s 0.05474f
C10846 _269_/a_193_47# net44 0
C10847 _269_/a_1283_21# _014_ 0.00704f
C10848 genblk1\[12\].fa_inst.b _185_/a_68_297# 0.0302f
C10849 _284_/a_1270_413# net59 0
C10850 _054_ net17 0
C10851 _283_/a_27_47# _283_/a_448_47# -0.00297f
C10852 _144_/a_377_297# _057_ 0
C10853 VPWR _295_/a_193_47# 0.02596f
C10854 _270_/a_1108_47# _015_ -0.00159f
C10855 _270_/a_761_289# net45 0
C10856 net46 pmu_inst/dc_inst.x6.net14 0.00581f
C10857 _292_/a_639_47# net2 0
C10858 _303_/a_1283_21# _048_ 0.05418f
C10859 _303_/a_193_47# genblk1\[15\].fa_inst.b 0
C10860 _135_/a_382_47# _053_ 0
C10861 net14 input15/a_75_212# 0
C10862 _277_/a_448_47# genblk1\[5\].fa_inst.a 0
C10863 net33 _190_/a_68_297# 0.00257f
C10864 s[2] VPWR 0.40077f
C10865 a[9] net16 0.00213f
C10866 _278_/a_1283_21# genblk1\[6\].fa_inst.a 0.00179f
C10867 _285_/a_543_47# net18 0.02181f
C10868 clkload0/Y _005_ 0.24709f
C10869 genblk1\[15\].fa_inst.b genblk1\[14\].fa_inst.a 0
C10870 _275_/a_193_47# _288_/a_193_47# 0.00148f
C10871 clknet_2_2__leaf_clk_regs genblk1\[9\].fa_inst.a 0
C10872 genblk1\[12\].fa_inst.a _299_/a_193_47# 0
C10873 net39 pmu_inst/dc_inst.x5.net19 0.00223f
C10874 _145_/a_68_297# _065_ 0.00131f
C10875 clknet_2_1__leaf_clk_regs _279_/a_761_289# 0
C10876 _168_/a_298_297# _084_ 0.00258f
C10877 _300_/a_639_47# net19 0.00176f
C10878 VPWR pmu_inst/dc_inst.x7.x1/a_27_47# 0.00609f
C10879 _285_/a_27_47# net36 0.00432f
C10880 _276_/a_761_289# _291_/a_651_413# 0
C10881 net61 _264_/a_651_413# 0
C10882 net7 _295_/a_651_413# 0.0026f
C10883 net33 _107_ 0
C10884 net33 _062_ 0.0068f
C10885 _293_/a_1108_47# _076_ 0
C10886 net58 genblk1\[8\].fa_inst.a 0.00516f
C10887 _286_/a_1108_47# clknet_2_3__leaf_clk_regs 0
C10888 net39 s[0] 0.00522f
C10889 _259_/a_193_47# _258_/a_543_47# 0
C10890 clknet_2_0__leaf_clk_regs clkbuf_2_0__f_clk_regs/a_110_47# 0.06481f
C10891 clk _265_/a_543_47# 0.01546f
C10892 net61 _266_/a_1108_47# 0.00379f
C10893 net39 pmu_inst/dc_inst.x2.net11 0.0036f
C10894 net12 net16 0.04067f
C10895 _277_/a_651_413# _036_ 0
C10896 net26 _296_/a_193_47# 0
C10897 net47 pmu_inst/dc_inst.x3.net12 0.01003f
C10898 net17 genblk1\[6\].fa_inst.a 0.02901f
C10899 net58 _279_/a_1283_21# 0.0158f
C10900 _189_/a_47_47# genblk1\[12\].fa_inst.s 0.00112f
C10901 _273_/a_1270_413# clknet_2_0__leaf_clk_regs 0
C10902 VPWR _154_/a_129_47# -0
C10903 net7 _280_/a_543_47# 0.01332f
C10904 _275_/a_1283_21# genblk1\[2\].fa_inst.a 0.03016f
C10905 clknet_2_0__leaf_clk_regs _059_ 0
C10906 _290_/a_193_47# _289_/a_193_47# 0
C10907 _276_/a_1108_47# _035_ 0.0085f
C10908 VPWR _161_/a_113_47# -0
C10909 _255_/a_1283_21# net57 0.01945f
C10910 _304_/a_27_47# genblk1\[1\].fa_inst.b 0.03743f
C10911 genblk1\[2\].fa_inst.b _136_/a_68_297# 0.02655f
C10912 _154_/a_377_297# _072_ 0
C10913 _273_/a_448_47# VPWR 0.00127f
C10914 _283_/a_27_47# _028_ 0
C10915 VPWR genblk1\[2\].fa_inst.b 0.5527f
C10916 cout_next pmu_inst/_05_ 0
C10917 VPWR _295_/a_1462_47# 0.00209f
C10918 genblk1\[4\].fa_inst.b net2 0
C10919 _272_/a_193_47# _272_/a_543_47# -0.01294f
C10920 _284_/a_761_289# _043_ 0
C10921 _303_/a_1462_47# genblk1\[15\].fa_inst.b 0
C10922 _199_/a_377_297# _110_ 0.00156f
C10923 _029_ _298_/a_761_289# 0.00103f
C10924 VPWR _269_/a_193_47# 0.02948f
C10925 net46 pmu_inst/dc_inst.x4.net9 0
C10926 _304_/a_27_47# _288_/a_1283_21# 0
C10927 _276_/a_27_47# _290_/a_27_47# 0.0068f
C10928 genblk1\[4\].fa_inst.a _153_/a_215_297# 0
C10929 _163_/a_215_297# _076_ 0.03337f
C10930 output43/a_27_47# VPWR 0.07863f
C10931 _268_/a_761_289# genblk1\[13\].fa_inst.s 0
C10932 _289_/a_543_47# a[6] 0
C10933 VPWR _082_ 0.19636f
C10934 _302_/a_27_47# _302_/a_193_47# -0.00591f
C10935 net28 _295_/a_27_47# 0
C10936 _284_/a_27_47# net36 0
C10937 net75 genblk1\[0\].fa_inst.b 0
C10938 _052_ _050_ 0.11336f
C10939 _159_/a_285_47# _076_ 0.00633f
C10940 genblk1\[2\].fa_inst.s net75 0
C10941 _273_/a_761_289# net8 0.00213f
C10942 VPWR _144_/a_47_47# 0.04728f
C10943 _277_/a_27_47# net12 0.14967f
C10944 net29 net59 0
C10945 _143_/a_215_297# _058_ 0.02584f
C10946 net49 VPWR 6.06912f
C10947 net2 _295_/a_193_47# 0.0314f
C10948 _129_/a_47_47# _051_ 0
C10949 VPWR _280_/a_1270_413# 0
C10950 fanout58/a_27_47# _007_ 0.01133f
C10951 net52 s[7] 0.01123f
C10952 fanout61/a_27_47# net62 0.02084f
C10953 _291_/a_193_47# a[9] 0
C10954 _188_/a_215_297# _184_/a_47_47# 0
C10955 _266_/a_1283_21# net35 0
C10956 net26 _281_/a_193_47# 0.01248f
C10957 net29 _298_/a_27_47# 0
C10958 input36/a_27_47# delay_sel[2] 0.03254f
C10959 _301_/a_193_47# net60 0.00283f
C10960 _099_ genblk1\[12\].fa_inst.a 0
C10961 net24 a[11] 0
C10962 _087_ _088_ 0.30759f
C10963 _286_/a_1108_47# net19 0.03808f
C10964 net46 pmu_inst/dc_inst.x7.net5 0
C10965 clknet_2_2__leaf_clk_regs _297_/a_1108_47# 0.03757f
C10966 output42/a_27_47# net43 0
C10967 _188_/a_215_297# _097_ 0
C10968 _288_/a_651_413# net56 0
C10969 net39 pmu_inst/dc_inst.x2.net16 0
C10970 _022_ net36 0
C10971 s[4] s[5] 0
C10972 _256_/a_761_289# genblk1\[1\].fa_inst.s 0.00151f
C10973 _270_/a_543_47# clknet_2_3__leaf_clk_regs 0.03396f
C10974 net5 clknet_2_3__leaf_clk_regs 0.1781f
C10975 net46 pmu_inst/dc_inst.net6 0
C10976 genblk1\[0\].fa_inst.a _135_/a_27_413# 0
C10977 _291_/a_193_47# net12 0
C10978 clk_regs VPWR 0.69179f
C10979 _304_/a_1217_47# genblk1\[1\].fa_inst.b 0
C10980 net14 input16/a_75_212# 0
C10981 net26 _278_/a_193_47# 0.01351f
C10982 _199_/a_377_297# _105_ 0
C10983 _018_ VPWR 0.11959f
C10984 net5 net32 0.03623f
C10985 genblk1\[12\].fa_inst.b net7 0
C10986 net39 pmu_inst/dc_inst.net5 0
C10987 VPWR _135_/a_382_47# -0
C10988 _258_/a_448_47# genblk1\[3\].fa_inst.s 0.00211f
C10989 net55 pmu_inst/dc_inst.x5.net3 0
C10990 _272_/a_27_47# clknet_2_0__leaf_clk_regs 0.089f
C10991 pmu_inst/dc_inst.x3.net9 cout_next 0
C10992 input3/a_27_47# a[13] 0
C10993 net58 _262_/a_1283_21# 0.02434f
C10994 _282_/a_448_47# genblk1\[10\].fa_inst.a 0
C10995 _108_ _193_/a_215_297# 0
C10996 genblk1\[3\].fa_inst.a genblk1\[1\].fa_inst.b 0.13194f
C10997 _258_/a_27_47# net57 0.00603f
C10998 _290_/a_27_47# net14 0.03793f
C10999 _290_/a_193_47# a[7] 0
C11000 net28 _295_/a_1217_47# 0
C11001 net27 b[4] 0.00149f
C11002 genblk1\[0\].fa_inst.a _053_ 0.00111f
C11003 b[7] input29/a_75_212# 0.00306f
C11004 input30/a_75_212# b[6] 0
C11005 net54 net34 0.02399f
C11006 genblk1\[3\].fa_inst.a _288_/a_1283_21# 0.00126f
C11007 _276_/a_1217_47# net36 0
C11008 fanout60/a_27_47# _268_/a_1108_47# 0
C11009 net5 b[2] 0
C11010 cin_q _304_/a_193_47# 0
C11011 _184_/a_129_47# VPWR -0
C11012 genblk1\[4\].fa_inst.b _069_ 0
C11013 _303_/a_543_47# _287_/a_27_47# 0
C11014 net61 genblk1\[13\].fa_inst.s 0
C11015 net13 net14 2.42453f
C11016 _286_/a_27_47# net36 0.03638f
C11017 clknet_2_3__leaf_clk_regs clknet_2_2__leaf_clk_regs 1.66347f
C11018 _301_/a_1462_47# net60 0
C11019 output42/a_27_47# net42 0.12258f
C11020 VPWR _283_/a_805_47# 0
C11021 _303_/a_805_47# net60 0
C11022 VPWR _279_/a_543_47# 0.0163f
C11023 VPWR _282_/a_639_47# 0
C11024 clknet_2_2__leaf_clk_regs net32 0.80313f
C11025 _188_/a_27_413# genblk1\[11\].fa_inst.a 0
C11026 VPWR pmu_inst/dc_inst.x5.net14 0
C11027 net58 _262_/a_448_47# 0
C11028 input27/a_75_212# b[6] 0
C11029 _044_ clknet_2_2__leaf_clk_regs 0
C11030 genblk1\[0\].fa_inst.b _288_/a_1283_21# 0.00191f
C11031 _257_/a_1270_413# net57 0
C11032 _259_/a_1283_21# fanout57/a_27_47# 0.0044f
C11033 _302_/a_761_289# VPWR 0.01433f
C11034 net46 pmu_inst/dc_inst.x6.net13 0.00404f
C11035 _054_ _304_/a_1108_47# 0
C11036 _271_/a_1283_21# net37 0
C11037 _276_/a_193_47# _291_/a_1108_47# 0
C11038 net5 net19 0
C11039 VPWR delay_sel[2] 0.36876f
C11040 _271_/a_1283_21# net45 0
C11041 s[12] s[11] 0
C11042 VPWR pmu_inst/_15_/a_600_345# 0.00195f
C11043 _008_ net59 0.03835f
C11044 _293_/a_1283_21# _150_/a_68_297# 0
C11045 _003_ genblk1\[3\].fa_inst.s 0.00207f
C11046 _259_/a_27_47# clkbuf_2_0__f_clk_regs/a_110_47# 0
C11047 _023_ _278_/a_1270_413# 0
C11048 clknet_2_2__leaf_clk_regs b[2] 0
C11049 _272_/a_1217_47# clknet_2_0__leaf_clk_regs 0
C11050 _272_/a_639_47# _017_ -0
C11051 _272_/a_448_47# genblk1\[0\].fa_inst.a 0
C11052 _279_/a_1270_413# _024_ -0
C11053 _279_/a_1108_47# genblk1\[7\].fa_inst.a 0
C11054 _027_ genblk1\[10\].fa_inst.a 0
C11055 net39 pmu_inst/dc_inst.x1.net1 0.01727f
C11056 clknet_0_clk_regs _264_/a_543_47# 0
C11057 net39 pmu_inst/_04_ 0
C11058 net7 _279_/a_639_47# 0
C11059 fanout58/a_27_47# _008_ 0
C11060 _272_/a_639_47# VPWR 0
C11061 net46 pmu_inst/dc_inst.x6.net12 0.00459f
C11062 _293_/a_1108_47# _038_ -0.01297f
C11063 _302_/a_448_47# _047_ 0
C11064 net24 net36 1.86038f
C11065 net51 output51/a_27_47# 0.0207f
C11066 input7/a_27_47# a[15] 0.014f
C11067 s[8] output52/a_27_47# 0
C11068 clknet_2_2__leaf_clk_regs _298_/a_543_47# 0
C11069 _302_/a_1270_413# net7 0
C11070 _269_/a_543_47# cout_next 0
C11071 _270_/a_27_47# net34 0
C11072 net33 _109_ 0.00901f
C11073 net21 _287_/a_27_47# 0
C11074 cin_q _304_/a_1462_47# 0
C11075 _259_/a_761_289# net57 0.00139f
C11076 genblk1\[6\].fa_inst.b net17 0.03309f
C11077 _188_/a_298_297# VPWR -0.01469f
C11078 net46 pmu_inst/dc_inst.x5.net17 0.01159f
C11079 _276_/a_761_289# net36 0.00681f
C11080 VPWR _153_/a_215_297# -0.00173f
C11081 _153_/a_27_413# _072_ 0
C11082 _293_/a_761_289# clknet_2_1__leaf_clk_regs 0.02198f
C11083 net62 genblk1\[7\].fa_inst.a 0.03137f
C11084 _270_/a_639_47# net61 0
C11085 net5 b[1] 0
C11086 net46 pmu_inst/dc_inst.x2.x10/a_27_47# 0
C11087 _062_ _059_ 0
C11088 VPWR pmu_inst/dc_inst.x4.net19 0
C11089 _205_/a_47_47# _204_/a_561_297# 0.00102f
C11090 _269_/a_193_47# genblk1\[14\].fa_inst.s 0.06421f
C11091 clknet_2_2__leaf_clk_regs net19 0.02309f
C11092 net16 _023_ 0
C11093 _294_/a_193_47# _280_/a_193_47# 0
C11094 _274_/a_651_413# _273_/a_27_47# 0
C11095 _274_/a_27_47# _273_/a_651_413# 0
C11096 _274_/a_1283_21# _273_/a_543_47# 0.00371f
C11097 net3 net16 0.02167f
C11098 VPWR _174_/a_285_47# 0
C11099 VPWR genblk1\[10\].fa_inst.a 0.79298f
C11100 VPWR pmu_inst/dc_inst.x5.net5 0
C11101 _255_/a_193_47# genblk1\[0\].fa_inst.s 0.0428f
C11102 _255_/a_27_47# _000_ 0.00158f
C11103 _292_/a_193_47# net16 0.03055f
C11104 _265_/a_1283_21# genblk1\[10\].fa_inst.s 0
C11105 _271_/a_193_47# _271_/a_543_47# -0.01294f
C11106 genblk1\[11\].fa_inst.b _180_/a_150_297# 0
C11107 _256_/a_1283_21# VPWR 0.03544f
C11108 _054_ net33 0.00124f
C11109 _179_/a_285_47# genblk1\[10\].fa_inst.s 0.00392f
C11110 _276_/a_1462_47# net36 0
C11111 _292_/a_1108_47# net17 0.00396f
C11112 VPWR a[15] 0.23684f
C11113 _303_/a_1108_47# net34 0.05313f
C11114 genblk1\[6\].fa_inst.b _163_/a_298_297# 0
C11115 _064_ _062_ 0.13294f
C11116 _129_/a_47_47# _134_/a_285_47# 0
C11117 _129_/a_285_47# _134_/a_47_47# 0
C11118 _258_/a_639_47# clknet_2_0__leaf_clk_regs 0
C11119 VPWR net68 0.279f
C11120 genblk1\[12\].fa_inst.s _267_/a_193_47# 0.00599f
C11121 cin_q _050_ 0.01731f
C11122 net39 pmu_inst/dc_inst.x2.net2 0.00921f
C11123 _297_/a_27_47# net32 0.08967f
C11124 _258_/a_651_413# VPWR 0
C11125 net58 fanout57/a_27_47# 0.05148f
C11126 output49/a_27_47# VPWR 0.09827f
C11127 _281_/a_193_47# _295_/a_27_47# 0
C11128 input26/a_75_212# b[4] 0
C11129 _270_/a_27_47# genblk1\[15\].fa_inst.s 0.03304f
C11130 _017_ genblk1\[0\].fa_inst.a 0.04603f
C11131 VPWR _191_/a_113_47# -0
C11132 net27 net5 0.03721f
C11133 net33 genblk1\[9\].fa_inst.a 0.88556f
C11134 _130_/a_215_297# _051_ 0.00267f
C11135 genblk1\[0\].fa_inst.a VPWR 0.2931f
C11136 _130_/a_27_413# _050_ 0.00203f
C11137 _277_/a_193_47# clknet_2_0__leaf_clk_regs 0
C11138 clknet_2_1__leaf_clk_regs _262_/a_193_47# 0.00313f
C11139 clkbuf_2_0__f_clk_regs/a_110_47# _260_/a_193_47# 0.00164f
C11140 _303_/a_543_47# net36 0.00792f
C11141 net36 b[6] 0
C11142 _277_/a_27_47# _292_/a_193_47# 0
C11143 _259_/a_1217_47# net57 0
C11144 genblk1\[11\].fa_inst.b _299_/a_543_47# 0
C11145 clknet_2_0__leaf_clk_regs hold1/a_49_47# 0
C11146 cin_q _139_/a_285_47# 0
C11147 _276_/a_1270_413# _035_ 0
C11148 net25 a[13] 0
C11149 net39 pmu_inst/_16_/a_229_47# 0.00199f
C11150 _140_/a_68_297# genblk1\[2\].fa_inst.b 0
C11151 _293_/a_543_47# clknet_2_1__leaf_clk_regs 0.03568f
C11152 net59 _297_/a_543_47# 0.00158f
C11153 net45 net61 0.00108f
C11154 net47 pmu_inst/dc_inst.x7.x14/a_27_47# 0.00338f
C11155 net39 pmu_inst/dc_inst.x1.x17/a_27_47# 0
C11156 _290_/a_761_289# net12 0.00224f
C11157 _112_ _111_ 0.03938f
C11158 net75 _135_/a_27_413# 0
C11159 VPWR a[1] 0.07965f
C11160 net1 net8 0.3353f
C11161 net33 genblk1\[6\].fa_inst.a 0.24787f
C11162 _274_/a_193_47# _018_ 0.00254f
C11163 _274_/a_543_47# clknet_2_1__leaf_clk_regs 0.00363f
C11164 _019_ _273_/a_193_47# 0.00362f
C11165 _001_ clknet_2_0__leaf_clk_regs 0
C11166 _291_/a_193_47# genblk1\[3\].fa_inst.b 0.00353f
C11167 _291_/a_1283_21# _036_ 0.00164f
C11168 genblk1\[12\].fa_inst.b _101_ 0.00138f
C11169 genblk1\[11\].fa_inst.b net60 0
C11170 _255_/a_1270_413# net39 0
C11171 _275_/a_1108_47# net56 0
C11172 _255_/a_1462_47# genblk1\[0\].fa_inst.s 0
C11173 net29 _280_/a_193_47# 0.03495f
C11174 _265_/a_1108_47# net40 0.00144f
C11175 _271_/a_1108_47# clknet_2_3__leaf_clk_regs 0
C11176 clknet_2_3__leaf_clk_regs _299_/a_27_47# 0.02547f
C11177 _093_ _095_ 0.06253f
C11178 _258_/a_761_289# net48 0
C11179 _258_/a_1108_47# _003_ 0.00995f
C11180 clknet_2_3__leaf_clk_regs genblk1\[10\].fa_inst.s 0.06372f
C11181 net4 _295_/a_193_47# 0.01779f
C11182 net27 clknet_2_2__leaf_clk_regs 0.02724f
C11183 net27 net17 0.03225f
C11184 _004_ _259_/a_543_47# 0
C11185 _259_/a_448_47# clkbuf_2_0__f_clk_regs/a_110_47# 0
C11186 delay_sel[1] input36/a_27_47# 0
C11187 input35/a_27_47# delay_sel[2] 0.00236f
C11188 net28 genblk1\[11\].fa_inst.a 0
C11189 net71 pmu_inst/dc_inst.x5.net14 -0
C11190 net47 pmu_inst/dc_inst.x7.net13 0.00395f
C11191 genblk1\[8\].fa_inst.b _296_/a_1283_21# 0.00127f
C11192 _299_/a_27_47# net32 0
C11193 _293_/a_448_47# _278_/a_1108_47# 0
C11194 input8/a_75_212# a[1] 0.01895f
C11195 _304_/a_27_47# _304_/a_1283_21# -0
C11196 _304_/a_193_47# _304_/a_543_47# -0.01017f
C11197 net75 _053_ 0.05359f
C11198 _168_/a_27_413# genblk1\[7\].fa_inst.b 0.00131f
C11199 net60 _299_/a_761_289# 0.02324f
C11200 genblk1\[12\].fa_inst.s _267_/a_1462_47# 0
C11201 _044_ _299_/a_27_47# 0.00798f
C11202 VPWR pmu_inst/dc_inst.x2.net4 0
C11203 _155_/a_68_297# genblk1\[5\].fa_inst.b 0
C11204 _297_/a_805_47# _042_ -0.00125f
C11205 net2 genblk1\[10\].fa_inst.a 0
C11206 _268_/a_543_47# clknet_2_3__leaf_clk_regs 0.00605f
C11207 _270_/a_1217_47# genblk1\[15\].fa_inst.s 0
C11208 _262_/a_761_289# net62 0
C11209 net2 a[15] 0
C11210 net21 net36 0.02554f
C11211 net39 pmu_inst/_19_/a_193_297# 0.00194f
C11212 cout_next net62 2.91036f
C11213 _275_/a_1108_47# _020_ 0.00643f
C11214 _275_/a_761_289# genblk1\[3\].fa_inst.a 0
C11215 _274_/a_543_47# net11 0
C11216 clknet_0_clk_regs _260_/a_639_47# 0
C11217 a[14] input7/a_27_47# 0
C11218 input6/a_27_47# a[15] 0
C11219 net61 _265_/a_1108_47# 0
C11220 _268_/a_1108_47# net60 0.00134f
C11221 _277_/a_761_289# clknet_2_1__leaf_clk_regs 0
C11222 genblk1\[4\].fa_inst.b _146_/a_113_47# 0
C11223 _296_/a_651_413# net30 0.00266f
C11224 net29 net30 0.02505f
C11225 clkbuf_2_3__f_clk_regs/a_110_47# _266_/a_27_47# 0.02525f
C11226 a[11] net15 0.0335f
C11227 VPWR _285_/a_1283_21# 0.04469f
C11228 _021_ _291_/a_1283_21# 0
C11229 _169_/a_285_47# _084_ 0.00633f
C11230 _065_ net36 0
C11231 _260_/a_651_413# genblk1\[5\].fa_inst.s 0
C11232 net46 pmu_inst/dc_inst.x4.x10/a_27_47# 0
C11233 _289_/a_1270_413# net11 0
C11234 clknet_0_clk_regs _263_/a_1108_47# 0
C11235 _185_/a_150_297# genblk1\[12\].fa_inst.a 0
C11236 net60 net59 0.00241f
C11237 _274_/a_639_47# genblk1\[1\].fa_inst.a 0
C11238 _039_ clknet_2_1__leaf_clk_regs -0
C11239 genblk1\[8\].fa_inst.s net53 0
C11240 VPWR _264_/a_27_47# 0.03899f
C11241 net59 genblk1\[10\].fa_inst.b 0.08524f
C11242 _302_/a_761_289# net20 0
C11243 _300_/a_543_47# net7 0.00213f
C11244 _299_/a_27_47# net19 0.15382f
C11245 _271_/a_448_47# net38 0
C11246 _287_/a_193_47# clknet_2_3__leaf_clk_regs 0.00604f
C11247 _273_/a_1283_21# net9 0
C11248 VPWR _141_/a_113_47# -0
C11249 clkbuf_1_0__f_clk/a_110_47# net50 0
C11250 net53 net52 0
C11251 genblk1\[10\].fa_inst.b _298_/a_27_47# 0
C11252 cin input36/a_27_47# 0.00432f
C11253 input33/a_27_47# delay_sel[2] 0
C11254 _285_/a_805_47# net7 0
C11255 VPWR a[14] 0.23677f
C11256 _294_/a_193_47# _279_/a_651_413# 0
C11257 _302_/a_27_47# _286_/a_543_47# 0
C11258 _302_/a_543_47# _286_/a_27_47# 0
C11259 _267_/a_543_47# clknet_2_3__leaf_clk_regs 0.00542f
C11260 genblk1\[1\].fa_inst.b _135_/a_27_413# 0
C11261 net5 input26/a_75_212# 0.00552f
C11262 _080_ _160_/a_68_297# 0
C11263 _084_ _077_ 0
C11264 _060_ genblk1\[2\].fa_inst.b 0
C11265 _282_/a_651_413# _296_/a_761_289# 0
C11266 _282_/a_1108_47# _296_/a_1283_21# 0
C11267 output55/a_27_47# pmu_inst_70/HI 0
C11268 _277_/a_543_47# net36 0
C11269 net59 _298_/a_193_47# 0.00133f
C11270 _287_/a_543_47# net60 0.007f
C11271 genblk1\[4\].fa_inst.b _066_ 0.0566f
C11272 cout_next net69 1.27834f
C11273 clk clkbuf_regs_0_clk/a_110_47# 0.32449f
C11274 _264_/a_761_289# genblk1\[9\].fa_inst.s 0
C11275 _039_ _025_ 0.00139f
C11276 net27 _297_/a_27_47# 0
C11277 clkload1/Y clknet_2_2__leaf_clk_regs 0.05054f
C11278 _267_/a_1108_47# net60 0
C11279 net33 _148_/a_27_413# 0
C11280 _259_/a_651_413# net36 0
C11281 _157_/a_113_47# genblk1\[7\].fa_inst.a 0
C11282 VPWR _284_/a_1283_21# 0.05973f
C11283 net39 pmu_inst/_10_ 0
C11284 genblk1\[1\].fa_inst.b _053_ 0
C11285 _291_/a_651_413# _290_/a_1283_21# 0
C11286 _144_/a_47_47# _060_ 0
C11287 VPWR delay_sel[1] 0.15618f
C11288 _300_/a_1270_413# VPWR 0
C11289 net47 pmu_inst/_25_/a_27_47# 0.01518f
C11290 clknet_0_clk_regs net50 0.0333f
C11291 _262_/a_543_47# _262_/a_27_47# -0.00157f
C11292 net58 _263_/a_543_47# 0
C11293 b[7] _298_/a_193_47# 0
C11294 _198_/a_215_297# _101_ 0.10636f
C11295 _198_/a_298_297# genblk1\[13\].fa_inst.b 0
C11296 net49 net57 0.08803f
C11297 net33 clknet_2_3__leaf_clk_regs 0.02589f
C11298 net33 _299_/a_1108_47# 0.00834f
C11299 net47 pmu_inst/_24_/a_805_47# 0
C11300 clknet_2_1__leaf_clk_regs a[13] 0
C11301 _039_ _279_/a_193_47# 0
C11302 _280_/a_27_47# net16 0.0242f
C11303 _268_/a_761_289# net43 0
C11304 _268_/a_1108_47# _013_ 0.00978f
C11305 _096_ _094_ 0.00239f
C11306 genblk1\[0\].fa_inst.s genblk1\[0\].fa_inst.b 0
C11307 net46 pmu_inst/dc_inst.x6.net10 0.01307f
C11308 _276_/a_193_47# _035_ 0.03767f
C11309 clkload2/a_27_47# clknet_0_clk_regs 0.00215f
C11310 VPWR pmu_inst/dc_inst.x5.x4/a_27_47# 0
C11311 clknet_2_1__leaf_clk_regs _278_/a_761_289# 0.0221f
C11312 net17 _280_/a_1283_21# 0.0079f
C11313 _009_ net62 0
C11314 net46 pmu_inst/dc_inst.x2.x17/a_27_47# 0.00261f
C11315 _290_/a_27_47# net56 0
C11316 _159_/a_285_47# genblk1\[6\].fa_inst.s 0.00119f
C11317 VPWR pmu_inst/dc_inst.x3.net14 0
C11318 genblk1\[3\].fa_inst.b _068_ 0
C11319 _291_/a_543_47# net36 0.00643f
C11320 _085_ net59 0
C11321 _283_/a_27_47# b[6] 0
C11322 net33 _044_ 0.00574f
C11323 clknet_2_0__leaf_clk_regs net10 0.01629f
C11324 genblk1\[2\].fa_inst.s _304_/a_1283_21# 0
C11325 genblk1\[2\].fa_inst.a genblk1\[1\].fa_inst.a 0.25935f
C11326 net7 _284_/a_805_47# 0
C11327 _084_ _173_/a_215_297# 0.01025f
C11328 _016_ net38 0.00109f
C11329 clknet_2_1__leaf_clk_regs net9 0.24431f
C11330 fanout61/a_27_47# clk 0
C11331 _098_ _193_/a_27_413# 0.04506f
C11332 _274_/a_448_47# clknet_2_0__leaf_clk_regs 0.01376f
C11333 VPWR pmu_inst/dc_inst.x7.net9 0.02184f
C11334 _287_/a_193_47# _287_/a_448_47# -0.00297f
C11335 net75 VPWR 0.28695f
C11336 net47 pmu_inst/dc_inst.in 0.01027f
C11337 _274_/a_1283_21# VPWR 0.01448f
C11338 _292_/a_651_413# _036_ 0
C11339 net58 _278_/a_1283_21# 0.00752f
C11340 net28 _293_/a_761_289# 0
C11341 _027_ _296_/a_543_47# 0
C11342 _282_/a_543_47# _041_ 0
C11343 net59 _298_/a_1462_47# 0
C11344 _270_/a_1283_21# fanout61/a_27_47# 0.00126f
C11345 net47 pmu_inst/clkbuf_1_1__f_clk/a_110_47# 0.01555f
C11346 net15 net36 0.02375f
C11347 _026_ _040_ 0.00205f
C11348 net48 cout_next 0.13754f
C11349 genblk1\[4\].fa_inst.a _145_/a_68_297# 0.05537f
C11350 genblk1\[6\].fa_inst.b net33 0.08336f
C11351 clknet_2_3__leaf_clk_regs net35 0.13092f
C11352 _302_/a_639_47# genblk1\[14\].fa_inst.b 0
C11353 _102_ _101_ 0.69307f
C11354 net2 a[14] 0
C11355 tdo VPWR 0.05193f
C11356 VPWR _289_/a_639_47# 0
C11357 _279_/a_761_289# _278_/a_193_47# 0
C11358 _279_/a_543_47# _278_/a_27_47# 0
C11359 output42/a_27_47# VPWR 0.04196f
C11360 _013_ _267_/a_1108_47# 0
C11361 _292_/a_27_47# _292_/a_1108_47# -0
C11362 _274_/a_27_47# net8 0
C11363 _272_/a_1108_47# _288_/a_1108_47# 0.00103f
C11364 _051_ net56 0.03743f
C11365 _257_/a_1108_47# net47 0.0019f
C11366 _257_/a_1270_413# _002_ 0
C11367 _178_/a_382_47# _092_ 0.00106f
C11368 VPWR cin 0.32109f
C11369 net46 pmu_inst/dc_inst.x4.x5/a_27_47# 0.00543f
C11370 _131_/a_68_297# _131_/a_150_297# 0
C11371 cin_q _135_/a_215_297# 0.0172f
C11372 net47 pmu_inst/_25_/a_1217_47# 0
C11373 net35 net32 0.04134f
C11374 net33 net19 0
C11375 input6/a_27_47# a[14] 0.01404f
C11376 _198_/a_298_297# _201_/a_61_47# 0
C11377 _044_ net35 0
C11378 net47 pmu_inst/dc_inst.x8/a_834_97# 0
C11379 _039_ _279_/a_1462_47# 0
C11380 net11 net9 0
C11381 net47 pmu_inst/dc_inst.x9/a_757_363# 0
C11382 _148_/a_215_297# net36 0.01859f
C11383 net4 _279_/a_543_47# 0.014f
C11384 VPWR _286_/a_1283_21# 0.02143f
C11385 VPWR input14/a_75_212# 0.08616f
C11386 net61 _267_/a_639_47# 0
C11387 _130_/a_27_413# _135_/a_215_297# 0.00355f
C11388 _290_/a_1217_47# net56 0
C11389 _291_/a_193_47# _276_/a_1283_21# 0
C11390 pmu_inst/_17_/a_478_47# cout_next 0
C11391 net58 net17 0.35527f
C11392 _302_/a_1283_21# _301_/a_1283_21# 0
C11393 _302_/a_1108_47# _301_/a_543_47# 0
C11394 _302_/a_651_413# _301_/a_193_47# 0
C11395 VPWR pmu_inst/dc_inst.x5.net2 0
C11396 net47 pmu_inst/dc_inst.x1.net3 0.00215f
C11397 VPWR _296_/a_543_47# 0.01833f
C11398 _198_/a_27_413# _106_ 0
C11399 net61 net43 0.1186f
C11400 VPWR _194_/a_129_47# -0
C11401 _292_/a_761_289# _277_/a_1283_21# 0
C11402 _282_/a_1108_47# clknet_2_2__leaf_clk_regs 0
C11403 _282_/a_27_47# genblk1\[9\].fa_inst.a 0
C11404 _283_/a_448_47# clknet_2_2__leaf_clk_regs 0
C11405 net46 pmu_inst/dc_inst.x1.x8/a_27_47# 0.00105f
C11406 clknet_2_0__leaf_clk_regs _260_/a_1270_413# 0
C11407 genblk1\[5\].fa_inst.a net16 0
C11408 net39 pmu_inst/dc_inst.x5.x13/a_27_47# 0.00217f
C11409 _019_ clknet_2_0__leaf_clk_regs 0.30189f
C11410 _079_ _159_/a_285_47# 0
C11411 _287_/a_193_47# _032_ 0
C11412 _104_ genblk1\[13\].fa_inst.b 0
C11413 VPWR net41 8.69053f
C11414 _290_/a_27_47# _290_/a_193_47# -0.00547f
C11415 net35 _298_/a_543_47# 0
C11416 _302_/a_1108_47# genblk1\[14\].fa_inst.a 0
C11417 clkload0/a_27_47# net58 0
C11418 VPWR _260_/a_448_47# 0
C11419 clknet_0_clk_regs _265_/a_193_47# 0.00273f
C11420 clk clkbuf_2_3__f_clk_regs/a_110_47# 0.04687f
C11421 _275_/a_761_289# _273_/a_543_47# 0
C11422 _275_/a_27_47# _273_/a_1108_47# 0
C11423 _275_/a_1108_47# _273_/a_27_47# 0
C11424 _275_/a_1283_21# _273_/a_193_47# 0
C11425 net28 _293_/a_543_47# 0.00204f
C11426 _189_/a_47_47# _097_ 0.01688f
C11427 _021_ _290_/a_1108_47# 0
C11428 _267_/a_1108_47# _012_ 0.00643f
C11429 _267_/a_761_289# net42 0
C11430 net7 _296_/a_639_47# 0.00162f
C11431 genblk1\[1\].fa_inst.b _136_/a_68_297# 0
C11432 s[6] s[7] 0
C11433 _290_/a_193_47# net13 0
C11434 genblk1\[5\].fa_inst.a _147_/a_113_47# 0
C11435 VPWR _263_/a_761_289# 0
C11436 _096_ _092_ 0.00974f
C11437 input35/a_27_47# delay_sel[1] 0.02188f
C11438 _199_/a_285_47# _107_ 0.00416f
C11439 _199_/a_377_297# genblk1\[14\].fa_inst.s 0
C11440 net35 net19 0.02722f
C11441 net46 pmu_inst/dc_inst.x7.net7 0.00119f
C11442 net46 pmu_inst/dc_inst.x5.net19 0.03245f
C11443 VPWR genblk1\[1\].fa_inst.b 1.89133f
C11444 _292_/a_27_47# net27 0.38403f
C11445 net26 _295_/a_27_47# 0.00889f
C11446 _036_ net25 0
C11447 _017_ _288_/a_1283_21# 0
C11448 clknet_2_0__leaf_clk_regs _288_/a_448_47# 0.00379f
C11449 genblk1\[0\].fa_inst.a _288_/a_193_47# 0
C11450 genblk1\[2\].fa_inst.s net47 0
C11451 net26 _035_ 0
C11452 _300_/a_543_47# _030_ 0
C11453 clkbuf_2_1__f_clk_regs/a_110_47# _261_/a_448_47# 0
C11454 _007_ _262_/a_27_47# -0.00107f
C11455 VPWR _281_/a_543_47# 0.01619f
C11456 _108_ _201_/a_637_47# 0
C11457 net5 input31/a_75_212# 0.00552f
C11458 net36 _038_ 0
C11459 VPWR pmu_inst/dc_inst.x6.x1/a_27_47# 0.00495f
C11460 VPWR _288_/a_1283_21# 0.03512f
C11461 genblk1\[3\].fa_inst.a net36 0.05237f
C11462 _297_/a_543_47# net30 0.0079f
C11463 net33 _032_ 0.00865f
C11464 net4 genblk1\[10\].fa_inst.a 0
C11465 net46 pmu_inst/dc_inst.x2.net11 0
C11466 _286_/a_1283_21# _285_/a_193_47# 0
C11467 _286_/a_1108_47# _285_/a_27_47# 0
C11468 _277_/a_27_47# genblk1\[5\].fa_inst.a 0
C11469 _190_/a_150_297# genblk1\[13\].fa_inst.b 0
C11470 _190_/a_68_297# _101_ 0
C11471 net61 net42 0.17837f
C11472 _294_/a_27_47# _280_/a_193_47# 0
C11473 _051_ _055_ 0
C11474 _302_/a_543_47# net21 0.01912f
C11475 VPWR _193_/a_27_413# 0.03092f
C11476 _100_ _193_/a_27_413# 0
C11477 _061_ _058_ 0
C11478 _150_/a_68_297# genblk1\[5\].fa_inst.b 0.01622f
C11479 net16 _279_/a_448_47# 0
C11480 _028_ clknet_2_2__leaf_clk_regs 0
C11481 _269_/a_27_47# _268_/a_27_47# 0
C11482 _076_ _155_/a_68_297# 0
C11483 _270_/a_761_289# VPWR 0.00978f
C11484 _256_/a_1283_21# net57 0.02636f
C11485 genblk1\[7\].fa_inst.s _080_ 0.00262f
C11486 _078_ _077_ 0.20598f
C11487 VPWR _278_/a_543_47# 0.01703f
C11488 clk genblk1\[9\].fa_inst.s 0.01438f
C11489 _277_/a_1270_413# net36 0
C11490 _155_/a_150_297# genblk1\[6\].fa_inst.a 0
C11491 net7 _281_/a_639_47# 0.00198f
C11492 _287_/a_1462_47# _032_ 0
C11493 _287_/a_639_47# genblk1\[15\].fa_inst.a 0
C11494 _143_/a_215_297# net56 0
C11495 _304_/a_193_47# genblk1\[2\].fa_inst.b 0
C11496 VPWR _005_ 1.00001f
C11497 _163_/a_215_297# _073_ 0.06736f
C11498 clknet_0_clk_regs _265_/a_1462_47# 0
C11499 _275_/a_193_47# clknet_2_1__leaf_clk_regs 0.01143f
C11500 _021_ net25 0
C11501 _283_/a_448_47# _297_/a_27_47# 0
C11502 _283_/a_1108_47# _297_/a_193_47# 0
C11503 _283_/a_543_47# _297_/a_543_47# 0.00201f
C11504 _283_/a_193_47# _297_/a_1108_47# 0
C11505 _283_/a_27_47# _297_/a_448_47# 0
C11506 _148_/a_27_413# _059_ 0
C11507 output51/a_27_47# s[6] 0.00932f
C11508 _282_/a_761_289# _297_/a_543_47# 0
C11509 _282_/a_1283_21# _297_/a_193_47# 0
C11510 _282_/a_543_47# _297_/a_761_289# 0
C11511 _205_/a_47_47# _110_ 0.04612f
C11512 _205_/a_377_297# _112_ 0
C11513 _255_/a_543_47# genblk1\[1\].fa_inst.s 0.01028f
C11514 _264_/a_761_289# _009_ 0.00537f
C11515 _301_/a_639_47# VPWR 0
C11516 net39 pmu_inst/dc_inst.x1.x12/a_27_47# 0
C11517 _004_ _258_/a_1108_47# 0
C11518 genblk1\[15\].fa_inst.a net34 0
C11519 _291_/a_448_47# clknet_2_1__leaf_clk_regs 0.00183f
C11520 _290_/a_1283_21# net36 0.00412f
C11521 _039_ net28 0
C11522 _294_/a_1270_413# net17 0
C11523 _032_ net35 0
C11524 _292_/a_805_47# _037_ -0.00125f
C11525 _292_/a_651_413# genblk1\[4\].fa_inst.b 0
C11526 _153_/a_215_297# _070_ 0
C11527 _303_/a_651_413# VPWR -0.00848f
C11528 clknet_2_0__leaf_clk_regs _033_ 0.0014f
C11529 _293_/a_1108_47# VPWR 0.00971f
C11530 net34 genblk1\[15\].fa_inst.s 0
C11531 tdo net71 0
C11532 _269_/a_543_47# clknet_2_3__leaf_clk_regs 0.00193f
C11533 _274_/a_27_47# a[3] 0.00446f
C11534 net1 net17 0.00382f
C11535 VPWR _145_/a_68_297# 0.02347f
C11536 _273_/a_805_47# net56 0
C11537 _262_/a_543_47# _007_ -0
C11538 _148_/a_27_413# _064_ 0.00174f
C11539 _065_ _153_/a_298_297# 0.0166f
C11540 _294_/a_1217_47# net58 0
C11541 net3 _295_/a_651_413# 0.00523f
C11542 _156_/a_113_47# genblk1\[6\].fa_inst.a 0
C11543 net62 genblk1\[6\].fa_inst.a 0
C11544 net46 pmu_inst/dc_inst.x2.net16 0.00285f
C11545 genblk1\[10\].fa_inst.a _170_/a_68_297# 0.00541f
C11546 clkload1/a_110_47# _092_ 0
C11547 clknet_0_clk_regs net59 0.91017f
C11548 net60 _193_/a_215_297# 0
C11549 clkload0/a_361_47# clknet_2_0__leaf_clk_regs 0.00725f
C11550 _189_/a_377_297# _100_ 0.00143f
C11551 net39 pmu_inst/dc_inst.x4.x8/a_27_47# 0.00819f
C11552 _275_/a_761_289# a[4] 0
C11553 _275_/a_193_47# net11 0
C11554 clknet_2_0__leaf_clk_regs net12 0
C11555 _149_/a_285_47# genblk1\[5\].fa_inst.s 0
C11556 VPWR _158_/a_382_47# -0
C11557 net16 _024_ 0
C11558 genblk1\[10\].fa_inst.b net30 0.0011f
C11559 pmu_inst/dc_inst.x5.net2 net71 0
C11560 _066_ _153_/a_215_297# 0.00419f
C11561 net5 _285_/a_27_47# 0.16837f
C11562 _158_/a_298_297# _072_ 0.00297f
C11563 net26 b[3] 0.00149f
C11564 fanout58/a_27_47# clknet_0_clk_regs 0.00106f
C11565 genblk1\[12\].fa_inst.b _299_/a_193_47# 0
C11566 net7 genblk1\[9\].fa_inst.a 0
C11567 net46 pmu_inst/dc_inst.net5 0
C11568 net3 _280_/a_543_47# 0.00665f
C11569 _107_ _201_/a_217_297# 0.00102f
C11570 _037_ net36 0
C11571 _304_/a_1283_21# _135_/a_27_413# 0.00126f
C11572 net33 _137_/a_113_47# 0
C11573 _291_/a_448_47# net11 0
C11574 _290_/a_448_47# _035_ 0
C11575 fanout56/a_27_47# net56 0.03349f
C11576 _163_/a_215_297# VPWR -0.00135f
C11577 net59 _040_ 0.09867f
C11578 _185_/a_68_297# _299_/a_1108_47# 0
C11579 VPWR _159_/a_285_47# 0
C11580 _275_/a_1462_47# clknet_2_1__leaf_clk_regs 0
C11581 net50 pmu_inst_73/HI 0.04894f
C11582 _298_/a_193_47# net30 0.03627f
C11583 _301_/a_761_289# _300_/a_193_47# 0
C11584 _301_/a_543_47# _300_/a_27_47# 0
C11585 _301_/a_193_47# _300_/a_761_289# 0
C11586 clkbuf_2_3__f_clk_regs/a_110_47# _265_/a_27_47# 0
C11587 _283_/a_193_47# net32 0.03162f
C11588 _283_/a_27_47# _042_ 0
C11589 genblk1\[8\].fa_inst.a net15 0
C11590 _282_/a_27_47# net32 0
C11591 _264_/a_805_47# net54 0
C11592 _184_/a_47_47# _095_ 0.05609f
C11593 _293_/a_1283_21# net33 0.00204f
C11594 _054_ hold1/a_49_47# 0.03179f
C11595 _036_ clknet_2_1__leaf_clk_regs 0
C11596 genblk1\[9\].fa_inst.b _297_/a_761_289# 0
C11597 input33/a_27_47# cin 0.01944f
C11598 _258_/a_27_47# genblk1\[3\].fa_inst.s 0.16081f
C11599 net20 _286_/a_1283_21# 0.00899f
C11600 _271_/a_1283_21# net44 0.04571f
C11601 _266_/a_448_47# net41 0
C11602 net39 pmu_inst/dc_inst.x2.x12/a_27_47# 0.00261f
C11603 _276_/a_543_47# _291_/a_193_47# 0
C11604 _285_/a_27_47# clknet_2_2__leaf_clk_regs 0.03968f
C11605 net33 genblk1\[8\].fa_inst.b 0.11361f
C11606 _256_/a_193_47# _255_/a_1108_47# 0
C11607 _256_/a_761_289# _255_/a_1283_21# 0.00362f
C11608 clknet_2_1__leaf_clk_regs clkbuf_2_1__f_clk_regs/a_110_47# 0.11131f
C11609 clk _262_/a_761_289# 0.0449f
C11610 _283_/a_1283_21# net59 0.02406f
C11611 net47 pmu_inst/dc_inst.x1.x3/a_27_47# 0.00144f
C11612 net27 _295_/a_543_47# 0.00385f
C11613 _282_/a_543_47# net59 0
C11614 clk cout_next 0.02585f
C11615 net70 pmu_inst_70/HI 0.00337f
C11616 _142_/a_113_47# net36 0
C11617 _283_/a_1283_21# _298_/a_27_47# 0
C11618 _283_/a_761_289# _298_/a_761_289# 0
C11619 _283_/a_543_47# _298_/a_193_47# 0
C11620 _272_/a_761_289# net56 0.02233f
C11621 net47 pmu_inst/dc_inst.x7.x3/a_27_47# -0
C11622 a[10] a[9] 0.06434f
C11623 _294_/a_193_47# net14 0
C11624 genblk1\[5\].fa_inst.a _067_ 0
C11625 _085_ _088_ 0.13657f
C11626 _269_/a_1108_47# _013_ 0
C11627 _014_ _268_/a_1108_47# 0
C11628 VPWR pmu_inst/dc_inst.net1 0.0123f
C11629 net29 _294_/a_193_47# 0.00495f
C11630 _169_/a_47_47# _173_/a_215_297# 0
C11631 genblk1\[2\].fa_inst.a _289_/a_193_47# 0.00207f
C11632 _294_/a_27_47# _279_/a_651_413# 0
C11633 _270_/a_1283_21# cout_next 0
C11634 _290_/a_1108_47# genblk1\[2\].fa_inst.b 0
C11635 net25 _295_/a_193_47# 0
C11636 clk _264_/a_448_47# 0.01349f
C11637 _304_/a_1108_47# _057_ 0.00142f
C11638 _195_/a_68_297# _105_ 0.00114f
C11639 net46 pmu_inst/dc_inst.x1.net1 0
C11640 net61 _269_/a_639_47# 0
C11641 _099_ genblk1\[12\].fa_inst.b 0.00334f
C11642 net4 _284_/a_1283_21# 0
C11643 net46 pmu_inst/_04_ 0
C11644 _021_ clknet_2_1__leaf_clk_regs 0
C11645 _277_/a_805_47# genblk1\[5\].fa_inst.a 0
C11646 _292_/a_27_47# net58 0.04418f
C11647 clk _266_/a_1283_21# 0.00208f
C11648 _259_/a_1270_413# genblk1\[4\].fa_inst.s 0
C11649 _298_/a_1462_47# net30 0
C11650 _255_/a_1108_47# VPWR 0.01454f
C11651 _289_/a_448_47# genblk1\[1\].fa_inst.b 0
C11652 _292_/a_1108_47# _277_/a_1108_47# 0
C11653 _188_/a_27_413# _095_ 0
C11654 _188_/a_298_297# _093_ 0.02112f
C11655 _188_/a_382_47# _094_ 0
C11656 clknet_2_1__leaf_clk_regs input13/a_75_212# 0.00601f
C11657 net3 _283_/a_1108_47# 0
C11658 pmu_inst/_18_/a_439_47# net64 0
C11659 genblk1\[7\].fa_inst.b _295_/a_1108_47# 0
C11660 _301_/a_1108_47# genblk1\[13\].fa_inst.b 0
C11661 _275_/a_1283_21# clknet_2_0__leaf_clk_regs 0
C11662 b[2] input17/a_27_47# 0
C11663 _097_ _193_/a_298_297# 0.02423f
C11664 _284_/a_27_47# clknet_2_2__leaf_clk_regs 0.0123f
C11665 clknet_2_3__leaf_clk_regs net62 0.02874f
C11666 _300_/a_1283_21# clknet_2_2__leaf_clk_regs 0
C11667 net33 net58 0.02992f
C11668 _275_/a_761_289# VPWR 0.01205f
C11669 clknet_0_clk_regs _261_/a_193_47# 0
C11670 _038_ _155_/a_68_297# 0
C11671 _011_ net41 0.14587f
C11672 VPWR pmu_inst/_20_/a_384_47# 0.00389f
C11673 genblk1\[6\].fa_inst.b _155_/a_150_297# 0
C11674 _277_/a_1283_21# fanout56/a_27_47# 0.00204f
C11675 input10/a_75_212# net9 0
C11676 _256_/a_27_47# _000_ 0
C11677 _256_/a_193_47# genblk1\[0\].fa_inst.s 0.00178f
C11678 genblk1\[5\].fa_inst.b _278_/a_1283_21# 0
C11679 _261_/a_1108_47# net51 0.00144f
C11680 _291_/a_651_413# VPWR 0.00112f
C11681 _269_/a_27_47# genblk1\[15\].fa_inst.s 0
C11682 _271_/a_1283_21# VPWR 0.01758f
C11683 _274_/a_651_413# genblk1\[2\].fa_inst.a 0
C11684 _281_/a_193_47# _296_/a_761_289# 0
C11685 _281_/a_27_47# _296_/a_543_47# 0.00156f
C11686 _281_/a_761_289# _296_/a_193_47# 0
C11687 _281_/a_543_47# _296_/a_27_47# 0
C11688 _021_ net11 0
C11689 net59 genblk1\[9\].fa_inst.b 0.13088f
C11690 _038_ _279_/a_1283_21# 0.00173f
C11691 VPWR _297_/a_805_47# 0
C11692 clkbuf_2_2__f_clk_regs/a_110_47# clknet_2_2__leaf_clk_regs 0.0722f
C11693 _274_/a_761_289# net9 0
C11694 _257_/a_27_47# clknet_2_0__leaf_clk_regs 0.01914f
C11695 _022_ net17 0.02902f
C11696 net29 net14 0
C11697 net46 pmu_inst/dc_inst.x2.net2 0.00342f
C11698 genblk1\[2\].fa_inst.a _289_/a_1462_47# 0
C11699 net49 _259_/a_543_47# 0
C11700 net25 genblk1\[2\].fa_inst.b 0
C11701 clk _009_ 0.03498f
C11702 net33 _057_ 0
C11703 _039_ _294_/a_1283_21# 0.00785f
C11704 VPWR _268_/a_761_289# 0.00878f
C11705 VPWR pmu_inst/dc_inst.x8/a_757_363# -0
C11706 _293_/a_1108_47# _069_ 0
C11707 net61 net44 0.22791f
C11708 b[9] net36 0
C11709 _292_/a_1217_47# net58 0
C11710 _263_/a_27_47# _263_/a_193_47# -0.00487f
C11711 net7 clknet_2_3__leaf_clk_regs 0.10465f
C11712 _301_/a_639_47# net20 0
C11713 _194_/a_285_47# genblk1\[13\].fa_inst.s 0.003f
C11714 net17 genblk1\[5\].fa_inst.b 0
C11715 clknet_2_0__leaf_clk_regs _304_/a_448_47# 0.01381f
C11716 genblk1\[0\].fa_inst.s VPWR 1.15524f
C11717 _034_ genblk1\[1\].fa_inst.b 0.11369f
C11718 net27 _277_/a_1108_47# 0
C11719 _302_/a_543_47# _287_/a_651_413# 0
C11720 genblk1\[6\].fa_inst.b _156_/a_113_47# 0
C11721 _149_/a_129_47# VPWR -0
C11722 net3 _279_/a_639_47# 0.0015f
C11723 genblk1\[6\].fa_inst.b net62 0
C11724 _303_/a_193_47# net23 -0
C11725 net7 net32 0
C11726 _304_/a_1283_21# VPWR 0.0153f
C11727 genblk1\[4\].fa_inst.a net36 0.04601f
C11728 _280_/a_651_413# _295_/a_27_47# 0
C11729 genblk1\[7\].fa_inst.b net30 0
C11730 net27 _282_/a_27_47# 0.01768f
C11731 _301_/a_448_47# _286_/a_1283_21# 0
C11732 net21 genblk1\[13\].fa_inst.b 0
C11733 _286_/a_761_289# b[11] 0
C11734 genblk1\[10\].fa_inst.a _178_/a_27_413# 0
C11735 genblk1\[1\].fa_inst.b _288_/a_193_47# 0
C11736 _047_ net60 0.09138f
C11737 net7 _044_ 0.01498f
C11738 input34/a_27_47# net35 0
C11739 delay_sel[0] net34 0.00281f
C11740 _204_/a_33_297# _201_/a_217_297# 0
C11741 net46 pmu_inst/dc_inst.x1.x17/a_27_47# 0
C11742 clknet_0_clk_regs _261_/a_1462_47# 0
C11743 _163_/a_215_297# _075_ 0.00999f
C11744 input24/a_27_47# b[0] 0
C11745 b[1] input17/a_27_47# 0
C11746 _092_ _171_/a_113_47# 0
C11747 net39 pmu_inst/dc_inst.x5.net7 0.02693f
C11748 _158_/a_382_47# _069_ 0.00333f
C11749 clknet_1_0__leaf_clk net50 0.03118f
C11750 _159_/a_285_47# _075_ 0.00424f
C11751 VPWR input30/a_75_212# 0.09161f
C11752 _277_/a_639_47# VPWR 0
C11753 _260_/a_543_47# _005_ 0.00231f
C11754 _260_/a_27_47# net50 0
C11755 _286_/a_27_47# clknet_2_2__leaf_clk_regs 0.03992f
C11756 _256_/a_1270_413# net39 0
C11757 _290_/a_651_413# net11 0.0079f
C11758 _150_/a_150_297# genblk1\[6\].fa_inst.a 0
C11759 genblk1\[6\].fa_inst.s net51 0
C11760 net33 _028_ 0
C11761 _286_/a_651_413# genblk1\[14\].fa_inst.a 0
C11762 _286_/a_805_47# _031_ -0.00125f
C11763 clknet_2_0__leaf_clk_regs _023_ 0
C11764 net47 pmu_inst/_23_/a_651_413# 0
C11765 net29 input29/a_75_212# 0.0021f
C11766 VPWR _299_/a_805_47# 0
C11767 VPWR net40 5.46321f
C11768 net24 net5 0.03693f
C11769 _259_/a_1283_21# clkbuf_2_0__f_clk_regs/a_110_47# 0
C11770 VPWR _287_/a_27_47# 0.06971f
C11771 net56 _058_ 0
C11772 clknet_2_0__leaf_clk_regs net3 0
C11773 net29 _281_/a_651_413# 0.0026f
C11774 _292_/a_193_47# clknet_2_0__leaf_clk_regs 0.02723f
C11775 VPWR _267_/a_761_289# 0.00964f
C11776 net7 _298_/a_543_47# 0.01366f
C11777 VPWR a[11] 0.23691f
C11778 clknet_2_1__leaf_clk_regs _295_/a_193_47# 0
C11779 net36 _279_/a_27_47# 0.00111f
C11780 _295_/a_1108_47# _040_ 0.00621f
C11781 _295_/a_448_47# net30 0.0145f
C11782 VPWR _178_/a_382_47# -0
C11783 genblk1\[14\].fa_inst.a _106_ 0.00364f
C11784 VPWR pmu_inst/dc_inst.x2.net19 0.00124f
C11785 _296_/a_1270_413# _041_ -0
C11786 _296_/a_639_47# net31 0.0015f
C11787 VPWR input27/a_75_212# 0.09177f
C11788 _178_/a_298_297# _086_ 0
C11789 _183_/a_215_297# _090_ 0.03993f
C11790 net46 pmu_inst/_19_/a_193_297# 0.00201f
C11791 input36/a_27_47# net36 0.00174f
C11792 net7 net19 0.49228f
C11793 clknet_2_0__leaf_clk_regs _049_ 0.18232f
C11794 input5/a_27_47# net5 0.00215f
C11795 _078_ genblk1\[7\].fa_inst.a 0.03943f
C11796 _287_/a_448_47# net7 0.01727f
C11797 _302_/a_1283_21# _032_ 0
C11798 genblk1\[11\].fa_inst.s net35 0
C11799 net4 _281_/a_543_47# 0.00339f
C11800 _173_/a_27_413# _088_ 0
C11801 _270_/a_27_47# _270_/a_193_47# -0.32207f
C11802 net3 genblk1\[7\].fa_inst.a 0
C11803 VPWR net61 2.67998f
C11804 _303_/a_1462_47# net23 0
C11805 a[13] _278_/a_193_47# 0
C11806 net27 _279_/a_1108_47# 0.00523f
C11807 _280_/a_193_47# _040_ 0
C11808 _280_/a_761_289# net30 0
C11809 _025_ _295_/a_193_47# 0
C11810 _085_ _087_ 0.10746f
C11811 _301_/a_1283_21# _031_ 0.00207f
C11812 _301_/a_193_47# genblk1\[14\].fa_inst.a 0
C11813 _046_ _286_/a_1283_21# 0.00125f
C11814 net21 _286_/a_1108_47# 0
C11815 net24 net17 0.0235f
C11816 VPWR _298_/a_1270_413# 0
C11817 _278_/a_27_47# _278_/a_543_47# -0.00482f
C11818 clk _263_/a_1270_413# 0
C11819 clkbuf_2_0__f_clk_regs/a_110_47# genblk1\[5\].fa_inst.s 0.00274f
C11820 clkload0/a_27_47# _260_/a_761_289# 0.00319f
C11821 clkload0/a_361_47# _260_/a_193_47# 0
C11822 _204_/a_33_297# _203_/a_109_297# 0
C11823 _288_/a_27_47# net17 0.03565f
C11824 net46 pmu_inst/dc_inst.x6.x15/a_27_47# 0
C11825 clknet_2_1__leaf_clk_regs _262_/a_1462_47# 0
C11826 _300_/a_1283_21# _299_/a_27_47# 0
C11827 _286_/a_1217_47# clknet_2_2__leaf_clk_regs 0
C11828 net21 genblk1\[14\].fa_inst.b 0
C11829 s[7] VGND 0.82402f
C11830 output52/a_27_47# VGND 0.3175f
C11831 s[11] VGND 0.79582f
C11832 output41/a_27_47# VGND 0.33671f
C11833 pmu_inst_69/HI VGND 0.3713f
C11834 _055_ VGND 1.6069f
C11835 _132_/a_113_47# VGND 0
C11836 _201_/a_637_47# VGND -0.00212f
C11837 _201_/a_479_47# VGND -0
C11838 _201_/a_217_297# VGND 0.02009f
C11839 _201_/a_61_47# VGND 0.25053f
C11840 genblk1\[6\].fa_inst.a VGND 0.7812f
C11841 _278_/a_1462_47# VGND -0
C11842 _278_/a_1217_47# VGND -0
C11843 _278_/a_805_47# VGND -0
C11844 _278_/a_639_47# VGND -0.00169f
C11845 _278_/a_651_413# VGND 0.00609f
C11846 _278_/a_448_47# VGND 0.00776f
C11847 _278_/a_1108_47# VGND 0.13301f
C11848 _278_/a_1283_21# VGND 0.27929f
C11849 _278_/a_543_47# VGND 0.15397f
C11850 _278_/a_761_289# VGND 0.12031f
C11851 _278_/a_193_47# VGND 0.27406f
C11852 _278_/a_27_47# VGND 0.38572f
C11853 _040_ VGND 0.48499f
C11854 net30 VGND 1.20388f
C11855 _295_/a_651_413# VGND 0.00562f
C11856 _295_/a_448_47# VGND 0.01468f
C11857 _295_/a_1108_47# VGND 0.14247f
C11858 _295_/a_1283_21# VGND 0.33251f
C11859 _295_/a_543_47# VGND 0.16212f
C11860 _295_/a_761_289# VGND 0.1223f
C11861 _295_/a_193_47# VGND 0.27829f
C11862 _295_/a_27_47# VGND 0.56064f
C11863 s[6] VGND 0.79366f
C11864 output51/a_27_47# VGND 0.33671f
C11865 s[10] VGND 0.79582f
C11866 output40/a_27_47# VGND 0.33671f
C11867 pmu_inst_68/HI VGND 0.37123f
C11868 _133_/a_113_47# VGND 0
C11869 _202_/a_109_297# VGND -0
C11870 genblk1\[7\].fa_inst.a VGND 2.21179f
C11871 _024_ VGND 0.37988f
C11872 _279_/a_651_413# VGND 0.00609f
C11873 _279_/a_448_47# VGND 0.0139f
C11874 _279_/a_1108_47# VGND 0.14622f
C11875 _279_/a_1283_21# VGND 0.31543f
C11876 _279_/a_543_47# VGND 0.16167f
C11877 _279_/a_761_289# VGND 0.12627f
C11878 _279_/a_193_47# VGND 0.28258f
C11879 _279_/a_27_47# VGND 0.48137f
C11880 _069_ VGND 0.52105f
C11881 genblk1\[5\].fa_inst.b VGND 0.75937f
C11882 _150_/a_150_297# VGND -0
C11883 _150_/a_68_297# VGND 0.15766f
C11884 _041_ VGND 0.48411f
C11885 net31 VGND 2.10824f
C11886 _296_/a_651_413# VGND 0.00562f
C11887 _296_/a_448_47# VGND 0.01151f
C11888 _296_/a_1108_47# VGND 0.14085f
C11889 _296_/a_1283_21# VGND 0.33193f
C11890 _296_/a_543_47# VGND 0.16184f
C11891 _296_/a_761_289# VGND 0.12266f
C11892 _296_/a_193_47# VGND 0.27837f
C11893 _296_/a_27_47# VGND 0.50517f
C11894 s[5] VGND 0.93596f
C11895 output50/a_27_47# VGND 0.31071f
C11896 pmu_inst_67/HI VGND 0.37128f
C11897 genblk1\[1\].fa_inst.s VGND 1.83732f
C11898 _053_ VGND 0.45398f
C11899 _056_ VGND 0.29184f
C11900 _134_/a_285_47# VGND 0.0188f
C11901 _134_/a_129_47# VGND 0
C11902 _134_/a_377_297# VGND -0
C11903 _134_/a_47_47# VGND 0.2028f
C11904 _109_ VGND 0.99435f
C11905 _203_/a_109_297# VGND -0.00128f
C11906 _151_/a_113_47# VGND 0
C11907 _042_ VGND 0.04858f
C11908 net32 VGND 1.81778f
C11909 _297_/a_1462_47# VGND -0
C11910 _297_/a_1217_47# VGND -0
C11911 _297_/a_805_47# VGND -0
C11912 _297_/a_639_47# VGND -0.00169f
C11913 _297_/a_651_413# VGND 0.00562f
C11914 _297_/a_448_47# VGND 0.00854f
C11915 _297_/a_1108_47# VGND 0.13082f
C11916 _297_/a_1283_21# VGND 0.29649f
C11917 _297_/a_543_47# VGND 0.15501f
C11918 _297_/a_761_289# VGND 0.11662f
C11919 _297_/a_193_47# VGND 0.26935f
C11920 _297_/a_27_47# VGND 0.41162f
C11921 pmu_inst_66/HI VGND 0.37648f
C11922 _057_ VGND 0.95256f
C11923 _135_/a_382_47# VGND 0
C11924 _135_/a_298_297# VGND 0.00519f
C11925 _135_/a_215_297# VGND 0.15134f
C11926 _135_/a_27_413# VGND 0.17957f
C11927 _111_ VGND 1.78261f
C11928 _204_/a_225_47# VGND 0.06219f
C11929 _204_/a_561_297# VGND -0.00739f
C11930 _204_/a_33_297# VGND 0.46177f
C11931 _070_ VGND 0.85601f
C11932 _152_/a_113_47# VGND 0
C11933 _043_ VGND 0.42817f
C11934 net18 VGND 1.96518f
C11935 _298_/a_651_413# VGND 0.00469f
C11936 _298_/a_448_47# VGND 0.0139f
C11937 _298_/a_1108_47# VGND 0.1456f
C11938 _298_/a_1283_21# VGND 0.30835f
C11939 _298_/a_543_47# VGND 0.17913f
C11940 _298_/a_761_289# VGND 0.12233f
C11941 _298_/a_193_47# VGND 0.28844f
C11942 _298_/a_27_47# VGND 0.52202f
C11943 pmu_inst_65/HI VGND 0.37123f
C11944 _058_ VGND 1.3093f
C11945 _136_/a_150_297# VGND -0
C11946 _136_/a_68_297# VGND 0.16059f
C11947 genblk1\[15\].fa_inst.s VGND 0.78411f
C11948 _110_ VGND 1.47576f
C11949 _112_ VGND 0.38945f
C11950 _205_/a_285_47# VGND 0.01891f
C11951 _205_/a_129_47# VGND 0
C11952 _205_/a_377_297# VGND -0.00125f
C11953 _205_/a_47_47# VGND 0.22147f
C11954 _072_ VGND 0.94587f
C11955 _153_/a_382_47# VGND -0
C11956 _153_/a_298_297# VGND 0.00103f
C11957 _153_/a_215_297# VGND 0.17522f
C11958 _153_/a_27_413# VGND 0.17024f
C11959 net19 VGND 1.53779f
C11960 _299_/a_1462_47# VGND 0
C11961 _299_/a_1217_47# VGND 0.00108f
C11962 _299_/a_805_47# VGND 0
C11963 _299_/a_639_47# VGND 0
C11964 _299_/a_1270_413# VGND 0
C11965 _299_/a_651_413# VGND 0.00659f
C11966 _299_/a_448_47# VGND 0.0139f
C11967 _299_/a_1108_47# VGND 0.20426f
C11968 _299_/a_1283_21# VGND 0.34388f
C11969 _299_/a_543_47# VGND 0.16901f
C11970 _299_/a_761_289# VGND 0.13061f
C11971 _299_/a_193_47# VGND 0.31758f
C11972 _299_/a_27_47# VGND 0.56771f
C11973 _170_/a_150_297# VGND -0
C11974 _170_/a_68_297# VGND 0.15591f
C11975 pmu_inst_64/HI VGND 0.37123f
C11976 _059_ VGND 0.54595f
C11977 genblk1\[2\].fa_inst.b VGND 2.05959f
C11978 _137_/a_113_47# VGND -0
C11979 genblk1\[5\].fa_inst.s VGND 0.58175f
C11980 _071_ VGND 0.40522f
C11981 _154_/a_285_47# VGND 0.0207f
C11982 _154_/a_129_47# VGND 0
C11983 _154_/a_47_47# VGND 0.24181f
C11984 net56 VGND 6.51618f
C11985 genblk1\[9\].fa_inst.b VGND 0.78995f
C11986 _171_/a_113_47# VGND 0
C11987 pmu_inst_74/HI VGND 0.37108f
C11988 pmu_inst_63/HI VGND 0.36849f
C11989 _060_ VGND 0.35838f
C11990 _138_/a_113_47# VGND -0
C11991 _073_ VGND 0.49041f
C11992 _155_/a_150_297# VGND -0
C11993 _155_/a_68_297# VGND 0.16005f
C11994 _086_ VGND 1.07846f
C11995 _172_/a_113_47# VGND -0
C11996 pmu_inst_73/HI VGND 0.37063f
C11997 _139_/a_285_47# VGND 0.0217f
C11998 _139_/a_129_47# VGND 0
C11999 _139_/a_377_297# VGND 0
C12000 _139_/a_47_47# VGND 0.27924f
C12001 _156_/a_113_47# VGND 0
C12002 b[11] VGND 0.80726f
C12003 input19/a_75_212# VGND 0.25593f
C12004 _088_ VGND 0.83198f
C12005 _081_ VGND 0.27677f
C12006 _082_ VGND 1.05407f
C12007 _173_/a_382_47# VGND -0
C12008 _173_/a_298_297# VGND 0.00149f
C12009 _173_/a_215_297# VGND 0.13766f
C12010 _173_/a_27_413# VGND 0.18313f
C12011 _101_ VGND 0.64943f
C12012 genblk1\[13\].fa_inst.b VGND 0.69629f
C12013 _190_/a_150_297# VGND -0
C12014 _190_/a_68_297# VGND 0.15702f
C12015 pmu_inst_72/HI VGND 0.27849f
C12016 _075_ VGND 0.41484f
C12017 _074_ VGND 0.96957f
C12018 _157_/a_113_47# VGND -0
C12019 b[6] VGND 0.80478f
C12020 input29/a_75_212# VGND 0.27939f
C12021 genblk1\[9\].fa_inst.s VGND 0.28597f
C12022 _087_ VGND 0.22797f
C12023 _174_/a_285_47# VGND 0.02051f
C12024 _174_/a_129_47# VGND 0
C12025 _174_/a_377_297# VGND -0.00125f
C12026 _174_/a_47_47# VGND 0.22101f
C12027 b[10] VGND 0.8485f
C12028 input18/a_75_212# VGND 0.27949f
C12029 _038_ VGND 1.65422f
C12030 _102_ VGND 0.96527f
C12031 _191_/a_113_47# VGND 0
C12032 net50 VGND 9.55912f
C12033 _005_ VGND 0.47576f
C12034 _260_/a_651_413# VGND 0.00472f
C12035 _260_/a_448_47# VGND 0.0139f
C12036 _260_/a_1108_47# VGND 0.13971f
C12037 _260_/a_1283_21# VGND 0.30962f
C12038 _260_/a_543_47# VGND 0.15824f
C12039 _260_/a_761_289# VGND 0.12317f
C12040 _260_/a_193_47# VGND 0.28007f
C12041 _260_/a_27_47# VGND 0.55498f
C12042 pmu_inst_71/HI VGND 0.32359f
C12043 _076_ VGND 0.94648f
C12044 _158_/a_298_297# VGND 0.00188f
C12045 _158_/a_215_297# VGND 0.18243f
C12046 _158_/a_27_413# VGND 0.18804f
C12047 _089_ VGND 0.4986f
C12048 _175_/a_150_297# VGND -0
C12049 _175_/a_68_297# VGND 0.16914f
C12050 b[5] VGND 0.84836f
C12051 input28/a_75_212# VGND 0.27949f
C12052 b[0] VGND 0.83029f
C12053 input17/a_27_47# VGND 0.27697f
C12054 _192_/a_113_47# VGND 0
C12055 net51 VGND 20.21404f
C12056 _006_ VGND 0.29707f
C12057 genblk1\[6\].fa_inst.s VGND 0.59545f
C12058 _261_/a_651_413# VGND 0.00646f
C12059 _261_/a_448_47# VGND 0.01468f
C12060 _261_/a_1108_47# VGND 0.15675f
C12061 _261_/a_1283_21# VGND 0.31177f
C12062 _261_/a_543_47# VGND 0.16957f
C12063 _261_/a_761_289# VGND 0.12555f
C12064 _261_/a_193_47# VGND 0.29316f
C12065 _261_/a_27_47# VGND 0.56514f
C12066 pmu_inst_70/HI VGND 0.28423f
C12067 _159_/a_285_47# VGND 0.02058f
C12068 _159_/a_129_47# VGND -0
C12069 _159_/a_47_47# VGND 0.21565f
C12070 _023_ VGND 0.05106f
C12071 _090_ VGND 0.47423f
C12072 genblk1\[10\].fa_inst.b VGND 1.01293f
C12073 _176_/a_113_47# VGND 0
C12074 b[4] VGND 0.83215f
C12075 input27/a_75_212# VGND 0.27949f
C12076 net16 VGND 1.25865f
C12077 a[9] VGND 0.82914f
C12078 input16/a_75_212# VGND 0.27939f
C12079 net59 VGND 7.27323f
C12080 _104_ VGND 0.86147f
C12081 _193_/a_298_297# VGND 0
C12082 _193_/a_215_297# VGND 0.16092f
C12083 _193_/a_27_413# VGND 0.17249f
C12084 net52 VGND 3.98243f
C12085 _007_ VGND 0.41844f
C12086 _262_/a_651_413# VGND 0.00611f
C12087 _262_/a_448_47# VGND 0.01396f
C12088 _262_/a_1108_47# VGND 0.13998f
C12089 _262_/a_1283_21# VGND 0.30397f
C12090 _262_/a_543_47# VGND 0.16457f
C12091 _262_/a_761_289# VGND 0.12645f
C12092 _262_/a_193_47# VGND 0.28099f
C12093 _262_/a_27_47# VGND 0.49672f
C12094 pmu_inst/dc_inst.x3.x8/a_27_47# VGND 0.20778f
C12095 pmu_inst/dc_inst.x6.net8 VGND 0.17842f
C12096 pmu_inst/dc_inst.x6.x7/a_27_47# VGND 0.20778f
C12097 pmu_inst/dc_inst.x1.net12 VGND 0.1529f
C12098 pmu_inst/dc_inst.x1.x12/a_27_47# VGND 0.20781f
C12099 pmu_inst/dc_inst.x4.x20/a_27_47# VGND 0.28447f
C12100 pmu_inst/dc_inst.x3.net8 VGND 0.16862f
C12101 pmu_inst/dc_inst.x3.x7/a_27_47# VGND 0.2086f
C12102 pmu_inst/dc_inst.x6.net7 VGND 0.21573f
C12103 pmu_inst/dc_inst.x6.net6 VGND 0.17683f
C12104 pmu_inst/dc_inst.x6.x6/a_27_47# VGND 0.20778f
C12105 pmu_inst/dc_inst.x5.net19 VGND 0.29596f
C12106 pmu_inst/dc_inst.x5.x19/a_27_47# VGND 0.20778f
C12107 pmu_inst/dc_inst.x1.net11 VGND 0.16457f
C12108 pmu_inst/dc_inst.x1.x11/a_27_47# VGND 0.20778f
C12109 pmu_inst/dc_inst.x3.net7 VGND 0.15223f
C12110 pmu_inst/dc_inst.x3.net6 VGND 0.14232f
C12111 pmu_inst/dc_inst.x3.x6/a_27_47# VGND 0.21027f
C12112 pmu_inst/dc_inst.x6.x5/a_27_47# VGND 0.20779f
C12113 pmu_inst/dc_inst.x1.net1 VGND 0.14564f
C12114 pmu_inst/dc_inst.x1.net10 VGND 0.17391f
C12115 pmu_inst/dc_inst.x1.x10/a_27_47# VGND 0.20778f
C12116 pmu_inst/dc_inst.x5.net18 VGND 0.14253f
C12117 pmu_inst/dc_inst.x5.x18/a_27_47# VGND 0.20778f
C12118 pmu_inst/dc_inst.x3.x5/a_27_47# VGND 0.2089f
C12119 pmu_inst/dc_inst.x6.net5 VGND 0.14278f
C12120 pmu_inst/dc_inst.x6.x4/a_27_47# VGND 0.20783f
C12121 pmu_inst/dc_inst.x1.x20/a_27_47# VGND 0.28447f
C12122 pmu_inst/dc_inst.x5.net17 VGND 0.25705f
C12123 pmu_inst/dc_inst.x5.x17/a_27_47# VGND 0.20778f
C12124 pmu_inst/dc_inst.x3.net5 VGND 0.15546f
C12125 pmu_inst/dc_inst.x3.x4/a_27_47# VGND 0.21015f
C12126 pmu_inst/dc_inst.x6.net4 VGND 0.15048f
C12127 pmu_inst/dc_inst.x6.x3/a_27_47# VGND 0.20782f
C12128 pmu_inst/dc_inst.x2.net19 VGND 0.16789f
C12129 pmu_inst/dc_inst.x2.x19/a_27_47# VGND 0.20783f
C12130 pmu_inst/_04_ VGND 0.13968f
C12131 pmu_inst/dc_inst.x5.net16 VGND 0.23924f
C12132 pmu_inst/dc_inst.x5.net15 VGND 0.17024f
C12133 pmu_inst/dc_inst.x5.x16/a_27_47# VGND 0.20778f
C12134 pmu_inst/dc_inst.x3.net4 VGND 0.14699f
C12135 pmu_inst/dc_inst.x3.x3/a_27_47# VGND 0.21033f
C12136 pmu_inst/dc_inst.x6.net3 VGND 0.18329f
C12137 pmu_inst/dc_inst.x6.net2 VGND 0.24542f
C12138 pmu_inst/dc_inst.x6.x2/a_27_47# VGND 0.20778f
C12139 pmu_inst/_01_ VGND 0.27778f
C12140 net62 VGND 15.56298f
C12141 pmu_inst/dc_inst.x2.net18 VGND 0.18688f
C12142 pmu_inst/dc_inst.x2.x18/a_27_47# VGND 0.20778f
C12143 pmu_inst/dc_inst.x5.x15/a_27_47# VGND 0.20778f
C12144 pmu_inst/dc_inst.x3.net3 VGND 0.17513f
C12145 pmu_inst/dc_inst.x3.net2 VGND 0.19579f
C12146 pmu_inst/dc_inst.x3.x2/a_27_47# VGND 0.21115f
C12147 pmu_inst/_05_ VGND 0.19615f
C12148 pmu_inst/_13_/a_470_47# VGND 0.01853f
C12149 pmu_inst/_13_/a_470_297# VGND 0.02289f
C12150 pmu_inst/_13_/a_27_297# VGND 0.02117f
C12151 pmu_inst/_13_/a_112_47# VGND 0.28506f
C12152 pmu_inst/dc_inst.net5 VGND 0.37349f
C12153 pmu_inst/dc_inst.x6.x1/a_27_47# VGND 0.20783f
C12154 pmu_inst/dc_inst.x2.net17 VGND 0.17258f
C12155 pmu_inst/dc_inst.x2.x17/a_27_47# VGND 0.20778f
C12156 pmu_inst/dc_inst.x5.net14 VGND 0.19133f
C12157 pmu_inst/dc_inst.x5.net13 VGND 0.15495f
C12158 pmu_inst/dc_inst.x5.x14/a_27_47# VGND 0.20778f
C12159 pmu_inst/dc_inst.net8 VGND 0.18224f
C12160 net36 VGND 8.85832f
C12161 pmu_inst/capture_d VGND 0.19304f
C12162 pmu_inst/dc_inst.x10/a_218_47# VGND 0
C12163 pmu_inst/dc_inst.x10/a_535_374# VGND 0
C12164 pmu_inst/dc_inst.x10/a_218_374# VGND 0
C12165 pmu_inst/dc_inst.x10/a_505_21# VGND 0.2477f
C12166 pmu_inst/dc_inst.x10/a_76_199# VGND 0.14289f
C12167 pmu_inst/dc_inst.x3.x1/a_27_47# VGND 0.21051f
C12168 net74 VGND 1.66476f
C12169 net73 VGND 2.14951f
C12170 pmu_inst/_14_/a_505_21# VGND 0.24676f
C12171 pmu_inst/_14_/a_76_199# VGND 0.13947f
C12172 pmu_inst/dc_inst.x2.net16 VGND 0.14287f
C12173 pmu_inst/dc_inst.x2.x16/a_27_47# VGND 0.20778f
C12174 pmu_inst/dc_inst.x5.net12 VGND 1.1906f
C12175 pmu_inst/dc_inst.x5.x13/a_27_47# VGND 0.20778f
C12176 net66 VGND 1.84089f
C12177 net67 VGND 1.69729f
C12178 net69 VGND 1.8365f
C12179 net68 VGND 1.16356f
C12180 pmu_inst/_15_/a_1281_47# VGND 0
C12181 pmu_inst/_15_/a_1064_47# VGND 0
C12182 pmu_inst/_15_/a_397_47# VGND 0
C12183 pmu_inst/_15_/a_1279_413# VGND 0
C12184 pmu_inst/_15_/a_1060_369# VGND 0
C12185 pmu_inst/_15_/a_872_316# VGND 0.03692f
C12186 pmu_inst/_15_/a_193_47# VGND 0
C12187 pmu_inst/_15_/a_600_345# VGND 0.17f
C12188 pmu_inst/_15_/a_788_316# VGND 0.23107f
C12189 pmu_inst/_15_/a_372_413# VGND 0
C12190 pmu_inst/_15_/a_288_47# VGND 0.03863f
C12191 pmu_inst/_15_/a_193_369# VGND 0.00112f
C12192 pmu_inst/_15_/a_27_47# VGND 0.32096f
C12193 pmu_inst/dc_inst.x2.net15 VGND 0.20568f
C12194 pmu_inst/dc_inst.x2.x15/a_27_47# VGND 0.20778f
C12195 pmu_inst/dc_inst.x5.x12/a_27_47# VGND 0.20778f
C12196 pmu_inst/clkbuf_1_1__f_clk/a_110_47# VGND 1.73295f
C12197 pmu_inst/dc_inst.x2.net14 VGND 0.16699f
C12198 pmu_inst/dc_inst.x2.x14/a_27_47# VGND 0.20778f
C12199 pmu_inst/_07_ VGND 0.13824f
C12200 net63 VGND 1.9247f
C12201 net70 VGND 4.14312f
C12202 pmu_inst/_16_/a_229_47# VGND 0.0409f
C12203 pmu_inst/_16_/a_27_93# VGND 0.28968f
C12204 pmu_inst/dc_inst.x5.net11 VGND 0.17669f
C12205 pmu_inst/dc_inst.x5.x11/a_27_47# VGND 0.20778f
C12206 pmu_inst/dc_inst.x2.net13 VGND 0.14855f
C12207 pmu_inst/dc_inst.x2.x13/a_27_47# VGND 0.20778f
C12208 pmu_inst/_08_ VGND 0.11432f
C12209 net71 VGND 1.71814f
C12210 cout_next VGND 16.31355f
C12211 pmu_inst/_17_/a_478_47# VGND 0.0324f
C12212 pmu_inst/_17_/a_27_93# VGND 0.20594f
C12213 pmu_inst/_17_/a_174_21# VGND 0.21227f
C12214 pmu_inst/dc_inst.x5.net1 VGND 0.16899f
C12215 pmu_inst/dc_inst.x5.net10 VGND 0.14851f
C12216 pmu_inst/dc_inst.x5.x10/a_27_47# VGND 0.20778f
C12217 pmu_inst/dc_inst.x5.x9/a_27_47# VGND 0.20778f
C12218 pmu_inst/dc_inst.x2.net10 VGND 0.13089f
C12219 pmu_inst/dc_inst.x2.x9/a_27_47# VGND 0.20778f
C12220 net65 VGND 1.49987f
C12221 net64 VGND 1.61017f
C12222 pmu_inst/_09_ VGND 0.12632f
C12223 pmu_inst/_18_/a_505_21# VGND 0.24676f
C12224 pmu_inst/_18_/a_76_199# VGND 0.13947f
C12225 pmu_inst/dc_inst.x2.net12 VGND 0.17632f
C12226 pmu_inst/dc_inst.x2.x12/a_27_47# VGND 0.20778f
C12227 pmu_inst/dc_inst.x5.net9 VGND 0.14112f
C12228 pmu_inst/dc_inst.x5.net8 VGND 0.15291f
C12229 pmu_inst/dc_inst.x5.x8/a_27_47# VGND 0.20778f
C12230 pmu_inst/dc_inst.x5.x20/a_27_47# VGND 0.29014f
C12231 pmu_inst/dc_inst.x2.net9 VGND 0.13438f
C12232 pmu_inst/dc_inst.x2.x8/a_27_47# VGND 0.20778f
C12233 pmu_inst/_10_ VGND 0.13283f
C12234 net72 VGND 1.64091f
C12235 pmu_inst/_19_/a_193_297# VGND 0.0011f
C12236 pmu_inst/_19_/a_109_297# VGND 0
C12237 pmu_inst/_19_/a_27_47# VGND 0.30506f
C12238 pmu_inst/dc_inst.x2.net11 VGND 0.14232f
C12239 pmu_inst/dc_inst.x2.x11/a_27_47# VGND 0.20778f
C12240 pmu_inst/dc_inst.x5.net7 VGND 0.28364f
C12241 pmu_inst/dc_inst.x5.x7/a_27_47# VGND 0.20778f
C12242 pmu_inst/dc_inst.x6.x19/a_27_47# VGND 0.21259f
C12243 pmu_inst/dc_inst.x2.net8 VGND 0.13799f
C12244 pmu_inst/dc_inst.x2.x7/a_27_47# VGND 0.20778f
C12245 pmu_inst/dc_inst.x5.x6/a_27_47# VGND 0.20778f
C12246 pmu_inst/dc_inst.x2.net1 VGND 0.14079f
C12247 pmu_inst/dc_inst.x2.x10/a_27_47# VGND 0.20778f
C12248 pmu_inst/dc_inst.x6.net18 VGND 0.16435f
C12249 pmu_inst/dc_inst.x6.x18/a_27_47# VGND 0.21125f
C12250 pmu_inst/dc_inst.x2.net7 VGND 0.15318f
C12251 pmu_inst/dc_inst.x2.net6 VGND 0.16499f
C12252 pmu_inst/dc_inst.x2.x6/a_27_47# VGND 0.20778f
C12253 pmu_inst/dc_inst.x2.x20/a_27_47# VGND 0.28943f
C12254 pmu_inst/dc_inst.x5.net6 VGND 0.22006f
C12255 pmu_inst/dc_inst.x5.net5 VGND 0.13486f
C12256 pmu_inst/dc_inst.x5.x5/a_27_47# VGND 0.20778f
C12257 pmu_inst/dc_inst.x6.net17 VGND 0.15464f
C12258 pmu_inst/dc_inst.x6.x17/a_27_47# VGND 0.20787f
C12259 pmu_inst/dc_inst.x2.x5/a_27_47# VGND 0.20778f
C12260 pmu_inst/dc_inst.x5.x4/a_27_47# VGND 0.20778f
C12261 pmu_inst/dc_inst.x3.x19/a_27_47# VGND 0.21042f
C12262 pmu_inst/clknet_1_0__leaf_clk VGND 0.36404f
C12263 pmu_inst/clknet_0_clk VGND 0.95503f
C12264 pmu_inst/clkbuf_1_0__f_clk/a_110_47# VGND 1.74447f
C12265 pmu_inst/dc_inst.x6.net16 VGND 0.13478f
C12266 pmu_inst/dc_inst.x6.x16/a_27_47# VGND 0.20778f
C12267 pmu_inst/dc_inst.x2.net5 VGND 0.14408f
C12268 pmu_inst/dc_inst.x2.x4/a_27_47# VGND 0.20778f
C12269 pmu_inst/dc_inst.x3.net18 VGND 0.14776f
C12270 pmu_inst/dc_inst.x3.x18/a_27_47# VGND 0.20993f
C12271 pmu_inst/dc_inst.x5.net4 VGND 0.13995f
C12272 pmu_inst/dc_inst.x5.x3/a_27_47# VGND 0.20778f
C12273 pmu_inst/dc_inst.x6.net15 VGND 0.13899f
C12274 pmu_inst/dc_inst.x6.x15/a_27_47# VGND 0.20783f
C12275 pmu_inst/dc_inst.x2.net4 VGND 0.13216f
C12276 pmu_inst/dc_inst.x2.x3/a_27_47# VGND 0.20778f
C12277 pmu_inst/dc_inst.x5.net3 VGND 0.17699f
C12278 pmu_inst/dc_inst.x5.net2 VGND 0.26989f
C12279 pmu_inst/dc_inst.x5.x2/a_27_47# VGND 0.20778f
C12280 pmu_inst/dc_inst.x3.net17 VGND 0.14811f
C12281 pmu_inst/dc_inst.x3.net16 VGND 0.18386f
C12282 pmu_inst/dc_inst.x3.x17/a_27_47# VGND 0.21029f
C12283 pmu_inst/dc_inst.x6.net14 VGND 0.14858f
C12284 pmu_inst/dc_inst.x6.x14/a_27_47# VGND 0.20778f
C12285 pmu_inst/dc_inst.x2.net3 VGND 0.1338f
C12286 pmu_inst/dc_inst.x2.net2 VGND 0.14756f
C12287 pmu_inst/dc_inst.x2.x2/a_27_47# VGND 0.20778f
C12288 pmu_inst/dc_inst.x3.x16/a_27_47# VGND 0.20936f
C12289 pmu_inst/dc_inst.net4 VGND 0.31545f
C12290 pmu_inst/dc_inst.x5.x1/a_27_47# VGND 0.20778f
C12291 pmu_inst/dc_inst.x6.net13 VGND 0.14592f
C12292 pmu_inst/dc_inst.x6.x13/a_27_47# VGND 0.20778f
C12293 pmu_inst/dc_inst.net1 VGND 0.27529f
C12294 pmu_inst/dc_inst.x2.x1/a_27_47# VGND 0.20778f
C12295 pmu_inst/dc_inst.x3.net15 VGND 0.14136f
C12296 pmu_inst/dc_inst.x3.x15/a_27_47# VGND 0.20901f
C12297 pmu_inst/dc_inst.x6.net12 VGND 0.14307f
C12298 pmu_inst/dc_inst.x6.x12/a_27_47# VGND 0.20779f
C12299 pmu_inst/dc_inst.x3.net14 VGND 0.21357f
C12300 pmu_inst/dc_inst.x3.net13 VGND 0.15231f
C12301 pmu_inst/dc_inst.x3.x14/a_27_47# VGND 0.21253f
C12302 pmu_inst/dc_inst.x6.net11 VGND 0.18014f
C12303 pmu_inst/dc_inst.x6.x11/a_27_47# VGND 0.20778f
C12304 pmu_inst/dc_inst.x3.x13/a_27_47# VGND 0.20859f
C12305 pmu_inst/dc_inst.x6.net1 VGND 0.12726f
C12306 pmu_inst/dc_inst.x6.net10 VGND 0.12401f
C12307 pmu_inst/dc_inst.x6.x10/a_27_47# VGND 0.20778f
C12308 pmu_inst/dc_inst.x7.net10 VGND 0.14487f
C12309 pmu_inst/dc_inst.x7.x9/a_27_47# VGND 0.2128f
C12310 pmu_inst/dc_inst.x6.net19 VGND 0.16361f
C12311 pmu_inst/dc_inst.x6.x20/a_27_47# VGND 0.28904f
C12312 pmu_inst/dc_inst.x3.net12 VGND 0.24642f
C12313 pmu_inst/dc_inst.x3.net11 VGND 0.21647f
C12314 pmu_inst/dc_inst.x3.x12/a_27_47# VGND 0.21114f
C12315 pmu_inst/dc_inst.x4.net10 VGND 0.14842f
C12316 pmu_inst/dc_inst.x4.net9 VGND 0.16452f
C12317 pmu_inst/dc_inst.x4.x9/a_27_47# VGND 0.20778f
C12318 pmu_inst/dc_inst.in VGND 0.53656f
C12319 pmu_inst/_06_ VGND 0.20276f
C12320 pmu_inst/_20_/a_384_47# VGND 0.01898f
C12321 pmu_inst/_20_/a_79_21# VGND 0.24782f
C12322 pmu_inst/dc_inst.x7.net9 VGND 0.25955f
C12323 pmu_inst/dc_inst.x7.x8/a_27_47# VGND 0.2078f
C12324 pmu_inst/dc_inst.net9 VGND 0.16638f
C12325 net35 VGND 8.97045f
C12326 pmu_inst/dc_inst.net7 VGND 0.17615f
C12327 net34 VGND 7.94863f
C12328 pmu_inst/dc_inst.x9/a_834_97# VGND 0.02587f
C12329 pmu_inst/dc_inst.x9/a_668_97# VGND 0.0218f
C12330 pmu_inst/dc_inst.x9/a_193_47# VGND 0
C12331 pmu_inst/dc_inst.x9/a_27_47# VGND 0.04387f
C12332 pmu_inst/dc_inst.x9/a_1478_413# VGND 0.17048f
C12333 pmu_inst/dc_inst.x9/a_1290_413# VGND 0.22395f
C12334 pmu_inst/dc_inst.x9/a_750_97# VGND 0.04903f
C12335 pmu_inst/dc_inst.x9/a_757_363# VGND 0.00999f
C12336 pmu_inst/dc_inst.x9/a_923_363# VGND 0
C12337 pmu_inst/dc_inst.x9/a_277_47# VGND 0.08781f
C12338 pmu_inst/dc_inst.x9/a_247_21# VGND 0.35138f
C12339 pmu_inst/dc_inst.x9/a_193_413# VGND 0.00708f
C12340 pmu_inst/dc_inst.x9/a_27_413# VGND 0.03047f
C12341 pmu_inst/dc_inst.x1.net9 VGND 0.20424f
C12342 pmu_inst/dc_inst.x1.x9/a_27_47# VGND 0.20778f
C12343 pmu_inst/dc_inst.x3.x11/a_27_47# VGND 0.20778f
C12344 pmu_inst/dc_inst.x7.net19 VGND 0.163f
C12345 pmu_inst/dc_inst.x7.x19/a_27_47# VGND 0.21033f
C12346 pmu_inst/dc_inst.x4.x8/a_27_47# VGND 0.20778f
C12347 pmu_inst/dc_inst.x7.net8 VGND 0.14595f
C12348 pmu_inst/dc_inst.x7.x7/a_27_47# VGND 0.20778f
C12349 pmu_inst/dc_inst.net2 VGND 0.32144f
C12350 pmu_inst/dc_inst.x8/a_834_97# VGND 0.02528f
C12351 pmu_inst/dc_inst.x8/a_668_97# VGND 0.02172f
C12352 pmu_inst/dc_inst.x8/a_193_47# VGND 0
C12353 pmu_inst/dc_inst.x8/a_27_47# VGND 0.04343f
C12354 pmu_inst/dc_inst.x8/a_1478_413# VGND 0.16992f
C12355 pmu_inst/dc_inst.x8/a_1290_413# VGND 0.22299f
C12356 pmu_inst/dc_inst.x8/a_750_97# VGND 0.04694f
C12357 pmu_inst/dc_inst.x8/a_757_363# VGND 0.00901f
C12358 pmu_inst/dc_inst.x8/a_923_363# VGND 0
C12359 pmu_inst/dc_inst.x8/a_277_47# VGND 0.08473f
C12360 pmu_inst/dc_inst.x8/a_247_21# VGND 0.34576f
C12361 pmu_inst/dc_inst.x8/a_193_413# VGND 0.00505f
C12362 pmu_inst/dc_inst.x8/a_27_413# VGND 0.03049f
C12363 pmu_inst/dc_inst.x1.x8/a_27_47# VGND 0.20779f
C12364 pmu_inst/dc_inst.x7.net18 VGND 0.14412f
C12365 pmu_inst/dc_inst.x7.x18/a_27_47# VGND 0.21023f
C12366 pmu_inst/dc_inst.x3.net1 VGND 0.17464f
C12367 pmu_inst/dc_inst.x3.net10 VGND 0.16668f
C12368 pmu_inst/dc_inst.x3.x10/a_27_47# VGND 0.21008f
C12369 pmu_inst/dc_inst.x4.net8 VGND 0.1579f
C12370 pmu_inst/dc_inst.x4.net7 VGND 0.13762f
C12371 pmu_inst/dc_inst.x4.x7/a_27_47# VGND 0.20778f
C12372 pmu_inst/dc_inst.x7.net7 VGND 0.12936f
C12373 pmu_inst/dc_inst.x7.net6 VGND 0.1906f
C12374 pmu_inst/dc_inst.x7.x6/a_27_47# VGND 0.20778f
C12375 pmu_inst/_03_ VGND 0.27262f
C12376 pmu_inst/dc_inst.x3.net19 VGND 0.19478f
C12377 pmu_inst/dc_inst.x3.x20/a_27_47# VGND 0.28956f
C12378 pmu_inst/dc_inst.x1.net8 VGND 0.15844f
C12379 pmu_inst/dc_inst.x1.net7 VGND 0.23004f
C12380 pmu_inst/dc_inst.x1.x7/a_27_47# VGND 0.20778f
C12381 pmu_inst/dc_inst.x7.net17 VGND 0.16969f
C12382 pmu_inst/dc_inst.x7.x17/a_27_47# VGND 0.21035f
C12383 pmu_inst/dc_inst.x4.x6/a_27_47# VGND 0.20778f
C12384 pmu_inst/dc_inst.x7.x5/a_27_47# VGND 0.212f
C12385 pmu_inst/shadow_q VGND 0.41277f
C12386 pmu_inst/_23_/a_1270_413# VGND 0
C12387 pmu_inst/_23_/a_651_413# VGND 0.00469f
C12388 pmu_inst/_23_/a_448_47# VGND 0.01435f
C12389 pmu_inst/_23_/a_1108_47# VGND 0.13783f
C12390 pmu_inst/_23_/a_1283_21# VGND 0.39105f
C12391 pmu_inst/_23_/a_543_47# VGND 0.15873f
C12392 pmu_inst/_23_/a_761_289# VGND 0.12173f
C12393 pmu_inst/_23_/a_193_47# VGND 0.27602f
C12394 pmu_inst/_23_/a_27_47# VGND 0.4991f
C12395 pmu_inst/dc_inst.x1.x6/a_27_47# VGND 0.20778f
C12396 pmu_inst/dc_inst.x7.net16 VGND 0.13926f
C12397 pmu_inst/dc_inst.x7.x16/a_27_47# VGND 0.21035f
C12398 pmu_inst/dc_inst.x4.net6 VGND 0.12424f
C12399 pmu_inst/dc_inst.x4.net5 VGND 0.18663f
C12400 pmu_inst/dc_inst.x4.x5/a_27_47# VGND 0.20778f
C12401 pmu_inst/dc_inst.x4.net19 VGND 0.2078f
C12402 pmu_inst/dc_inst.x4.net18 VGND 0.1575f
C12403 pmu_inst/dc_inst.x4.x19/a_27_47# VGND 0.20778f
C12404 pmu_inst/dc_inst.x7.net5 VGND 0.14063f
C12405 pmu_inst/dc_inst.x7.net4 VGND 0.2316f
C12406 pmu_inst/dc_inst.x7.x4/a_27_47# VGND 0.2108f
C12407 pmu_inst/capture_q VGND 0.35048f
C12408 pmu_inst/_02_ VGND 0.3127f
C12409 pmu_inst/clknet_1_1__leaf_clk VGND 0.37246f
C12410 pmu_inst/_24_/a_651_413# VGND 0.00469f
C12411 pmu_inst/_24_/a_448_47# VGND 0.0139f
C12412 pmu_inst/_24_/a_1108_47# VGND 0.13732f
C12413 pmu_inst/_24_/a_1283_21# VGND 0.38926f
C12414 pmu_inst/_24_/a_543_47# VGND 0.15787f
C12415 pmu_inst/_24_/a_761_289# VGND 0.12085f
C12416 pmu_inst/_24_/a_193_47# VGND 0.27321f
C12417 pmu_inst/_24_/a_27_47# VGND 0.49575f
C12418 pmu_inst/dc_inst.x1.net6 VGND 0.15399f
C12419 pmu_inst/dc_inst.x1.net5 VGND 0.15324f
C12420 pmu_inst/dc_inst.x1.x5/a_27_47# VGND 0.20779f
C12421 pmu_inst/dc_inst.x4.net17 VGND 0.19754f
C12422 pmu_inst/dc_inst.x4.x18/a_27_47# VGND 0.20778f
C12423 pmu_inst/dc_inst.x7.net15 VGND 0.13397f
C12424 pmu_inst/dc_inst.x7.x15/a_27_47# VGND 0.20997f
C12425 clknet_1_0__leaf_clk VGND 2.48099f
C12426 pmu_inst/clkbuf_0_clk/a_110_47# VGND 1.73295f
C12427 pmu_inst/dc_inst.x4.x4/a_27_47# VGND 0.20778f
C12428 pmu_inst/dc_inst.x7.x3/a_27_47# VGND 0.20778f
C12429 net55 VGND 2.8019f
C12430 pmu_inst/_00_ VGND 0.20466f
C12431 pmu_inst/_25_/a_651_413# VGND 0.00469f
C12432 pmu_inst/_25_/a_448_47# VGND 0.0139f
C12433 pmu_inst/_25_/a_1108_47# VGND 0.13732f
C12434 pmu_inst/_25_/a_1283_21# VGND 0.38926f
C12435 pmu_inst/_25_/a_543_47# VGND 0.15787f
C12436 pmu_inst/_25_/a_761_289# VGND 0.12085f
C12437 pmu_inst/_25_/a_193_47# VGND 0.27321f
C12438 pmu_inst/_25_/a_27_47# VGND 0.49575f
C12439 pmu_inst/dc_inst.x1.net4 VGND 0.19192f
C12440 pmu_inst/dc_inst.x1.x4/a_27_47# VGND 0.20778f
C12441 pmu_inst/dc_inst.x4.net4 VGND 0.14466f
C12442 pmu_inst/dc_inst.x4.x3/a_27_47# VGND 0.20779f
C12443 pmu_inst/dc_inst.x4.x17/a_27_47# VGND 0.20778f
C12444 pmu_inst/dc_inst.x7.net14 VGND 0.15407f
C12445 pmu_inst/dc_inst.x7.x14/a_27_47# VGND 0.21057f
C12446 pmu_inst/dc_inst.x7.net3 VGND 0.18554f
C12447 pmu_inst/dc_inst.x7.x2/a_27_47# VGND 0.20988f
C12448 pmu_inst/dc_inst.x1.x3/a_27_47# VGND 0.21188f
C12449 pmu_inst/dc_inst.x1.net19 VGND 0.19659f
C12450 pmu_inst/dc_inst.x1.net18 VGND 0.18824f
C12451 pmu_inst/dc_inst.x1.x19/a_27_47# VGND 0.20778f
C12452 pmu_inst/dc_inst.x7.net13 VGND 0.18518f
C12453 pmu_inst/dc_inst.x7.net12 VGND 0.2035f
C12454 pmu_inst/dc_inst.x7.x13/a_27_47# VGND 0.21211f
C12455 pmu_inst/dc_inst.x4.net3 VGND 0.14764f
C12456 pmu_inst/dc_inst.x4.net2 VGND 0.17703f
C12457 pmu_inst/dc_inst.x4.x2/a_27_47# VGND 0.20779f
C12458 pmu_inst/dc_inst.x4.net16 VGND 0.18162f
C12459 pmu_inst/dc_inst.x4.x16/a_27_47# VGND 0.20778f
C12460 pmu_inst/dc_inst.x7.net2 VGND 0.20011f
C12461 pmu_inst/dc_inst.net6 VGND 0.2856f
C12462 pmu_inst/dc_inst.x7.x1/a_27_47# VGND 0.20779f
C12463 pmu_inst/dc_inst.x1.net3 VGND 0.18399f
C12464 pmu_inst/dc_inst.x1.net2 VGND 0.16253f
C12465 pmu_inst/dc_inst.x1.x2/a_27_47# VGND 0.20778f
C12466 pmu_inst/dc_inst.net3 VGND 0.28098f
C12467 pmu_inst/dc_inst.x4.x1/a_27_47# VGND 0.21148f
C12468 pmu_inst/dc_inst.x1.x18/a_27_47# VGND 0.20778f
C12469 pmu_inst/dc_inst.x4.net15 VGND 0.13226f
C12470 pmu_inst/dc_inst.x4.net14 VGND 0.15393f
C12471 pmu_inst/dc_inst.x4.x15/a_27_47# VGND 0.20778f
C12472 pmu_inst/dc_inst.x7.net11 VGND 0.22817f
C12473 pmu_inst/dc_inst.x7.x12/a_27_47# VGND 0.20778f
C12474 pmu_inst/clkload0/X VGND 0.06701f
C12475 pmu_inst/clkload0/a_27_47# VGND 0.54298f
C12476 pmu_inst/dc_inst.x1.x1/a_27_47# VGND 0.21245f
C12477 pmu_inst/dc_inst.x1.net17 VGND 0.20129f
C12478 pmu_inst/dc_inst.x1.net16 VGND 0.18697f
C12479 pmu_inst/dc_inst.x1.x17/a_27_47# VGND 0.20778f
C12480 pmu_inst/dc_inst.x7.x11/a_27_47# VGND 0.20778f
C12481 pmu_inst/dc_inst.x4.x14/a_27_47# VGND 0.20778f
C12482 pmu_inst/dc_inst.x1.net15 VGND 0.15429f
C12483 pmu_inst/dc_inst.x1.x16/a_27_47# VGND 0.20779f
C12484 pmu_inst/dc_inst.x4.net13 VGND 0.16936f
C12485 pmu_inst/dc_inst.x4.net12 VGND 0.14012f
C12486 pmu_inst/dc_inst.x4.x13/a_27_47# VGND 0.20778f
C12487 pmu_inst/dc_inst.x7.net1 VGND 0.24156f
C12488 pmu_inst/dc_inst.x7.x10/a_27_47# VGND 0.21179f
C12489 pmu_inst/dc_inst.x1.x15/a_27_47# VGND 0.20778f
C12490 pmu_inst/dc_inst.x7.x20/a_27_47# VGND 0.21035f
C12491 pmu_inst/dc_inst.x4.x12/a_27_47# VGND 0.20778f
C12492 pmu_inst/dc_inst.x6.x9/a_27_47# VGND 0.20778f
C12493 pmu_inst/dc_inst.x1.net14 VGND 0.12752f
C12494 pmu_inst/dc_inst.x1.x14/a_27_47# VGND 0.20778f
C12495 pmu_inst/dc_inst.x4.net11 VGND 0.13642f
C12496 pmu_inst/dc_inst.x4.net1 VGND 0.1206f
C12497 pmu_inst/dc_inst.x4.x11/a_27_47# VGND 0.20778f
C12498 pmu_inst/dc_inst.x3.net9 VGND 0.14932f
C12499 pmu_inst/dc_inst.x3.x9/a_27_47# VGND 0.20863f
C12500 pmu_inst/dc_inst.x1.net13 VGND 0.14303f
C12501 pmu_inst/dc_inst.x1.x13/a_27_47# VGND 0.20778f
C12502 pmu_inst/dc_inst.x6.net9 VGND 0.12737f
C12503 pmu_inst/dc_inst.x6.x8/a_27_47# VGND 0.20778f
C12504 pmu_inst/dc_inst.x4.x10/a_27_47# VGND 0.20778f
C12505 _177_/a_113_47# VGND 0
C12506 b[3] VGND 0.85108f
C12507 input26/a_75_212# VGND 0.27949f
C12508 net15 VGND 1.93044f
C12509 a[8] VGND 0.83127f
C12510 input15/a_75_212# VGND 0.27938f
C12511 rst VGND 0.99529f
C12512 input37/a_75_212# VGND 0.25673f
C12513 genblk1\[13\].fa_inst.s VGND 0.99515f
C12514 _103_ VGND 0.36266f
C12515 _194_/a_285_47# VGND 0.01663f
C12516 _194_/a_129_47# VGND -0
C12517 _194_/a_377_297# VGND -0.00125f
C12518 _194_/a_47_47# VGND 0.2407f
C12519 net53 VGND 20.52512f
C12520 _008_ VGND 0.29042f
C12521 _263_/a_651_413# VGND 0.006f
C12522 _263_/a_448_47# VGND 0.01552f
C12523 _263_/a_1108_47# VGND 0.14487f
C12524 _263_/a_1283_21# VGND 0.31526f
C12525 _263_/a_543_47# VGND 0.1783f
C12526 _263_/a_761_289# VGND 0.13927f
C12527 _263_/a_193_47# VGND 0.2949f
C12528 _263_/a_27_47# VGND 0.5012f
C12529 clkbuf_0_clk_regs/a_110_47# VGND 1.78702f
C12530 genblk1\[8\].fa_inst.a VGND 1.86831f
C12531 _025_ VGND 0.39717f
C12532 _280_/a_651_413# VGND 0.00609f
C12533 _280_/a_448_47# VGND 0.0139f
C12534 _280_/a_1108_47# VGND 0.14393f
C12535 _280_/a_1283_21# VGND 0.32707f
C12536 _280_/a_543_47# VGND 0.16167f
C12537 _280_/a_761_289# VGND 0.12627f
C12538 _280_/a_193_47# VGND 0.28244f
C12539 _280_/a_27_47# VGND 0.48142f
C12540 _092_ VGND 0.69918f
C12541 _085_ VGND 0.28182f
C12542 _178_/a_382_47# VGND -0
C12543 _178_/a_298_297# VGND 0
C12544 _178_/a_215_297# VGND 0.14027f
C12545 _178_/a_27_413# VGND 0.17554f
C12546 b[2] VGND 0.85416f
C12547 input25/a_75_212# VGND 0.27939f
C12548 net14 VGND 1.60817f
C12549 a[7] VGND 0.84994f
C12550 input14/a_75_212# VGND 0.26242f
C12551 delay_sel[2] VGND 1.51701f
C12552 input36/a_27_47# VGND 0.3956f
C12553 _105_ VGND 0.3201f
C12554 _195_/a_150_297# VGND -0
C12555 _195_/a_68_297# VGND 0.15997f
C12556 net54 VGND 21.03064f
C12557 _009_ VGND 0.50447f
C12558 _264_/a_651_413# VGND 0.00646f
C12559 _264_/a_448_47# VGND 0.01468f
C12560 _264_/a_1108_47# VGND 0.15668f
C12561 _264_/a_1283_21# VGND 0.30612f
C12562 _264_/a_543_47# VGND 0.16673f
C12563 _264_/a_761_289# VGND 0.12174f
C12564 _264_/a_193_47# VGND 0.29282f
C12565 _264_/a_27_47# VGND 0.54231f
C12566 genblk1\[9\].fa_inst.a VGND 1.805f
C12567 _026_ VGND 0.39585f
C12568 clknet_2_2__leaf_clk_regs VGND 8.71199f
C12569 _281_/a_651_413# VGND 0.00609f
C12570 _281_/a_448_47# VGND 0.0139f
C12571 _281_/a_1108_47# VGND 0.14622f
C12572 _281_/a_1283_21# VGND 0.31542f
C12573 _281_/a_543_47# VGND 0.16167f
C12574 _281_/a_761_289# VGND 0.12627f
C12575 _281_/a_193_47# VGND 0.28194f
C12576 _281_/a_27_47# VGND 0.49941f
C12577 genblk1\[10\].fa_inst.s VGND 1.60248f
C12578 _091_ VGND 0.2777f
C12579 _179_/a_285_47# VGND 0.02039f
C12580 _179_/a_129_47# VGND 0
C12581 _179_/a_47_47# VGND 0.23445f
C12582 b[1] VGND 0.84774f
C12583 input24/a_27_47# VGND 0.27697f
C12584 delay_sel[1] VGND 0.99579f
C12585 input35/a_27_47# VGND 0.34262f
C12586 net13 VGND 1.27311f
C12587 a[6] VGND 0.84373f
C12588 input13/a_75_212# VGND 0.28046f
C12589 _106_ VGND 0.39474f
C12590 genblk1\[14\].fa_inst.b VGND 1.56422f
C12591 _196_/a_113_47# VGND 0
C12592 net40 VGND 20.08312f
C12593 _010_ VGND 0.30679f
C12594 clknet_2_3__leaf_clk_regs VGND 9.46984f
C12595 _265_/a_651_413# VGND 0.006f
C12596 _265_/a_448_47# VGND 0.01546f
C12597 _265_/a_1108_47# VGND 0.14626f
C12598 _265_/a_1283_21# VGND 0.31298f
C12599 _265_/a_543_47# VGND 0.17807f
C12600 _265_/a_761_289# VGND 0.1355f
C12601 _265_/a_193_47# VGND 0.29365f
C12602 _265_/a_27_47# VGND 0.4658f
C12603 genblk1\[10\].fa_inst.a VGND 1.97354f
C12604 _027_ VGND 0.4498f
C12605 _282_/a_651_413# VGND 0.00597f
C12606 _282_/a_448_47# VGND 0.01546f
C12607 _282_/a_1108_47# VGND 0.1426f
C12608 _282_/a_1283_21# VGND 0.31822f
C12609 _282_/a_543_47# VGND 0.15957f
C12610 _282_/a_761_289# VGND 0.13413f
C12611 _282_/a_193_47# VGND 0.29268f
C12612 _282_/a_27_47# VGND 0.5002f
C12613 hold1/a_391_47# VGND 0.12732f
C12614 hold1/a_285_47# VGND 0.30083f
C12615 hold1/a_49_47# VGND 0.3094f
C12616 _044_ VGND 0.69292f
C12617 net60 VGND 8.84832f
C12618 net23 VGND 0.53781f
C12619 b[15] VGND 0.85466f
C12620 input23/a_75_212# VGND 0.26242f
C12621 delay_sel[0] VGND 0.84079f
C12622 input34/a_27_47# VGND 0.31789f
C12623 net12 VGND 1.35262f
C12624 a[5] VGND 0.96047f
C12625 input12/a_75_212# VGND 0.28291f
C12626 _197_/a_113_47# VGND -0
C12627 net41 VGND 13.9351f
C12628 _011_ VGND 0.44439f
C12629 _266_/a_651_413# VGND 0.00611f
C12630 _266_/a_448_47# VGND 0.01393f
C12631 _266_/a_1108_47# VGND 0.13931f
C12632 _266_/a_1283_21# VGND 0.30715f
C12633 _266_/a_543_47# VGND 0.16296f
C12634 _266_/a_761_289# VGND 0.12479f
C12635 _266_/a_193_47# VGND 0.28885f
C12636 _266_/a_27_47# VGND 0.54367f
C12637 net9 VGND 0.53169f
C12638 a[2] VGND 0.84641f
C12639 input9/a_75_212# VGND 0.27949f
C12640 genblk1\[11\].fa_inst.a VGND 1.13132f
C12641 _028_ VGND 0.37747f
C12642 _283_/a_651_413# VGND 0.00562f
C12643 _283_/a_448_47# VGND 0.01468f
C12644 _283_/a_1108_47# VGND 0.14095f
C12645 _283_/a_1283_21# VGND 0.31367f
C12646 _283_/a_543_47# VGND 0.16408f
C12647 _283_/a_761_289# VGND 0.1241f
C12648 _283_/a_193_47# VGND 0.28345f
C12649 _283_/a_27_47# VGND 0.57481f
C12650 clkbuf_1_0__f_clk/a_110_47# VGND 1.84868f
C12651 cin VGND 0.86707f
C12652 input33/a_27_47# VGND 0.2644f
C12653 net11 VGND 1.03249f
C12654 a[4] VGND 0.92785f
C12655 input11/a_75_212# VGND 0.2816f
C12656 b[14] VGND 0.83671f
C12657 input22/a_75_212# VGND 0.27942f
C12658 _108_ VGND 0.80399f
C12659 _198_/a_382_47# VGND -0
C12660 _198_/a_298_297# VGND 0.0015f
C12661 _198_/a_215_297# VGND 0.15767f
C12662 _198_/a_27_413# VGND 0.18512f
C12663 net42 VGND 5.16698f
C12664 _012_ VGND 0.40918f
C12665 _267_/a_651_413# VGND 0.00645f
C12666 _267_/a_448_47# VGND 0.01474f
C12667 _267_/a_1108_47# VGND 0.15596f
C12668 _267_/a_1283_21# VGND 0.29758f
C12669 _267_/a_543_47# VGND 0.16963f
C12670 _267_/a_761_289# VGND 0.12573f
C12671 _267_/a_193_47# VGND 0.2878f
C12672 _267_/a_27_47# VGND 0.50811f
C12673 net8 VGND 0.64206f
C12674 a[1] VGND 0.89699f
C12675 input8/a_75_212# VGND 0.23951f
C12676 genblk1\[12\].fa_inst.a VGND 1.79033f
C12677 _029_ VGND 0.35324f
C12678 _284_/a_651_413# VGND 0.00565f
C12679 _284_/a_448_47# VGND 0.01468f
C12680 _284_/a_1108_47# VGND 0.14028f
C12681 _284_/a_1283_21# VGND 0.30925f
C12682 _284_/a_543_47# VGND 0.16596f
C12683 _284_/a_761_289# VGND 0.12421f
C12684 _284_/a_193_47# VGND 0.28423f
C12685 _284_/a_27_47# VGND 0.55505f
C12686 b[9] VGND 0.83035f
C12687 input32/a_75_212# VGND 0.27949f
C12688 b[13] VGND 0.85178f
C12689 input21/a_75_212# VGND 0.27949f
C12690 net10 VGND 0.39172f
C12691 a[3] VGND 0.85465f
C12692 input10/a_75_212# VGND 0.26242f
C12693 genblk1\[14\].fa_inst.s VGND 0.55893f
C12694 _107_ VGND 0.50046f
C12695 _199_/a_285_47# VGND 0.00427f
C12696 _199_/a_129_47# VGND -0.00145f
C12697 _199_/a_377_297# VGND -0.00125f
C12698 _199_/a_47_47# VGND 0.23174f
C12699 net43 VGND 20.72445f
C12700 _013_ VGND 0.49742f
C12701 _268_/a_651_413# VGND 0.00645f
C12702 _268_/a_448_47# VGND 0.01475f
C12703 _268_/a_1108_47# VGND 0.14396f
C12704 _268_/a_1283_21# VGND 0.31345f
C12705 _268_/a_543_47# VGND 0.16817f
C12706 _268_/a_761_289# VGND 0.12571f
C12707 _268_/a_193_47# VGND 0.28813f
C12708 _268_/a_27_47# VGND 0.50417f
C12709 net7 VGND 1.85778f
C12710 a[15] VGND 0.83098f
C12711 input7/a_27_47# VGND 0.27697f
C12712 genblk1\[13\].fa_inst.a VGND 2.06312f
C12713 _030_ VGND 0.3364f
C12714 _285_/a_651_413# VGND 0.00643f
C12715 _285_/a_448_47# VGND 0.01468f
C12716 _285_/a_1108_47# VGND 0.13893f
C12717 _285_/a_1283_21# VGND 0.2925f
C12718 _285_/a_543_47# VGND 0.16552f
C12719 _285_/a_761_289# VGND 0.12325f
C12720 _285_/a_193_47# VGND 0.27806f
C12721 _285_/a_27_47# VGND 0.5074f
C12722 clknet_0_clk_regs VGND 6.60007f
C12723 clkbuf_2_0__f_clk_regs/a_110_47# VGND 1.8505f
C12724 b[12] VGND 0.86288f
C12725 input20/a_75_212# VGND 0.27939f
C12726 b[8] VGND 0.85077f
C12727 input31/a_75_212# VGND 0.27949f
C12728 net44 VGND 1.24986f
C12729 _014_ VGND 0.30905f
C12730 _269_/a_651_413# VGND 0.00597f
C12731 _269_/a_448_47# VGND 0.01546f
C12732 _269_/a_1108_47# VGND 0.15369f
C12733 _269_/a_1283_21# VGND 0.3296f
C12734 _269_/a_543_47# VGND 0.16375f
C12735 _269_/a_761_289# VGND 0.13414f
C12736 _269_/a_193_47# VGND 0.29181f
C12737 _269_/a_27_47# VGND 0.52628f
C12738 _061_ VGND 0.33555f
C12739 _140_/a_150_297# VGND -0
C12740 _140_/a_68_297# VGND 0.15919f
C12741 net6 VGND 2.36424f
C12742 a[14] VGND 0.85051f
C12743 input6/a_27_47# VGND 0.26832f
C12744 genblk1\[14\].fa_inst.a VGND 0.99818f
C12745 _031_ VGND 0.17077f
C12746 _286_/a_1462_47# VGND -0
C12747 _286_/a_1217_47# VGND -0
C12748 _286_/a_805_47# VGND -0
C12749 _286_/a_639_47# VGND -0.00169f
C12750 _286_/a_651_413# VGND 0.00471f
C12751 _286_/a_448_47# VGND 0.00932f
C12752 _286_/a_1108_47# VGND 0.12854f
C12753 _286_/a_1283_21# VGND 0.29132f
C12754 _286_/a_543_47# VGND 0.15305f
C12755 _286_/a_761_289# VGND 0.11484f
C12756 _286_/a_193_47# VGND 0.28207f
C12757 _286_/a_27_47# VGND 0.35924f
C12758 clkbuf_2_1__f_clk_regs/a_110_47# VGND 1.77663f
C12759 b[7] VGND 0.81277f
C12760 input30/a_75_212# VGND 0.27939f
C12761 _062_ VGND 1.35589f
C12762 _141_/a_113_47# VGND 0
C12763 net5 VGND 2.23656f
C12764 a[13] VGND 0.87146f
C12765 input5/a_27_47# VGND 0.27687f
C12766 genblk1\[15\].fa_inst.a VGND 2.04757f
C12767 _032_ VGND 0.49266f
C12768 _287_/a_651_413# VGND 0.00471f
C12769 _287_/a_448_47# VGND 0.01546f
C12770 _287_/a_1108_47# VGND 0.15614f
C12771 _287_/a_1283_21# VGND 0.3297f
C12772 _287_/a_543_47# VGND 0.16131f
C12773 _287_/a_761_289# VGND 0.12113f
C12774 _287_/a_193_47# VGND 0.30754f
C12775 _287_/a_27_47# VGND 0.52392f
C12776 clkbuf_2_2__f_clk_regs/a_110_47# VGND 1.81326f
C12777 net61 VGND 3.57159f
C12778 fanout59/a_27_47# VGND 0.51992f
C12779 net57 VGND 3.64107f
C12780 clkbuf_2_3__f_clk_regs/a_110_47# VGND 1.79292f
C12781 _142_/a_113_47# VGND -0
C12782 net4 VGND 1.35182f
C12783 a[12] VGND 0.84932f
C12784 input4/a_27_47# VGND 0.27697f
C12785 _033_ VGND 0.40279f
C12786 net17 VGND 3.3336f
C12787 _288_/a_1462_47# VGND 0
C12788 _288_/a_1217_47# VGND 0
C12789 _288_/a_805_47# VGND -0
C12790 _288_/a_639_47# VGND 0.00172f
C12791 _288_/a_1270_413# VGND 0
C12792 _288_/a_651_413# VGND 0.0136f
C12793 _288_/a_448_47# VGND 0.01878f
C12794 _288_/a_1108_47# VGND 0.14535f
C12795 _288_/a_1283_21# VGND 0.31363f
C12796 _288_/a_543_47# VGND 0.18692f
C12797 _288_/a_761_289# VGND 0.13352f
C12798 _288_/a_193_47# VGND 0.31787f
C12799 _288_/a_27_47# VGND 0.46544f
C12800 fanout58/a_27_47# VGND 0.49172f
C12801 _050_ VGND 0.69723f
C12802 genblk1\[0\].fa_inst.b VGND 0.43614f
C12803 _126_/a_150_297# VGND 0
C12804 _126_/a_68_297# VGND 0.17471f
C12805 _064_ VGND 1.00016f
C12806 _143_/a_298_297# VGND 0.00144f
C12807 _143_/a_215_297# VGND 0.159f
C12808 _143_/a_27_413# VGND 0.17441f
C12809 net3 VGND 1.47012f
C12810 a[11] VGND 0.8331f
C12811 input3/a_27_47# VGND 0.27697f
C12812 genblk1\[1\].fa_inst.b VGND 0.90869f
C12813 _034_ VGND 0.42704f
C12814 net24 VGND 1.92334f
C12815 _289_/a_1462_47# VGND 0
C12816 _289_/a_1217_47# VGND 0
C12817 _289_/a_805_47# VGND 0
C12818 _289_/a_639_47# VGND 0
C12819 _289_/a_1270_413# VGND 0
C12820 _289_/a_651_413# VGND 0.00698f
C12821 _289_/a_448_47# VGND 0.01647f
C12822 _289_/a_1108_47# VGND 0.14882f
C12823 _289_/a_1283_21# VGND 0.31018f
C12824 _289_/a_543_47# VGND 0.18082f
C12825 _289_/a_761_289# VGND 0.1379f
C12826 _289_/a_193_47# VGND 0.30237f
C12827 _289_/a_27_47# VGND 0.51209f
C12828 _077_ VGND 0.48995f
C12829 genblk1\[7\].fa_inst.b VGND 1.81921f
C12830 _160_/a_150_297# VGND -0
C12831 _160_/a_68_297# VGND 0.15186f
C12832 fanout57/a_27_47# VGND 0.3074f
C12833 _051_ VGND 0.85502f
C12834 _127_/a_113_47# VGND 0
C12835 genblk1\[3\].fa_inst.s VGND 0.62363f
C12836 _063_ VGND 0.45879f
C12837 _144_/a_285_47# VGND 0.02048f
C12838 _144_/a_129_47# VGND 0
C12839 _144_/a_47_47# VGND 0.23037f
C12840 net2 VGND 1.2337f
C12841 a[10] VGND 0.85203f
C12842 input2/a_27_47# VGND 0.27697f
C12843 _161_/a_113_47# VGND 0
C12844 net58 VGND 8.40959f
C12845 fanout56/a_27_47# VGND 0.50329f
C12846 _128_/a_113_47# VGND 0
C12847 _065_ VGND 0.48954f
C12848 _145_/a_150_297# VGND -0
C12849 _145_/a_68_297# VGND 0.15759f
C12850 VPWR VGND 3.55832p
C12851 net1 VGND 1.21572f
C12852 a[0] VGND 1.19651f
C12853 input1/a_75_212# VGND 0.25577f
C12854 _078_ VGND 0.97277f
C12855 _162_/a_113_47# VGND 0
C12856 _045_ VGND 0.45911f
C12857 net20 VGND 0.79417f
C12858 _300_/a_651_413# VGND 0.0055f
C12859 _300_/a_448_47# VGND 0.01546f
C12860 _300_/a_1108_47# VGND 0.15369f
C12861 _300_/a_1283_21# VGND 0.31023f
C12862 _300_/a_543_47# VGND 0.16347f
C12863 _300_/a_761_289# VGND 0.12325f
C12864 _300_/a_193_47# VGND 0.30683f
C12865 _300_/a_27_47# VGND 0.50866f
C12866 net75 VGND 0.44798f
C12867 _052_ VGND 0.26549f
C12868 _129_/a_285_47# VGND 0.0204f
C12869 _129_/a_129_47# VGND 0
C12870 _129_/a_47_47# VGND 0.21776f
C12871 _146_/a_113_47# VGND 0
C12872 _080_ VGND 0.98119f
C12873 _163_/a_298_297# VGND 0.00195f
C12874 _163_/a_215_297# VGND 0.17898f
C12875 _163_/a_27_413# VGND 0.17819f
C12876 _046_ VGND 0.48011f
C12877 net21 VGND 1.65052f
C12878 _301_/a_651_413# VGND 0.0047f
C12879 _301_/a_448_47# VGND 0.0139f
C12880 _301_/a_1108_47# VGND 0.15619f
C12881 _301_/a_1283_21# VGND 0.32943f
C12882 _301_/a_543_47# VGND 0.15859f
C12883 _301_/a_761_289# VGND 0.12066f
C12884 _301_/a_193_47# VGND 0.2902f
C12885 _301_/a_27_47# VGND 0.49992f
C12886 _180_/a_150_297# VGND -0
C12887 _180_/a_68_297# VGND 0.17199f
C12888 _066_ VGND 0.96894f
C12889 _147_/a_113_47# VGND -0
C12890 genblk1\[7\].fa_inst.s VGND 1.49043f
C12891 _079_ VGND 0.41714f
C12892 _164_/a_285_47# VGND 0.02053f
C12893 _164_/a_129_47# VGND 0
C12894 _164_/a_377_297# VGND -0
C12895 _164_/a_47_47# VGND 0.24176f
C12896 _047_ VGND 0.44747f
C12897 net22 VGND 1.27191f
C12898 _302_/a_651_413# VGND 0.00597f
C12899 _302_/a_448_47# VGND 0.01546f
C12900 _302_/a_1108_47# VGND 0.14016f
C12901 _302_/a_1283_21# VGND 0.32746f
C12902 _302_/a_543_47# VGND 0.15963f
C12903 _302_/a_761_289# VGND 0.13377f
C12904 _302_/a_193_47# VGND 0.29046f
C12905 _302_/a_27_47# VGND 0.46551f
C12906 genblk1\[11\].fa_inst.b VGND 1.12901f
C12907 _181_/a_113_47# VGND 0
C12908 _068_ VGND 0.9555f
C12909 _148_/a_382_47# VGND -0
C12910 _148_/a_298_297# VGND 0
C12911 _148_/a_215_297# VGND 0.14986f
C12912 _148_/a_27_413# VGND 0.17186f
C12913 genblk1\[8\].fa_inst.b VGND 1.04464f
C12914 _165_/a_150_297# VGND -0
C12915 _165_/a_68_297# VGND 0.17118f
C12916 genblk1\[15\].fa_inst.b VGND 2.43555f
C12917 _048_ VGND 0.36215f
C12918 _303_/a_651_413# VGND 0.00599f
C12919 _303_/a_448_47# VGND 0.01546f
C12920 _303_/a_1108_47# VGND 0.14543f
C12921 _303_/a_1283_21# VGND 0.30785f
C12922 _303_/a_543_47# VGND 0.1781f
C12923 _303_/a_761_289# VGND 0.13549f
C12924 _303_/a_193_47# VGND 0.29232f
C12925 _303_/a_27_47# VGND 0.44745f
C12926 _095_ VGND 0.44421f
C12927 _093_ VGND 0.40182f
C12928 _094_ VGND 1.12131f
C12929 _182_/a_113_47# VGND -0
C12930 s[0] VGND 0.83509f
C12931 output39/a_27_47# VGND 0.34156f
C12932 _067_ VGND 0.4466f
C12933 _149_/a_285_47# VGND 0.02055f
C12934 _149_/a_129_47# VGND -0
C12935 _149_/a_47_47# VGND 0.21704f
C12936 clk_regs VGND 1.24409f
C12937 clkbuf_regs_0_clk/a_110_47# VGND 1.84378f
C12938 _166_/a_113_47# VGND 0
C12939 _049_ VGND 0.3687f
C12940 net33 VGND 8.12337f
C12941 _304_/a_1462_47# VGND 0
C12942 _304_/a_1217_47# VGND 0
C12943 _304_/a_805_47# VGND 0
C12944 _304_/a_639_47# VGND 0.00111f
C12945 _304_/a_1270_413# VGND 0
C12946 _304_/a_651_413# VGND 0.0083f
C12947 _304_/a_448_47# VGND 0.01846f
C12948 _304_/a_1108_47# VGND 0.16028f
C12949 _304_/a_1283_21# VGND 0.31038f
C12950 _304_/a_543_47# VGND 0.16769f
C12951 _304_/a_761_289# VGND 0.13946f
C12952 _304_/a_193_47# VGND 0.3235f
C12953 _304_/a_27_47# VGND 0.54944f
C12954 _096_ VGND 0.90034f
C12955 _183_/a_298_297# VGND 0
C12956 _183_/a_215_297# VGND 0.14925f
C12957 _183_/a_27_413# VGND 0.18126f
C12958 net37 VGND 1.63198f
C12959 fanout62/a_110_47# VGND 0.89722f
C12960 clknet_0_clk VGND 0.89957f
C12961 clk VGND 8.41725f
C12962 clkbuf_0_clk/a_110_47# VGND 1.71904f
C12963 s[4] VGND 0.81515f
C12964 output49/a_27_47# VGND 0.33276f
C12965 cout VGND 0.97698f
C12966 output38/a_27_47# VGND 0.31624f
C12967 _167_/a_113_47# VGND -0
C12968 genblk1\[11\].fa_inst.s VGND 0.25807f
C12969 _184_/a_285_47# VGND 0.02066f
C12970 _184_/a_129_47# VGND -0
C12971 _184_/a_377_297# VGND -0
C12972 _184_/a_47_47# VGND 0.20922f
C12973 fanout61/a_27_47# VGND 0.31832f
C12974 net45 VGND 20.89808f
C12975 _015_ VGND 0.31548f
C12976 _270_/a_651_413# VGND 0.00645f
C12977 _270_/a_448_47# VGND 0.01475f
C12978 _270_/a_1108_47# VGND 0.14096f
C12979 _270_/a_1283_21# VGND 0.31127f
C12980 _270_/a_543_47# VGND 0.16872f
C12981 _270_/a_761_289# VGND 0.12579f
C12982 _270_/a_193_47# VGND 0.27753f
C12983 _270_/a_27_47# VGND 0.52243f
C12984 s[3] VGND 0.81515f
C12985 output48/a_27_47# VGND 0.33276f
C12986 _084_ VGND 0.74225f
C12987 _168_/a_298_297# VGND 0.00185f
C12988 _168_/a_215_297# VGND 0.1708f
C12989 _168_/a_27_413# VGND 0.17873f
C12990 clkload2/X VGND 0.12682f
C12991 clkload2/a_27_47# VGND 0.57155f
C12992 _097_ VGND 0.31161f
C12993 _185_/a_150_297# VGND -0
C12994 _185_/a_68_297# VGND 0.15252f
C12995 fanout60/a_27_47# VGND 0.48817f
C12996 net38 VGND 7.71598f
C12997 _016_ VGND 0.31654f
C12998 _271_/a_651_413# VGND 0.00644f
C12999 _271_/a_448_47# VGND 0.01469f
C13000 _271_/a_1108_47# VGND 0.15214f
C13001 _271_/a_1283_21# VGND 0.31577f
C13002 _271_/a_543_47# VGND 0.16592f
C13003 _271_/a_761_289# VGND 0.12415f
C13004 _271_/a_193_47# VGND 0.2803f
C13005 _271_/a_27_47# VGND 0.53324f
C13006 s[2] VGND 0.87576f
C13007 output47/a_27_47# VGND 0.33568f
C13008 genblk1\[8\].fa_inst.s VGND 1.27282f
C13009 _083_ VGND 0.3264f
C13010 _169_/a_285_47# VGND 0.02053f
C13011 _169_/a_129_47# VGND 0
C13012 _169_/a_377_297# VGND -0.00125f
C13013 _169_/a_47_47# VGND 0.2625f
C13014 clkload1/Y VGND 0.05089f
C13015 clkload1/a_268_47# VGND 0
C13016 clkload1/a_110_47# VGND 0
C13017 _098_ VGND 0.63374f
C13018 genblk1\[12\].fa_inst.b VGND 0.767f
C13019 _186_/a_113_47# VGND 0
C13020 net39 VGND 4.09957f
C13021 _000_ VGND 0.38107f
C13022 genblk1\[0\].fa_inst.s VGND 0.79992f
C13023 _255_/a_651_413# VGND 0.0061f
C13024 _255_/a_448_47# VGND 0.01391f
C13025 _255_/a_1108_47# VGND 0.14063f
C13026 _255_/a_1283_21# VGND 0.31504f
C13027 _255_/a_543_47# VGND 0.16234f
C13028 _255_/a_761_289# VGND 0.12474f
C13029 _255_/a_193_47# VGND 0.28732f
C13030 _255_/a_27_47# VGND 0.53952f
C13031 genblk1\[0\].fa_inst.a VGND 0.9782f
C13032 _017_ VGND 0.13728f
C13033 clknet_2_0__leaf_clk_regs VGND 12.43094f
C13034 _272_/a_1462_47# VGND -0
C13035 _272_/a_1217_47# VGND -0
C13036 _272_/a_805_47# VGND -0
C13037 _272_/a_639_47# VGND 0.00172f
C13038 _272_/a_1270_413# VGND 0
C13039 _272_/a_651_413# VGND 0.01164f
C13040 _272_/a_448_47# VGND 0.01717f
C13041 _272_/a_1108_47# VGND 0.13431f
C13042 _272_/a_1283_21# VGND 0.30182f
C13043 _272_/a_543_47# VGND 0.1833f
C13044 _272_/a_761_289# VGND 0.12776f
C13045 _272_/a_193_47# VGND 0.31458f
C13046 _272_/a_27_47# VGND 0.4325f
C13047 s[1] VGND 0.79597f
C13048 output46/a_27_47# VGND 0.33277f
C13049 clkload0/Y VGND 0.09751f
C13050 clkload0/a_361_47# VGND 1.57242f
C13051 clkload0/a_27_47# VGND 0.6348f
C13052 _099_ VGND 0.40215f
C13053 _187_/a_113_47# VGND -0
C13054 net46 VGND 3.95016f
C13055 _001_ VGND 0.32067f
C13056 _256_/a_651_413# VGND 0.00609f
C13057 _256_/a_448_47# VGND 0.0139f
C13058 _256_/a_1108_47# VGND 0.15385f
C13059 _256_/a_1283_21# VGND 0.33078f
C13060 _256_/a_543_47# VGND 0.16061f
C13061 _256_/a_761_289# VGND 0.12313f
C13062 _256_/a_193_47# VGND 0.28521f
C13063 _256_/a_27_47# VGND 0.53097f
C13064 genblk1\[1\].fa_inst.a VGND 1.32398f
C13065 _018_ VGND 0.35207f
C13066 clknet_2_1__leaf_clk_regs VGND 10.21422f
C13067 _273_/a_651_413# VGND 0.00596f
C13068 _273_/a_448_47# VGND 0.01546f
C13069 _273_/a_1108_47# VGND 0.14002f
C13070 _273_/a_1283_21# VGND 0.32075f
C13071 _273_/a_543_47# VGND 0.17457f
C13072 _273_/a_761_289# VGND 0.13563f
C13073 _273_/a_193_47# VGND 0.29592f
C13074 _273_/a_27_47# VGND 0.51678f
C13075 _035_ VGND 0.4516f
C13076 net25 VGND 2.12668f
C13077 _290_/a_651_413# VGND 0.00471f
C13078 _290_/a_448_47# VGND 0.01391f
C13079 _290_/a_1108_47# VGND 0.14383f
C13080 _290_/a_1283_21# VGND 0.30828f
C13081 _290_/a_543_47# VGND 0.16137f
C13082 _290_/a_761_289# VGND 0.12076f
C13083 _290_/a_193_47# VGND 0.27703f
C13084 _290_/a_27_47# VGND 0.47578f
C13085 s[15] VGND 0.79848f
C13086 output45/a_27_47# VGND 0.33671f
C13087 _100_ VGND 0.99864f
C13088 _188_/a_298_297# VGND 0
C13089 _188_/a_215_297# VGND 0.15889f
C13090 _188_/a_27_413# VGND 0.17421f
C13091 net47 VGND 7.58938f
C13092 _002_ VGND 0.35603f
C13093 genblk1\[2\].fa_inst.s VGND 0.55164f
C13094 _257_/a_1462_47# VGND 0
C13095 _257_/a_1217_47# VGND 0
C13096 _257_/a_805_47# VGND 0
C13097 _257_/a_639_47# VGND 0
C13098 _257_/a_1270_413# VGND 0
C13099 _257_/a_651_413# VGND 0.00717f
C13100 _257_/a_448_47# VGND 0.01739f
C13101 _257_/a_1108_47# VGND 0.1578f
C13102 _257_/a_1283_21# VGND 0.33576f
C13103 _257_/a_543_47# VGND 0.16547f
C13104 _257_/a_761_289# VGND 0.1413f
C13105 _257_/a_193_47# VGND 0.29979f
C13106 _257_/a_27_47# VGND 0.53873f
C13107 genblk1\[2\].fa_inst.a VGND 1.89533f
C13108 _019_ VGND 0.46544f
C13109 _274_/a_651_413# VGND 0.00471f
C13110 _274_/a_448_47# VGND 0.01396f
C13111 _274_/a_1108_47# VGND 0.13744f
C13112 _274_/a_1283_21# VGND 0.29009f
C13113 _274_/a_543_47# VGND 0.15928f
C13114 _274_/a_761_289# VGND 0.12091f
C13115 _274_/a_193_47# VGND 0.27553f
C13116 _274_/a_27_47# VGND 0.48591f
C13117 genblk1\[3\].fa_inst.b VGND 0.75457f
C13118 _036_ VGND 0.48831f
C13119 net26 VGND 2.37532f
C13120 _291_/a_651_413# VGND 0.00471f
C13121 _291_/a_448_47# VGND 0.01546f
C13122 _291_/a_1108_47# VGND 0.15387f
C13123 _291_/a_1283_21# VGND 0.31071f
C13124 _291_/a_543_47# VGND 0.16051f
C13125 _291_/a_761_289# VGND 0.12197f
C13126 _291_/a_193_47# VGND 0.2951f
C13127 _291_/a_27_47# VGND 0.51774f
C13128 tdo VGND 0.92074f
C13129 output55/a_27_47# VGND 0.33191f
C13130 s[14] VGND 0.82402f
C13131 output44/a_27_47# VGND 0.3175f
C13132 genblk1\[12\].fa_inst.s VGND 1.71579f
C13133 _189_/a_285_47# VGND 0.02066f
C13134 _189_/a_129_47# VGND -0
C13135 _189_/a_47_47# VGND 0.21109f
C13136 net48 VGND 7.03597f
C13137 _003_ VGND 0.34078f
C13138 _258_/a_651_413# VGND 0.00612f
C13139 _258_/a_448_47# VGND 0.01397f
C13140 _258_/a_1108_47# VGND 0.14273f
C13141 _258_/a_1283_21# VGND 0.32888f
C13142 _258_/a_543_47# VGND 0.16501f
C13143 _258_/a_761_289# VGND 0.12675f
C13144 _258_/a_193_47# VGND 0.28498f
C13145 _258_/a_27_47# VGND 0.53024f
C13146 genblk1\[3\].fa_inst.a VGND 2.29513f
C13147 _020_ VGND 0.32516f
C13148 _275_/a_651_413# VGND 0.00469f
C13149 _275_/a_448_47# VGND 0.0139f
C13150 _275_/a_1108_47# VGND 0.13882f
C13151 _275_/a_1283_21# VGND 0.29465f
C13152 _275_/a_543_47# VGND 0.16028f
C13153 _275_/a_761_289# VGND 0.12448f
C13154 _275_/a_193_47# VGND 0.27542f
C13155 _275_/a_27_47# VGND 0.5181f
C13156 genblk1\[4\].fa_inst.b VGND 0.4996f
C13157 _037_ VGND 0.25643f
C13158 net27 VGND 2.62626f
C13159 _292_/a_1462_47# VGND -0
C13160 _292_/a_1217_47# VGND -0
C13161 _292_/a_805_47# VGND -0
C13162 _292_/a_639_47# VGND -0.00169f
C13163 _292_/a_651_413# VGND 0.00597f
C13164 _292_/a_448_47# VGND 0.00932f
C13165 _292_/a_1108_47# VGND 0.14222f
C13166 _292_/a_1283_21# VGND 0.30565f
C13167 _292_/a_543_47# VGND 0.15188f
C13168 _292_/a_761_289# VGND 0.12805f
C13169 _292_/a_193_47# VGND 0.28224f
C13170 _292_/a_27_47# VGND 0.37314f
C13171 s[9] VGND 0.79582f
C13172 output54/a_27_47# VGND 0.33671f
C13173 s[13] VGND 0.79582f
C13174 output43/a_27_47# VGND 0.33671f
C13175 net49 VGND 5.27785f
C13176 _004_ VGND 0.42427f
C13177 genblk1\[4\].fa_inst.s VGND 0.54463f
C13178 _259_/a_651_413# VGND 0.00598f
C13179 _259_/a_448_47# VGND 0.01547f
C13180 _259_/a_1108_47# VGND 0.13977f
C13181 _259_/a_1283_21# VGND 0.29628f
C13182 _259_/a_543_47# VGND 0.15982f
C13183 _259_/a_761_289# VGND 0.13694f
C13184 _259_/a_193_47# VGND 0.29412f
C13185 _259_/a_27_47# VGND 0.48548f
C13186 cin_q VGND 0.99342f
C13187 _130_/a_382_47# VGND -0
C13188 _130_/a_298_297# VGND 0.00385f
C13189 _130_/a_215_297# VGND 0.15392f
C13190 _130_/a_27_413# VGND 0.17473f
C13191 genblk1\[4\].fa_inst.a VGND 1.6202f
C13192 _021_ VGND 0.80112f
C13193 _276_/a_651_413# VGND 0.00469f
C13194 _276_/a_448_47# VGND 0.0139f
C13195 _276_/a_1108_47# VGND 0.15154f
C13196 _276_/a_1283_21# VGND 0.31849f
C13197 _276_/a_543_47# VGND 0.15978f
C13198 _276_/a_761_289# VGND 0.12253f
C13199 _276_/a_193_47# VGND 0.2775f
C13200 _276_/a_27_47# VGND 0.5102f
C13201 net28 VGND 4.56026f
C13202 _293_/a_1462_47# VGND -0
C13203 _293_/a_1217_47# VGND -0
C13204 _293_/a_805_47# VGND -0
C13205 _293_/a_639_47# VGND 0.00172f
C13206 _293_/a_1270_413# VGND 0
C13207 _293_/a_651_413# VGND 0.01356f
C13208 _293_/a_448_47# VGND 0.01846f
C13209 _293_/a_1108_47# VGND 0.13635f
C13210 _293_/a_1283_21# VGND 0.30893f
C13211 _293_/a_543_47# VGND 0.18705f
C13212 _293_/a_761_289# VGND 0.1271f
C13213 _293_/a_193_47# VGND 0.31309f
C13214 _293_/a_27_47# VGND 0.42026f
C13215 s[8] VGND 0.79582f
C13216 output53/a_27_47# VGND 0.33671f
C13217 s[12] VGND 0.83539f
C13218 output42/a_27_47# VGND 0.31742f
C13219 _054_ VGND 0.39231f
C13220 _131_/a_150_297# VGND 0
C13221 _131_/a_68_297# VGND 0.16396f
C13222 _200_/a_145_75# VGND 0
C13223 _200_/a_59_75# VGND 0.18449f
C13224 genblk1\[5\].fa_inst.a VGND 1.86416f
C13225 _022_ VGND 0.41194f
C13226 _277_/a_651_413# VGND 0.00563f
C13227 _277_/a_448_47# VGND 0.01468f
C13228 _277_/a_1108_47# VGND 0.14133f
C13229 _277_/a_1283_21# VGND 0.31482f
C13230 _277_/a_543_47# VGND 0.16023f
C13231 _277_/a_761_289# VGND 0.12267f
C13232 _277_/a_193_47# VGND 0.27904f
C13233 _277_/a_27_47# VGND 0.56078f
C13234 genblk1\[6\].fa_inst.b VGND 0.80312f
C13235 _039_ VGND 0.48581f
C13236 net29 VGND 2.23f
C13237 _294_/a_651_413# VGND 0.00562f
C13238 _294_/a_448_47# VGND 0.01289f
C13239 _294_/a_1108_47# VGND 0.14085f
C13240 _294_/a_1283_21# VGND 0.33195f
C13241 _294_/a_543_47# VGND 0.16184f
C13242 _294_/a_761_289# VGND 0.12266f
C13243 _294_/a_193_47# VGND 0.27834f
C13244 _294_/a_27_47# VGND 0.52847f
.ends
