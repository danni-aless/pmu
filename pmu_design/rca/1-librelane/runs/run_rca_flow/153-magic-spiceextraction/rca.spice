* NGSPICE file created from rca.ext - technology: sky130A

* Black-box entry subcircuit for sky130_fd_sc_hd__decap_3 abstract view
.subckt sky130_fd_sc_hd__decap_3 VGND VNB VPB VPWR
.ends

* Black-box entry subcircuit for sky130_fd_sc_hd__tapvpwrvgnd_1 abstract view
.subckt sky130_fd_sc_hd__tapvpwrvgnd_1 VGND VPWR
.ends

* Black-box entry subcircuit for sky130_fd_sc_hd__dfrtp_1 abstract view
.subckt sky130_fd_sc_hd__dfrtp_1 CLK D RESET_B VGND VNB VPB VPWR Q
.ends

* Black-box entry subcircuit for sky130_fd_sc_hd__fill_2 abstract view
.subckt sky130_fd_sc_hd__fill_2 VGND VNB VPB VPWR
.ends

* Black-box entry subcircuit for sky130_fd_sc_hd__and2_1 abstract view
.subckt sky130_fd_sc_hd__and2_1 A B VGND VNB VPB VPWR X
.ends

* Black-box entry subcircuit for sky130_fd_sc_hd__or2_1 abstract view
.subckt sky130_fd_sc_hd__or2_1 A B VGND VNB VPB VPWR X
.ends

* Black-box entry subcircuit for sky130_fd_sc_hd__fill_1 abstract view
.subckt sky130_fd_sc_hd__fill_1 VGND VNB VPB VPWR
.ends

* Black-box entry subcircuit for sky130_fd_sc_hd__buf_2 abstract view
.subckt sky130_fd_sc_hd__buf_2 A VGND VNB VPB VPWR X
.ends

* Black-box entry subcircuit for sky130_fd_sc_hd__a21bo_1 abstract view
.subckt sky130_fd_sc_hd__a21bo_1 A1 A2 B1_N VGND VNB VPB VPWR X
.ends

* Black-box entry subcircuit for sky130_fd_sc_hd__xnor2_1 abstract view
.subckt sky130_fd_sc_hd__xnor2_1 A B VGND VNB VPB VPWR Y
.ends

* Black-box entry subcircuit for sky130_fd_sc_hd__nand2_1 abstract view
.subckt sky130_fd_sc_hd__nand2_1 A B VGND VNB VPB VPWR Y
.ends

* Black-box entry subcircuit for sky130_fd_sc_hd__bufinv_16 abstract view
.subckt sky130_fd_sc_hd__bufinv_16 A VGND VNB VPB VPWR Y
.ends

* Black-box entry subcircuit for sky130_fd_sc_hd__inv_2 abstract view
.subckt sky130_fd_sc_hd__inv_2 A VGND VNB VPB VPWR Y
.ends

* Black-box entry subcircuit for sky130_fd_sc_hd__clkinvlp_4 abstract view
.subckt sky130_fd_sc_hd__clkinvlp_4 A VGND VNB VPB VPWR Y
.ends

* Black-box entry subcircuit for sky130_fd_sc_hd__buf_4 abstract view
.subckt sky130_fd_sc_hd__buf_4 A VGND VNB VPB VPWR X
.ends

* Black-box entry subcircuit for sky130_fd_sc_hd__clkbuf_4 abstract view
.subckt sky130_fd_sc_hd__clkbuf_4 A VGND VNB VPB VPWR X
.ends

* Black-box entry subcircuit for sky130_fd_sc_hd__clkbuf_16 abstract view
.subckt sky130_fd_sc_hd__clkbuf_16 A VGND VNB VPB VPWR X
.ends

* Black-box entry subcircuit for sky130_fd_sc_hd__clkbuf_8 abstract view
.subckt sky130_fd_sc_hd__clkbuf_8 A VGND VNB VPB VPWR X
.ends

* Black-box entry subcircuit for sky130_fd_sc_hd__clkbuf_1 abstract view
.subckt sky130_fd_sc_hd__clkbuf_1 A VGND VNB VPB VPWR X
.ends

* Black-box entry subcircuit for sky130_fd_sc_hd__buf_1 abstract view
.subckt sky130_fd_sc_hd__buf_1 A VGND VNB VPB VPWR X
.ends

* Black-box entry subcircuit for sky130_fd_sc_hd__dlygate4sd3_1 abstract view
.subckt sky130_fd_sc_hd__dlygate4sd3_1 A VGND VNB VPB VPWR X
.ends

* Black-box entry subcircuit for sky130_fd_sc_hd__clkbuf_2 abstract view
.subckt sky130_fd_sc_hd__clkbuf_2 A VGND VNB VPB VPWR X
.ends

* Black-box entry subcircuit for pmu abstract view
.subckt pmu VGND VPWR clk delay_sel[0] delay_sel[1] delay_sel[2] path[0] path[1] path[2]
+ path[3] path[4] path[5] path[6] path[7] path_sel[0] path_sel[1] path_sel[2] rst
+ se tdi tdo
.ends

* Black-box entry subcircuit for sky130_fd_sc_hd__conb_1 abstract view
.subckt sky130_fd_sc_hd__conb_1 VGND VNB VPB VPWR HI LO
.ends

* Black-box entry subcircuit for sky130_fd_sc_hd__o21bai_4 abstract view
.subckt sky130_fd_sc_hd__o21bai_4 A1 A2 B1_N VGND VNB VPB VPWR Y
.ends

* Black-box entry subcircuit for sky130_fd_sc_hd__diode_2 abstract view
.subckt sky130_fd_sc_hd__diode_2 DIODE VGND VNB VPB VPWR
.ends

* Black-box entry subcircuit for sky130_fd_sc_hd__nor2_1 abstract view
.subckt sky130_fd_sc_hd__nor2_1 A B VGND VNB VPB VPWR Y
.ends

* Black-box entry subcircuit for sky130_fd_sc_hd__a21boi_2 abstract view
.subckt sky130_fd_sc_hd__a21boi_2 A1 A2 B1_N VGND VNB VPB VPWR Y
.ends

.subckt rca VGND VPWR a[0] a[10] a[11] a[12] a[13] a[14] a[15] a[1] a[2] a[3] a[4]
+ a[5] a[6] a[7] a[8] a[9] b[0] b[10] b[11] b[12] b[13] b[14] b[15] b[1] b[2] b[3]
+ b[4] b[5] b[6] b[7] b[8] b[9] cin clk cout delay_sel[0] delay_sel[1] delay_sel[2]
+ rst s[0] s[10] s[11] s[12] s[13] s[14] s[15] s[1] s[2] s[3] s[4] s[5] s[6] s[7]
+ s[8] s[9] tdo
XFILLER_39_211 VGND VGND VPWR VPWR sky130_fd_sc_hd__decap_3
XFILLER_54_203 VGND VGND VPWR VPWR sky130_fd_sc_hd__decap_3
XFILLER_39_255 VGND VGND VPWR VPWR sky130_fd_sc_hd__decap_3
XFILLER_54_236 VGND VGND VPWR VPWR sky130_fd_sc_hd__decap_3
XFILLER_39_299 VGND VGND VPWR VPWR sky130_fd_sc_hd__decap_3
XFILLER_22_100 VGND VGND VPWR VPWR sky130_fd_sc_hd__decap_3
XFILLER_22_133 VGND VGND VPWR VPWR sky130_fd_sc_hd__decap_3
XFILLER_62_280 VGND VGND VPWR VPWR sky130_fd_sc_hd__decap_3
XTAP_TAPCELL_ROW_52_459 VGND VPWR sky130_fd_sc_hd__tapvpwrvgnd_1
XFILLER_52_29 VGND VGND VPWR VPWR sky130_fd_sc_hd__decap_3
XFILLER_22_144 VGND VGND VPWR VPWR sky130_fd_sc_hd__decap_3
XFILLER_22_177 VGND VGND VPWR VPWR sky130_fd_sc_hd__decap_3
XFILLER_45_225 VGND VGND VPWR VPWR sky130_fd_sc_hd__decap_3
XFILLER_45_214 VGND VGND VPWR VPWR sky130_fd_sc_hd__decap_3
XFILLER_26_41 VGND VGND VPWR VPWR sky130_fd_sc_hd__decap_3
XFILLER_45_258 VGND VGND VPWR VPWR sky130_fd_sc_hd__decap_3
XFILLER_60_206 VGND VGND VPWR VPWR sky130_fd_sc_hd__decap_3
XFILLER_13_122 VGND VGND VPWR VPWR sky130_fd_sc_hd__decap_3
XFILLER_26_85 VGND VGND VPWR VPWR sky130_fd_sc_hd__decap_3
XFILLER_60_239 VGND VGND VPWR VPWR sky130_fd_sc_hd__decap_3
XFILLER_13_155 VGND VGND VPWR VPWR sky130_fd_sc_hd__decap_3
XFILLER_9_137 VGND VGND VPWR VPWR sky130_fd_sc_hd__decap_3
X_294_ clknet_2_1__leaf_clk_regs net29 _039_ VGND VGND VPWR VPWR genblk1\[6\].fa_inst.b
+ sky130_fd_sc_hd__dfrtp_1
XFILLER_42_62 VGND VGND VPWR VPWR sky130_fd_sc_hd__decap_3
XFILLER_5_343 VGND VGND VPWR VPWR sky130_fd_sc_hd__decap_3
XFILLER_54_9 VGND VGND VPWR VPWR sky130_fd_sc_hd__decap_3
XFILLER_5_376 VGND VGND VPWR VPWR sky130_fd_sc_hd__decap_3
XFILLER_3_34 VGND VGND VPWR VPWR sky130_fd_sc_hd__fill_2
XFILLER_3_78 VGND VGND VPWR VPWR sky130_fd_sc_hd__decap_3
XFILLER_36_203 VGND VGND VPWR VPWR sky130_fd_sc_hd__decap_3
XPHY_EDGE_ROW_20_1_Right_19 VGND VGND VPWR VPWR sky130_fd_sc_hd__decap_3
XFILLER_36_236 VGND VGND VPWR VPWR sky130_fd_sc_hd__decap_3
XFILLER_51_228 VGND VGND VPWR VPWR sky130_fd_sc_hd__decap_3
XFILLER_51_217 VGND VGND VPWR VPWR sky130_fd_sc_hd__decap_3
XFILLER_44_280 VGND VGND VPWR VPWR sky130_fd_sc_hd__decap_3
XFILLER_59_317 VGND VGND VPWR VPWR sky130_fd_sc_hd__decap_3
XFILLER_47_18 VGND VGND VPWR VPWR sky130_fd_sc_hd__decap_3
XFILLER_27_214 VGND VGND VPWR VPWR sky130_fd_sc_hd__decap_3
XFILLER_27_225 VGND VGND VPWR VPWR sky130_fd_sc_hd__decap_3
XFILLER_27_258 VGND VGND VPWR VPWR sky130_fd_sc_hd__decap_3
XFILLER_63_28 VGND VGND VPWR VPWR sky130_fd_sc_hd__decap_3
XFILLER_42_206 VGND VGND VPWR VPWR sky130_fd_sc_hd__decap_3
XFILLER_42_239 VGND VGND VPWR VPWR sky130_fd_sc_hd__decap_3
XFILLER_10_103 VGND VGND VPWR VPWR sky130_fd_sc_hd__decap_3
XFILLER_50_283 VGND VGND VPWR VPWR sky130_fd_sc_hd__decap_3
XFILLER_10_136 VGND VGND VPWR VPWR sky130_fd_sc_hd__decap_3
XFILLER_10_147 VGND VGND VPWR VPWR sky130_fd_sc_hd__decap_3
XFILLER_12_32 VGND VGND VPWR VPWR sky130_fd_sc_hd__decap_3
XFILLER_6_118 VGND VGND VPWR VPWR sky130_fd_sc_hd__decap_3
XFILLER_12_65 VGND VGND VPWR VPWR sky130_fd_sc_hd__decap_3
XFILLER_2_357 VGND VGND VPWR VPWR sky130_fd_sc_hd__decap_3
XFILLER_2_346 VGND VGND VPWR VPWR sky130_fd_sc_hd__decap_3
XFILLER_58_383 VGND VGND VPWR VPWR sky130_fd_sc_hd__decap_3
XFILLER_37_40 VGND VGND VPWR VPWR sky130_fd_sc_hd__decap_3
XFILLER_37_95 VGND VGND VPWR VPWR sky130_fd_sc_hd__decap_3
XFILLER_33_217 VGND VGND VPWR VPWR sky130_fd_sc_hd__decap_3
XFILLER_26_280 VGND VGND VPWR VPWR sky130_fd_sc_hd__decap_3
XFILLER_33_228 VGND VGND VPWR VPWR sky130_fd_sc_hd__decap_3
XFILLER_53_72 VGND VGND VPWR VPWR sky130_fd_sc_hd__decap_3
XFILLER_41_261 VGND VGND VPWR VPWR sky130_fd_sc_hd__decap_3
X_277_ clknet_2_1__leaf_clk_regs net12 _022_ VGND VGND VPWR VPWR genblk1\[5\].fa_inst.a
+ sky130_fd_sc_hd__dfrtp_1
XFILLER_5_140 VGND VGND VPWR VPWR sky130_fd_sc_hd__decap_3
XFILLER_52_6 VGND VGND VPWR VPWR sky130_fd_sc_hd__fill_2
XFILLER_56_309 VGND VGND VPWR VPWR sky130_fd_sc_hd__decap_3
XFILLER_49_361 VGND VGND VPWR VPWR sky130_fd_sc_hd__decap_3
XFILLER_64_320 VGND VGND VPWR VPWR sky130_fd_sc_hd__decap_3
XFILLER_24_206 VGND VGND VPWR VPWR sky130_fd_sc_hd__decap_3
XFILLER_64_386 VGND VGND VPWR VPWR sky130_fd_sc_hd__decap_3
XFILLER_24_239 VGND VGND VPWR VPWR sky130_fd_sc_hd__decap_3
XTAP_TAPCELL_ROW_62_532 VGND VPWR sky130_fd_sc_hd__tapvpwrvgnd_1
XFILLER_32_283 VGND VGND VPWR VPWR sky130_fd_sc_hd__decap_3
XFILLER_59_169 VGND VGND VPWR VPWR sky130_fd_sc_hd__decap_3
XFILLER_59_147 VGND VGND VPWR VPWR sky130_fd_sc_hd__decap_3
XFILLER_55_320 VGND VGND VPWR VPWR sky130_fd_sc_hd__decap_3
XPHY_EDGE_ROW_21_Right_42 VGND VGND VPWR VPWR sky130_fd_sc_hd__decap_3
XFILLER_55_364 VGND VGND VPWR VPWR sky130_fd_sc_hd__decap_3
XFILLER_30_209 VGND VGND VPWR VPWR sky130_fd_sc_hd__decap_3
XFILLER_23_261 VGND VGND VPWR VPWR sky130_fd_sc_hd__decap_3
XTAP_TAPCELL_ROW_25_267 VGND VPWR sky130_fd_sc_hd__tapvpwrvgnd_1
X_200_ genblk1\[15\].fa_inst.b genblk1\[15\].fa_inst.a VGND VGND VPWR VPWR _109_ sky130_fd_sc_hd__and2_1
X_131_ genblk1\[1\].fa_inst.b genblk1\[1\].fa_inst.a VGND VGND VPWR VPWR _054_ sky130_fd_sc_hd__or2_1
XFILLER_23_75 VGND VGND VPWR VPWR sky130_fd_sc_hd__fill_1
XPHY_EDGE_ROW_30_Right_51 VGND VGND VPWR VPWR sky130_fd_sc_hd__decap_3
XFILLER_2_121 VGND VGND VPWR VPWR sky130_fd_sc_hd__decap_3
XFILLER_2_165 VGND VGND VPWR VPWR sky130_fd_sc_hd__decap_3
XFILLER_48_61 VGND VGND VPWR VPWR sky130_fd_sc_hd__decap_3
XFILLER_38_309 VGND VGND VPWR VPWR sky130_fd_sc_hd__decap_3
XFILLER_17_9 VGND VGND VPWR VPWR sky130_fd_sc_hd__decap_3
XFILLER_48_83 VGND VGND VPWR VPWR sky130_fd_sc_hd__fill_1
XFILLER_0_24 VGND VGND VPWR VPWR sky130_fd_sc_hd__decap_3
XFILLER_0_35 VGND VGND VPWR VPWR sky130_fd_sc_hd__decap_3
XFILLER_58_180 VGND VGND VPWR VPWR sky130_fd_sc_hd__decap_3
XFILLER_46_342 VGND VGND VPWR VPWR sky130_fd_sc_hd__decap_3
XFILLER_0_57 VGND VGND VPWR VPWR sky130_fd_sc_hd__decap_3
XFILLER_64_60 VGND VGND VPWR VPWR sky130_fd_sc_hd__decap_3
XFILLER_61_323 VGND VGND VPWR VPWR sky130_fd_sc_hd__decap_3
XFILLER_46_386 VGND VGND VPWR VPWR sky130_fd_sc_hd__decap_3
XFILLER_21_209 VGND VGND VPWR VPWR sky130_fd_sc_hd__decap_3
XFILLER_61_367 VGND VGND VPWR VPWR sky130_fd_sc_hd__decap_3
XFILLER_9_55 VGND VGND VPWR VPWR sky130_fd_sc_hd__fill_1
XFILLER_9_66 VGND VGND VPWR VPWR sky130_fd_sc_hd__decap_3
XFILLER_9_99 VGND VGND VPWR VPWR sky130_fd_sc_hd__decap_3
XFILLER_56_106 VGND VGND VPWR VPWR sky130_fd_sc_hd__decap_3
XFILLER_56_139 VGND VGND VPWR VPWR sky130_fd_sc_hd__fill_1
XFILLER_37_320 VGND VGND VPWR VPWR sky130_fd_sc_hd__decap_3
XFILLER_64_150 VGND VGND VPWR VPWR sky130_fd_sc_hd__decap_3
XFILLER_52_301 VGND VGND VPWR VPWR sky130_fd_sc_hd__decap_3
XFILLER_37_364 VGND VGND VPWR VPWR sky130_fd_sc_hd__decap_3
XFILLER_64_172 VGND VGND VPWR VPWR sky130_fd_sc_hd__decap_3
XFILLER_52_312 VGND VGND VPWR VPWR sky130_fd_sc_hd__decap_3
XFILLER_52_345 VGND VGND VPWR VPWR sky130_fd_sc_hd__decap_3
XFILLER_52_389 VGND VGND VPWR VPWR sky130_fd_sc_hd__decap_3
XTAP_TAPCELL_ROW_22_248 VGND VPWR sky130_fd_sc_hd__tapvpwrvgnd_1
XFILLER_47_128 VGND VGND VPWR VPWR sky130_fd_sc_hd__decap_3
XFILLER_28_342 VGND VGND VPWR VPWR sky130_fd_sc_hd__decap_3
XFILLER_62_109 VGND VGND VPWR VPWR sky130_fd_sc_hd__decap_3
XFILLER_55_161 VGND VGND VPWR VPWR sky130_fd_sc_hd__decap_3
XFILLER_18_97 VGND VGND VPWR VPWR sky130_fd_sc_hd__decap_3
XFILLER_55_172 VGND VGND VPWR VPWR sky130_fd_sc_hd__decap_3
XFILLER_43_323 VGND VGND VPWR VPWR sky130_fd_sc_hd__decap_3
XFILLER_28_386 VGND VGND VPWR VPWR sky130_fd_sc_hd__decap_3
XFILLER_43_367 VGND VGND VPWR VPWR sky130_fd_sc_hd__decap_3
XFILLER_34_41 VGND VGND VPWR VPWR sky130_fd_sc_hd__decap_3
XFILLER_34_85 VGND VGND VPWR VPWR sky130_fd_sc_hd__decap_3
XFILLER_34_74 VGND VGND VPWR VPWR sky130_fd_sc_hd__decap_3
XFILLER_50_62 VGND VGND VPWR VPWR sky130_fd_sc_hd__decap_3
XFILLER_59_60 VGND VGND VPWR VPWR sky130_fd_sc_hd__decap_3
XFILLER_59_93 VGND VGND VPWR VPWR sky130_fd_sc_hd__decap_3
XFILLER_38_106 VGND VGND VPWR VPWR sky130_fd_sc_hd__decap_3
XFILLER_15_6 VGND VGND VPWR VPWR sky130_fd_sc_hd__decap_3
XFILLER_19_331 VGND VGND VPWR VPWR sky130_fd_sc_hd__decap_3
XTAP_TAPCELL_ROW_6_1_187 VGND VPWR sky130_fd_sc_hd__tapvpwrvgnd_1
XFILLER_38_139 VGND VGND VPWR VPWR sky130_fd_sc_hd__fill_1
XFILLER_19_364 VGND VGND VPWR VPWR sky130_fd_sc_hd__decap_3
XFILLER_46_150 VGND VGND VPWR VPWR sky130_fd_sc_hd__decap_3
XFILLER_19_397 VGND VGND VPWR VPWR sky130_fd_sc_hd__decap_3
XFILLER_46_183 VGND VGND VPWR VPWR sky130_fd_sc_hd__decap_3
XFILLER_34_312 VGND VGND VPWR VPWR sky130_fd_sc_hd__decap_3
XFILLER_34_301 VGND VGND VPWR VPWR sky130_fd_sc_hd__decap_3
XFILLER_61_131 VGND VGND VPWR VPWR sky130_fd_sc_hd__decap_3
XFILLER_34_345 VGND VGND VPWR VPWR sky130_fd_sc_hd__decap_3
XFILLER_61_175 VGND VGND VPWR VPWR sky130_fd_sc_hd__decap_3
XFILLER_61_164 VGND VGND VPWR VPWR sky130_fd_sc_hd__decap_3
XFILLER_34_389 VGND VGND VPWR VPWR sky130_fd_sc_hd__decap_3
XFILLER_29_106 VGND VGND VPWR VPWR sky130_fd_sc_hd__decap_3
XFILLER_29_128 VGND VGND VPWR VPWR sky130_fd_sc_hd__decap_3
XFILLER_25_323 VGND VGND VPWR VPWR sky130_fd_sc_hd__decap_3
XFILLER_37_172 VGND VGND VPWR VPWR sky130_fd_sc_hd__decap_3
XFILLER_37_161 VGND VGND VPWR VPWR sky130_fd_sc_hd__decap_3
XFILLER_25_367 VGND VGND VPWR VPWR sky130_fd_sc_hd__decap_3
XTAP_TAPCELL_ROW_35_340 VGND VPWR sky130_fd_sc_hd__tapvpwrvgnd_1
XFILLER_52_153 VGND VGND VPWR VPWR sky130_fd_sc_hd__decap_3
XFILLER_52_131 VGND VGND VPWR VPWR sky130_fd_sc_hd__decap_3
XFILLER_52_186 VGND VGND VPWR VPWR sky130_fd_sc_hd__decap_3
XFILLER_40_315 VGND VGND VPWR VPWR sky130_fd_sc_hd__decap_3
XFILLER_40_304 VGND VGND VPWR VPWR sky130_fd_sc_hd__decap_3
XFILLER_52_197 VGND VGND VPWR VPWR sky130_fd_sc_hd__decap_3
XFILLER_40_348 VGND VGND VPWR VPWR sky130_fd_sc_hd__decap_3
XFILLER_20_21 VGND VGND VPWR VPWR sky130_fd_sc_hd__decap_3
XFILLER_20_32 VGND VGND VPWR VPWR sky130_fd_sc_hd__decap_3
XFILLER_20_65 VGND VGND VPWR VPWR sky130_fd_sc_hd__fill_1
XFILLER_20_76 VGND VGND VPWR VPWR sky130_fd_sc_hd__decap_3
XFILLER_0_400 VGND VGND VPWR VPWR sky130_fd_sc_hd__decap_3
XFILLER_48_404 VGND VGND VPWR VPWR sky130_fd_sc_hd__decap_3
XFILLER_29_96 VGND VGND VPWR VPWR sky130_fd_sc_hd__decap_3
XFILLER_35_109 VGND VGND VPWR VPWR sky130_fd_sc_hd__decap_3
XTAP_TAPCELL_ROW_58_498 VGND VPWR sky130_fd_sc_hd__tapvpwrvgnd_1
XFILLER_28_183 VGND VGND VPWR VPWR sky130_fd_sc_hd__decap_3
XFILLER_16_334 VGND VGND VPWR VPWR sky130_fd_sc_hd__decap_3
XFILLER_45_73 VGND VGND VPWR VPWR sky130_fd_sc_hd__decap_3
XFILLER_45_62 VGND VGND VPWR VPWR sky130_fd_sc_hd__decap_3
XFILLER_43_131 VGND VGND VPWR VPWR sky130_fd_sc_hd__decap_3
XFILLER_16_378 VGND VGND VPWR VPWR sky130_fd_sc_hd__decap_3
XFILLER_43_175 VGND VGND VPWR VPWR sky130_fd_sc_hd__decap_3
XFILLER_43_164 VGND VGND VPWR VPWR sky130_fd_sc_hd__decap_3
XFILLER_31_326 VGND VGND VPWR VPWR sky130_fd_sc_hd__decap_3
XFILLER_31_337 VGND VGND VPWR VPWR sky130_fd_sc_hd__decap_3
XFILLER_61_72 VGND VGND VPWR VPWR sky130_fd_sc_hd__decap_3
XFILLER_6_12 VGND VGND VPWR VPWR sky130_fd_sc_hd__decap_3
XFILLER_6_56 VGND VGND VPWR VPWR sky130_fd_sc_hd__decap_3
XFILLER_13_3 VGND VGND VPWR VPWR sky130_fd_sc_hd__decap_3
XFILLER_26_109 VGND VGND VPWR VPWR sky130_fd_sc_hd__decap_3
XFILLER_19_161 VGND VGND VPWR VPWR sky130_fd_sc_hd__decap_3
XFILLER_19_172 VGND VGND VPWR VPWR sky130_fd_sc_hd__decap_3
XFILLER_22_304 VGND VGND VPWR VPWR sky130_fd_sc_hd__decap_3
XFILLER_22_315 VGND VGND VPWR VPWR sky130_fd_sc_hd__decap_3
XFILLER_34_153 VGND VGND VPWR VPWR sky130_fd_sc_hd__decap_3
XFILLER_22_348 VGND VGND VPWR VPWR sky130_fd_sc_hd__decap_3
XTAP_TAPCELL_ROW_32_321 VGND VPWR sky130_fd_sc_hd__tapvpwrvgnd_1
XFILLER_34_197 VGND VGND VPWR VPWR sky130_fd_sc_hd__decap_3
XFILLER_34_186 VGND VGND VPWR VPWR sky130_fd_sc_hd__decap_3
XFILLER_30_392 VGND VGND VPWR VPWR sky130_fd_sc_hd__decap_3
XFILLER_57_234 VGND VGND VPWR VPWR sky130_fd_sc_hd__decap_3
XFILLER_57_223 VGND VGND VPWR VPWR sky130_fd_sc_hd__fill_1
XFILLER_17_109 VGND VGND VPWR VPWR sky130_fd_sc_hd__decap_3
XFILLER_57_267 VGND VGND VPWR VPWR sky130_fd_sc_hd__decap_3
XFILLER_25_131 VGND VGND VPWR VPWR sky130_fd_sc_hd__decap_3
XFILLER_25_164 VGND VGND VPWR VPWR sky130_fd_sc_hd__decap_3
XFILLER_25_175 VGND VGND VPWR VPWR sky130_fd_sc_hd__decap_3
XTAP_TAPCELL_ROW_55_479 VGND VPWR sky130_fd_sc_hd__tapvpwrvgnd_1
XFILLER_13_337 VGND VGND VPWR VPWR sky130_fd_sc_hd__decap_3
XFILLER_15_43 VGND VGND VPWR VPWR sky130_fd_sc_hd__decap_3
XFILLER_15_87 VGND VGND VPWR VPWR sky130_fd_sc_hd__decap_3
XFILLER_40_156 VGND VGND VPWR VPWR sky130_fd_sc_hd__decap_3
XFILLER_40_189 VGND VGND VPWR VPWR sky130_fd_sc_hd__decap_3
XTAP_TAPCELL_ROW_5_1_186 VGND VPWR sky130_fd_sc_hd__tapvpwrvgnd_1
XFILLER_31_53 VGND VGND VPWR VPWR sky130_fd_sc_hd__decap_3
XFILLER_31_75 VGND VGND VPWR VPWR sky130_fd_sc_hd__decap_3
Xoutput42 net42 VGND VGND VPWR VPWR s[12] sky130_fd_sc_hd__buf_2
Xoutput53 net53 VGND VGND VPWR VPWR s[8] sky130_fd_sc_hd__buf_2
XFILLER_48_212 VGND VGND VPWR VPWR sky130_fd_sc_hd__decap_3
XFILLER_56_50 VGND VGND VPWR VPWR sky130_fd_sc_hd__decap_3
XFILLER_48_256 VGND VGND VPWR VPWR sky130_fd_sc_hd__decap_3
XFILLER_48_245 VGND VGND VPWR VPWR sky130_fd_sc_hd__decap_3
XFILLER_63_237 VGND VGND VPWR VPWR sky130_fd_sc_hd__decap_3
XFILLER_48_289 VGND VGND VPWR VPWR sky130_fd_sc_hd__decap_3
XFILLER_16_131 VGND VGND VPWR VPWR sky130_fd_sc_hd__decap_3
XFILLER_56_94 VGND VGND VPWR VPWR sky130_fd_sc_hd__decap_3
XFILLER_16_153 VGND VGND VPWR VPWR sky130_fd_sc_hd__decap_3
XFILLER_31_134 VGND VGND VPWR VPWR sky130_fd_sc_hd__decap_3
XFILLER_31_167 VGND VGND VPWR VPWR sky130_fd_sc_hd__fill_1
XFILLER_12_381 VGND VGND VPWR VPWR sky130_fd_sc_hd__decap_3
XFILLER_31_178 VGND VGND VPWR VPWR sky130_fd_sc_hd__decap_3
XFILLER_8_352 VGND VGND VPWR VPWR sky130_fd_sc_hd__fill_1
XFILLER_8_363 VGND VGND VPWR VPWR sky130_fd_sc_hd__decap_3
XFILLER_8_396 VGND VGND VPWR VPWR sky130_fd_sc_hd__decap_3
XFILLER_39_234 VGND VGND VPWR VPWR sky130_fd_sc_hd__decap_3
XFILLER_39_223 VGND VGND VPWR VPWR sky130_fd_sc_hd__fill_1
XFILLER_39_267 VGND VGND VPWR VPWR sky130_fd_sc_hd__decap_3
XFILLER_54_215 VGND VGND VPWR VPWR sky130_fd_sc_hd__decap_3
XFILLER_54_259 VGND VGND VPWR VPWR sky130_fd_sc_hd__decap_3
XFILLER_54_248 VGND VGND VPWR VPWR sky130_fd_sc_hd__decap_3
XFILLER_22_112 VGND VGND VPWR VPWR sky130_fd_sc_hd__decap_3
XFILLER_62_292 VGND VGND VPWR VPWR sky130_fd_sc_hd__decap_3
XFILLER_22_156 VGND VGND VPWR VPWR sky130_fd_sc_hd__decap_3
XFILLER_22_189 VGND VGND VPWR VPWR sky130_fd_sc_hd__decap_3
XFILLER_45_237 VGND VGND VPWR VPWR sky130_fd_sc_hd__decap_3
XFILLER_26_75 VGND VGND VPWR VPWR sky130_fd_sc_hd__decap_3
XFILLER_60_218 VGND VGND VPWR VPWR sky130_fd_sc_hd__decap_3
XFILLER_26_97 VGND VGND VPWR VPWR sky130_fd_sc_hd__decap_3
XFILLER_53_281 VGND VGND VPWR VPWR sky130_fd_sc_hd__decap_3
XFILLER_53_270 VGND VGND VPWR VPWR sky130_fd_sc_hd__decap_3
XFILLER_13_134 VGND VGND VPWR VPWR sky130_fd_sc_hd__decap_3
XFILLER_13_167 VGND VGND VPWR VPWR sky130_fd_sc_hd__fill_1
XFILLER_9_105 VGND VGND VPWR VPWR sky130_fd_sc_hd__decap_3
XFILLER_9_116 VGND VGND VPWR VPWR sky130_fd_sc_hd__decap_3
XFILLER_13_178 VGND VGND VPWR VPWR sky130_fd_sc_hd__fill_2
XFILLER_9_149 VGND VGND VPWR VPWR sky130_fd_sc_hd__decap_3
X_293_ clknet_2_1__leaf_clk_regs net28 _038_ VGND VGND VPWR VPWR genblk1\[5\].fa_inst.b
+ sky130_fd_sc_hd__dfrtp_1
XFILLER_42_41 VGND VGND VPWR VPWR sky130_fd_sc_hd__decap_3
XFILLER_42_85 VGND VGND VPWR VPWR sky130_fd_sc_hd__decap_3
XFILLER_42_74 VGND VGND VPWR VPWR sky130_fd_sc_hd__decap_3
XFILLER_5_355 VGND VGND VPWR VPWR sky130_fd_sc_hd__decap_3
XFILLER_5_388 VGND VGND VPWR VPWR sky130_fd_sc_hd__decap_3
XFILLER_47_9 VGND VGND VPWR VPWR sky130_fd_sc_hd__decap_3
XFILLER_36_215 VGND VGND VPWR VPWR sky130_fd_sc_hd__decap_3
XFILLER_36_259 VGND VGND VPWR VPWR sky130_fd_sc_hd__decap_3
XFILLER_36_248 VGND VGND VPWR VPWR sky130_fd_sc_hd__decap_3
XFILLER_44_292 VGND VGND VPWR VPWR sky130_fd_sc_hd__decap_3
XFILLER_8_171 VGND VGND VPWR VPWR sky130_fd_sc_hd__decap_3
XFILLER_59_329 VGND VGND VPWR VPWR sky130_fd_sc_hd__decap_3
XFILLER_27_237 VGND VGND VPWR VPWR sky130_fd_sc_hd__decap_3
XFILLER_42_218 VGND VGND VPWR VPWR sky130_fd_sc_hd__decap_3
XFILLER_35_281 VGND VGND VPWR VPWR sky130_fd_sc_hd__decap_3
XFILLER_35_270 VGND VGND VPWR VPWR sky130_fd_sc_hd__decap_3
XFILLER_50_251 VGND VGND VPWR VPWR sky130_fd_sc_hd__fill_1
XFILLER_10_115 VGND VGND VPWR VPWR sky130_fd_sc_hd__decap_3
XFILLER_50_262 VGND VGND VPWR VPWR sky130_fd_sc_hd__decap_3
XFILLER_10_159 VGND VGND VPWR VPWR sky130_fd_sc_hd__decap_3
XFILLER_50_295 VGND VGND VPWR VPWR sky130_fd_sc_hd__decap_3
XFILLER_12_44 VGND VGND VPWR VPWR sky130_fd_sc_hd__decap_3
XFILLER_12_77 VGND VGND VPWR VPWR sky130_fd_sc_hd__decap_3
XFILLER_12_88 VGND VGND VPWR VPWR sky130_fd_sc_hd__decap_3
XFILLER_2_369 VGND VGND VPWR VPWR sky130_fd_sc_hd__decap_3
XFILLER_58_351 VGND VGND VPWR VPWR sky130_fd_sc_hd__decap_3
XFILLER_58_395 VGND VGND VPWR VPWR sky130_fd_sc_hd__decap_3
XFILLER_37_74 VGND VGND VPWR VPWR sky130_fd_sc_hd__decap_3
XFILLER_26_292 VGND VGND VPWR VPWR sky130_fd_sc_hd__decap_3
XFILLER_53_40 VGND VGND VPWR VPWR sky130_fd_sc_hd__decap_3
XFILLER_41_240 VGND VGND VPWR VPWR sky130_fd_sc_hd__decap_3
XFILLER_53_84 VGND VGND VPWR VPWR sky130_fd_sc_hd__decap_3
XFILLER_41_284 VGND VGND VPWR VPWR sky130_fd_sc_hd__decap_3
XFILLER_41_273 VGND VGND VPWR VPWR sky130_fd_sc_hd__decap_3
X_276_ clknet_2_1__leaf_clk_regs net11 _021_ VGND VGND VPWR VPWR genblk1\[4\].fa_inst.a
+ sky130_fd_sc_hd__dfrtp_1
XFILLER_5_152 VGND VGND VPWR VPWR sky130_fd_sc_hd__decap_3
XFILLER_45_6 VGND VGND VPWR VPWR sky130_fd_sc_hd__decap_3
XFILLER_1_391 VGND VGND VPWR VPWR sky130_fd_sc_hd__decap_3
XFILLER_49_340 VGND VGND VPWR VPWR sky130_fd_sc_hd__decap_3
XFILLER_49_373 VGND VGND VPWR VPWR sky130_fd_sc_hd__decap_3
XFILLER_64_332 VGND VGND VPWR VPWR sky130_fd_sc_hd__decap_3
XFILLER_64_343 VGND VGND VPWR VPWR sky130_fd_sc_hd__decap_3
XFILLER_24_218 VGND VGND VPWR VPWR sky130_fd_sc_hd__decap_3
XFILLER_64_365 VGND VGND VPWR VPWR sky130_fd_sc_hd__decap_3
XFILLER_20_402 VGND VGND VPWR VPWR sky130_fd_sc_hd__decap_3
XFILLER_32_262 VGND VGND VPWR VPWR sky130_fd_sc_hd__decap_3
XFILLER_32_251 VGND VGND VPWR VPWR sky130_fd_sc_hd__fill_1
XFILLER_32_295 VGND VGND VPWR VPWR sky130_fd_sc_hd__decap_3
XFILLER_58_18 VGND VGND VPWR VPWR sky130_fd_sc_hd__decap_3
XFILLER_59_126 VGND VGND VPWR VPWR sky130_fd_sc_hd__decap_3
XFILLER_59_159 VGND VGND VPWR VPWR sky130_fd_sc_hd__decap_3
XFILLER_55_343 VGND VGND VPWR VPWR sky130_fd_sc_hd__decap_3
XFILLER_55_332 VGND VGND VPWR VPWR sky130_fd_sc_hd__decap_3
XFILLER_55_376 VGND VGND VPWR VPWR sky130_fd_sc_hd__decap_3
XFILLER_23_240 VGND VGND VPWR VPWR sky130_fd_sc_hd__decap_3
XFILLER_23_273 VGND VGND VPWR VPWR sky130_fd_sc_hd__decap_3
XTAP_TAPCELL_ROW_25_268 VGND VPWR sky130_fd_sc_hd__tapvpwrvgnd_1
XFILLER_23_284 VGND VGND VPWR VPWR sky130_fd_sc_hd__decap_3
XFILLER_7_406 VGND VGND VPWR VPWR sky130_fd_sc_hd__fill_1
X_130_ cin_q _050_ _051_ VGND VGND VPWR VPWR _053_ sky130_fd_sc_hd__a21bo_1
XFILLER_2_100 VGND VGND VPWR VPWR sky130_fd_sc_hd__decap_3
XFILLER_2_144 VGND VGND VPWR VPWR sky130_fd_sc_hd__decap_3
XFILLER_2_133 VGND VGND VPWR VPWR sky130_fd_sc_hd__decap_3
XFILLER_58_192 VGND VGND VPWR VPWR sky130_fd_sc_hd__decap_3
XFILLER_46_321 VGND VGND VPWR VPWR sky130_fd_sc_hd__decap_3
XFILLER_0_47 VGND VGND VPWR VPWR sky130_fd_sc_hd__decap_3
XFILLER_0_69 VGND VGND VPWR VPWR sky130_fd_sc_hd__decap_3
XFILLER_61_302 VGND VGND VPWR VPWR sky130_fd_sc_hd__decap_3
XFILLER_46_365 VGND VGND VPWR VPWR sky130_fd_sc_hd__decap_3
XFILLER_46_354 VGND VGND VPWR VPWR sky130_fd_sc_hd__decap_3
XFILLER_64_50 VGND VGND VPWR VPWR sky130_fd_sc_hd__decap_3
XFILLER_64_72 VGND VGND VPWR VPWR sky130_fd_sc_hd__decap_3
XFILLER_61_335 VGND VGND VPWR VPWR sky130_fd_sc_hd__fill_1
XFILLER_46_398 VGND VGND VPWR VPWR sky130_fd_sc_hd__decap_3
XFILLER_64_94 VGND VGND VPWR VPWR sky130_fd_sc_hd__decap_3
XFILLER_61_346 VGND VGND VPWR VPWR sky130_fd_sc_hd__decap_3
XFILLER_9_34 VGND VGND VPWR VPWR sky130_fd_sc_hd__decap_3
XFILLER_61_379 VGND VGND VPWR VPWR sky130_fd_sc_hd__decap_3
XFILLER_9_78 VGND VGND VPWR VPWR sky130_fd_sc_hd__decap_3
X_259_ clknet_2_0__leaf_clk_regs genblk1\[4\].fa_inst.s _004_ VGND VGND VPWR VPWR
+ net49 sky130_fd_sc_hd__dfrtp_1
XFILLER_43_3 VGND VGND VPWR VPWR sky130_fd_sc_hd__decap_3
XFILLER_56_118 VGND VGND VPWR VPWR sky130_fd_sc_hd__decap_3
XFILLER_49_181 VGND VGND VPWR VPWR sky130_fd_sc_hd__decap_3
XFILLER_37_332 VGND VGND VPWR VPWR sky130_fd_sc_hd__decap_3
XFILLER_37_376 VGND VGND VPWR VPWR sky130_fd_sc_hd__decap_3
XFILLER_37_343 VGND VGND VPWR VPWR sky130_fd_sc_hd__decap_3
XFILLER_64_162 VGND VGND VPWR VPWR sky130_fd_sc_hd__decap_3
XFILLER_64_184 VGND VGND VPWR VPWR sky130_fd_sc_hd__decap_3
XFILLER_52_324 VGND VGND VPWR VPWR sky130_fd_sc_hd__decap_3
XFILLER_52_368 VGND VGND VPWR VPWR sky130_fd_sc_hd__decap_3
XFILLER_52_357 VGND VGND VPWR VPWR sky130_fd_sc_hd__decap_3
XTAP_TAPCELL_ROW_22_249 VGND VPWR sky130_fd_sc_hd__tapvpwrvgnd_1
XFILLER_18_21 VGND VGND VPWR VPWR sky130_fd_sc_hd__decap_3
XFILLER_18_32 VGND VGND VPWR VPWR sky130_fd_sc_hd__decap_3
XFILLER_28_321 VGND VGND VPWR VPWR sky130_fd_sc_hd__decap_3
XFILLER_55_140 VGND VGND VPWR VPWR sky130_fd_sc_hd__decap_3
XFILLER_28_365 VGND VGND VPWR VPWR sky130_fd_sc_hd__decap_3
XFILLER_28_354 VGND VGND VPWR VPWR sky130_fd_sc_hd__decap_3
XTAP_TAPCELL_ROW_38_360 VGND VPWR sky130_fd_sc_hd__tapvpwrvgnd_1
XFILLER_55_184 VGND VGND VPWR VPWR sky130_fd_sc_hd__decap_3
XFILLER_43_335 VGND VGND VPWR VPWR sky130_fd_sc_hd__fill_1
XFILLER_43_302 VGND VGND VPWR VPWR sky130_fd_sc_hd__decap_3
XFILLER_28_398 VGND VGND VPWR VPWR sky130_fd_sc_hd__decap_3
XFILLER_43_346 VGND VGND VPWR VPWR sky130_fd_sc_hd__decap_3
XFILLER_43_379 VGND VGND VPWR VPWR sky130_fd_sc_hd__decap_3
XFILLER_34_53 VGND VGND VPWR VPWR sky130_fd_sc_hd__decap_3
XFILLER_34_97 VGND VGND VPWR VPWR sky130_fd_sc_hd__decap_3
XFILLER_50_41 VGND VGND VPWR VPWR sky130_fd_sc_hd__decap_3
XFILLER_50_85 VGND VGND VPWR VPWR sky130_fd_sc_hd__decap_3
XFILLER_50_74 VGND VGND VPWR VPWR sky130_fd_sc_hd__decap_3
XFILLER_59_72 VGND VGND VPWR VPWR sky130_fd_sc_hd__decap_3
XFILLER_38_118 VGND VGND VPWR VPWR sky130_fd_sc_hd__decap_3
XTAP_TAPCELL_ROW_6_1_188 VGND VPWR sky130_fd_sc_hd__tapvpwrvgnd_1
XFILLER_19_343 VGND VGND VPWR VPWR sky130_fd_sc_hd__decap_3
XFILLER_19_376 VGND VGND VPWR VPWR sky130_fd_sc_hd__decap_3
XFILLER_46_162 VGND VGND VPWR VPWR sky130_fd_sc_hd__decap_3
XFILLER_34_324 VGND VGND VPWR VPWR sky130_fd_sc_hd__decap_3
XFILLER_61_143 VGND VGND VPWR VPWR sky130_fd_sc_hd__decap_3
XFILLER_46_195 VGND VGND VPWR VPWR sky130_fd_sc_hd__fill_1
XFILLER_34_368 VGND VGND VPWR VPWR sky130_fd_sc_hd__decap_3
XFILLER_34_357 VGND VGND VPWR VPWR sky130_fd_sc_hd__decap_3
XFILLER_61_187 VGND VGND VPWR VPWR sky130_fd_sc_hd__decap_3
XPHY_EDGE_ROW_7_1_Right_6 VGND VGND VPWR VPWR sky130_fd_sc_hd__decap_3
XFILLER_37_140 VGND VGND VPWR VPWR sky130_fd_sc_hd__decap_3
XFILLER_1_90 VGND VGND VPWR VPWR sky130_fd_sc_hd__decap_3
XFILLER_25_302 VGND VGND VPWR VPWR sky130_fd_sc_hd__decap_3
XFILLER_37_184 VGND VGND VPWR VPWR sky130_fd_sc_hd__decap_3
XFILLER_25_335 VGND VGND VPWR VPWR sky130_fd_sc_hd__fill_1
XFILLER_25_346 VGND VGND VPWR VPWR sky130_fd_sc_hd__decap_3
XFILLER_25_379 VGND VGND VPWR VPWR sky130_fd_sc_hd__decap_3
XTAP_TAPCELL_ROW_35_341 VGND VPWR sky130_fd_sc_hd__tapvpwrvgnd_1
XFILLER_52_165 VGND VGND VPWR VPWR sky130_fd_sc_hd__decap_3
XFILLER_40_327 VGND VGND VPWR VPWR sky130_fd_sc_hd__decap_3
XFILLER_20_44 VGND VGND VPWR VPWR sky130_fd_sc_hd__decap_3
XFILLER_20_88 VGND VGND VPWR VPWR sky130_fd_sc_hd__decap_3
XFILLER_29_42 VGND VGND VPWR VPWR sky130_fd_sc_hd__decap_3
XFILLER_29_75 VGND VGND VPWR VPWR sky130_fd_sc_hd__decap_3
XTAP_TAPCELL_ROW_58_499 VGND VPWR sky130_fd_sc_hd__tapvpwrvgnd_1
XFILLER_28_162 VGND VGND VPWR VPWR sky130_fd_sc_hd__decap_3
XFILLER_16_346 VGND VGND VPWR VPWR sky130_fd_sc_hd__decap_3
XFILLER_16_357 VGND VGND VPWR VPWR sky130_fd_sc_hd__decap_3
XFILLER_45_41 VGND VGND VPWR VPWR sky130_fd_sc_hd__decap_3
XFILLER_43_143 VGND VGND VPWR VPWR sky130_fd_sc_hd__decap_3
XFILLER_28_195 VGND VGND VPWR VPWR sky130_fd_sc_hd__fill_1
XFILLER_45_85 VGND VGND VPWR VPWR sky130_fd_sc_hd__decap_3
XFILLER_31_305 VGND VGND VPWR VPWR sky130_fd_sc_hd__decap_3
XFILLER_43_187 VGND VGND VPWR VPWR sky130_fd_sc_hd__decap_3
XFILLER_31_349 VGND VGND VPWR VPWR sky130_fd_sc_hd__decap_3
XFILLER_61_51 VGND VGND VPWR VPWR sky130_fd_sc_hd__decap_3
XFILLER_61_84 VGND VGND VPWR VPWR sky130_fd_sc_hd__decap_3
XFILLER_6_24 VGND VGND VPWR VPWR sky130_fd_sc_hd__decap_3
XFILLER_6_35 VGND VGND VPWR VPWR sky130_fd_sc_hd__decap_3
XFILLER_39_405 VGND VGND VPWR VPWR sky130_fd_sc_hd__fill_2
XFILLER_19_140 VGND VGND VPWR VPWR sky130_fd_sc_hd__decap_3
XFILLER_34_121 VGND VGND VPWR VPWR sky130_fd_sc_hd__decap_3
XFILLER_34_165 VGND VGND VPWR VPWR sky130_fd_sc_hd__decap_3
XFILLER_22_327 VGND VGND VPWR VPWR sky130_fd_sc_hd__decap_3
XTAP_TAPCELL_ROW_32_322 VGND VPWR sky130_fd_sc_hd__tapvpwrvgnd_1
XFILLER_30_371 VGND VGND VPWR VPWR sky130_fd_sc_hd__decap_3
XFILLER_30_360 VGND VGND VPWR VPWR sky130_fd_sc_hd__decap_3
XFILLER_57_202 VGND VGND VPWR VPWR sky130_fd_sc_hd__decap_3
XFILLER_57_246 VGND VGND VPWR VPWR sky130_fd_sc_hd__decap_3
XFILLER_57_279 VGND VGND VPWR VPWR sky130_fd_sc_hd__fill_1
XFILLER_25_143 VGND VGND VPWR VPWR sky130_fd_sc_hd__decap_3
XFILLER_13_349 VGND VGND VPWR VPWR sky130_fd_sc_hd__decap_3
XFILLER_15_55 VGND VGND VPWR VPWR sky130_fd_sc_hd__fill_1
XFILLER_15_66 VGND VGND VPWR VPWR sky130_fd_sc_hd__decap_3
XFILLER_25_187 VGND VGND VPWR VPWR sky130_fd_sc_hd__decap_3
XFILLER_40_124 VGND VGND VPWR VPWR sky130_fd_sc_hd__decap_3
XFILLER_15_99 VGND VGND VPWR VPWR sky130_fd_sc_hd__decap_3
XFILLER_40_168 VGND VGND VPWR VPWR sky130_fd_sc_hd__decap_3
XFILLER_21_371 VGND VGND VPWR VPWR sky130_fd_sc_hd__decap_3
XFILLER_21_393 VGND VGND VPWR VPWR sky130_fd_sc_hd__decap_3
XFILLER_31_87 VGND VGND VPWR VPWR sky130_fd_sc_hd__decap_3
Xoutput43 net43 VGND VGND VPWR VPWR s[13] sky130_fd_sc_hd__buf_2
Xoutput54 net54 VGND VGND VPWR VPWR s[9] sky130_fd_sc_hd__buf_2
XFILLER_48_224 VGND VGND VPWR VPWR sky130_fd_sc_hd__decap_3
XFILLER_48_268 VGND VGND VPWR VPWR sky130_fd_sc_hd__decap_3
XFILLER_63_205 VGND VGND VPWR VPWR sky130_fd_sc_hd__decap_3
XTAP_TAPCELL_ROW_46_414 VGND VPWR sky130_fd_sc_hd__tapvpwrvgnd_1
XFILLER_56_62 VGND VGND VPWR VPWR sky130_fd_sc_hd__decap_3
XFILLER_63_249 VGND VGND VPWR VPWR sky130_fd_sc_hd__decap_3
XTAP_TAPCELL_ROW_0_1_554 VGND VPWR sky130_fd_sc_hd__tapvpwrvgnd_1
XFILLER_16_165 VGND VGND VPWR VPWR sky130_fd_sc_hd__decap_3
XFILLER_31_113 VGND VGND VPWR VPWR sky130_fd_sc_hd__decap_3
XFILLER_31_102 VGND VGND VPWR VPWR sky130_fd_sc_hd__decap_3
XFILLER_31_146 VGND VGND VPWR VPWR sky130_fd_sc_hd__decap_3
XFILLER_12_360 VGND VGND VPWR VPWR sky130_fd_sc_hd__decap_3
XFILLER_12_393 VGND VGND VPWR VPWR sky130_fd_sc_hd__decap_3
XFILLER_8_331 VGND VGND VPWR VPWR sky130_fd_sc_hd__decap_3
XFILLER_8_375 VGND VGND VPWR VPWR sky130_fd_sc_hd__decap_3
XFILLER_39_202 VGND VGND VPWR VPWR sky130_fd_sc_hd__decap_3
XFILLER_39_246 VGND VGND VPWR VPWR sky130_fd_sc_hd__decap_3
XFILLER_54_227 VGND VGND VPWR VPWR sky130_fd_sc_hd__decap_3
XFILLER_39_279 VGND VGND VPWR VPWR sky130_fd_sc_hd__fill_1
XFILLER_47_290 VGND VGND VPWR VPWR sky130_fd_sc_hd__decap_3
XFILLER_22_124 VGND VGND VPWR VPWR sky130_fd_sc_hd__decap_3
XFILLER_62_271 VGND VGND VPWR VPWR sky130_fd_sc_hd__decap_3
XFILLER_22_168 VGND VGND VPWR VPWR sky130_fd_sc_hd__decap_3
XFILLER_7_9 VGND VGND VPWR VPWR sky130_fd_sc_hd__decap_3
XFILLER_45_205 VGND VGND VPWR VPWR sky130_fd_sc_hd__decap_3
XFILLER_26_21 VGND VGND VPWR VPWR sky130_fd_sc_hd__decap_3
XFILLER_26_32 VGND VGND VPWR VPWR sky130_fd_sc_hd__decap_3
XFILLER_45_249 VGND VGND VPWR VPWR sky130_fd_sc_hd__decap_3
XFILLER_13_113 VGND VGND VPWR VPWR sky130_fd_sc_hd__decap_3
XFILLER_53_293 VGND VGND VPWR VPWR sky130_fd_sc_hd__decap_3
XFILLER_13_146 VGND VGND VPWR VPWR sky130_fd_sc_hd__decap_3
XFILLER_9_128 VGND VGND VPWR VPWR sky130_fd_sc_hd__decap_3
XTAP_TAPCELL_ROW_51_450 VGND VPWR sky130_fd_sc_hd__tapvpwrvgnd_1
X_292_ clknet_2_0__leaf_clk_regs net27 _037_ VGND VGND VPWR VPWR genblk1\[4\].fa_inst.b
+ sky130_fd_sc_hd__dfrtp_1
XFILLER_42_53 VGND VGND VPWR VPWR sky130_fd_sc_hd__decap_3
XFILLER_21_190 VGND VGND VPWR VPWR sky130_fd_sc_hd__decap_3
XPHY_EDGE_ROW_39_Left_145 VGND VGND VPWR VPWR sky130_fd_sc_hd__decap_3
XFILLER_5_334 VGND VGND VPWR VPWR sky130_fd_sc_hd__decap_3
XPHY_EDGE_ROW_1_1_Left_107 VGND VGND VPWR VPWR sky130_fd_sc_hd__decap_3
XFILLER_5_367 VGND VGND VPWR VPWR sky130_fd_sc_hd__decap_3
XFILLER_3_69 VGND VGND VPWR VPWR sky130_fd_sc_hd__decap_3
XPHY_EDGE_ROW_48_Left_154 VGND VGND VPWR VPWR sky130_fd_sc_hd__decap_3
XFILLER_36_227 VGND VGND VPWR VPWR sky130_fd_sc_hd__decap_3
XFILLER_29_290 VGND VGND VPWR VPWR sky130_fd_sc_hd__decap_3
XFILLER_51_208 VGND VGND VPWR VPWR sky130_fd_sc_hd__decap_3
XFILLER_44_271 VGND VGND VPWR VPWR sky130_fd_sc_hd__decap_3
XFILLER_8_150 VGND VGND VPWR VPWR sky130_fd_sc_hd__decap_3
XPHY_EDGE_ROW_57_Left_163 VGND VGND VPWR VPWR sky130_fd_sc_hd__decap_3
XFILLER_59_308 VGND VGND VPWR VPWR sky130_fd_sc_hd__decap_3
XFILLER_27_205 VGND VGND VPWR VPWR sky130_fd_sc_hd__decap_3
XFILLER_27_249 VGND VGND VPWR VPWR sky130_fd_sc_hd__decap_3
XFILLER_63_19 VGND VGND VPWR VPWR sky130_fd_sc_hd__decap_3
XFILLER_50_230 VGND VGND VPWR VPWR sky130_fd_sc_hd__decap_3
XFILLER_35_293 VGND VGND VPWR VPWR sky130_fd_sc_hd__decap_3
XFILLER_50_274 VGND VGND VPWR VPWR sky130_fd_sc_hd__decap_3
XFILLER_10_127 VGND VGND VPWR VPWR sky130_fd_sc_hd__decap_3
XFILLER_6_109 VGND VGND VPWR VPWR sky130_fd_sc_hd__decap_3
XFILLER_12_56 VGND VGND VPWR VPWR sky130_fd_sc_hd__decap_3
XFILLER_5_6 VGND VGND VPWR VPWR sky130_fd_sc_hd__decap_3
XFILLER_2_337 VGND VGND VPWR VPWR sky130_fd_sc_hd__decap_3
XFILLER_58_330 VGND VGND VPWR VPWR sky130_fd_sc_hd__decap_3
XFILLER_58_374 VGND VGND VPWR VPWR sky130_fd_sc_hd__decap_3
XFILLER_58_363 VGND VGND VPWR VPWR sky130_fd_sc_hd__fill_1
XFILLER_37_86 VGND VGND VPWR VPWR sky130_fd_sc_hd__decap_3
XFILLER_33_208 VGND VGND VPWR VPWR sky130_fd_sc_hd__decap_3
XFILLER_26_271 VGND VGND VPWR VPWR sky130_fd_sc_hd__decap_3
XTAP_TAPCELL_ROW_28_288 VGND VPWR sky130_fd_sc_hd__tapvpwrvgnd_1
XFILLER_53_63 VGND VGND VPWR VPWR sky130_fd_sc_hd__decap_3
XFILLER_53_52 VGND VGND VPWR VPWR sky130_fd_sc_hd__decap_3
XFILLER_53_96 VGND VGND VPWR VPWR sky130_fd_sc_hd__decap_3
XFILLER_41_252 VGND VGND VPWR VPWR sky130_fd_sc_hd__decap_3
X_275_ clknet_2_1__leaf_clk_regs net10 _020_ VGND VGND VPWR VPWR genblk1\[3\].fa_inst.a
+ sky130_fd_sc_hd__dfrtp_1
XFILLER_41_296 VGND VGND VPWR VPWR sky130_fd_sc_hd__decap_3
XFILLER_5_131 VGND VGND VPWR VPWR sky130_fd_sc_hd__decap_3
XFILLER_5_164 VGND VGND VPWR VPWR sky130_fd_sc_hd__decap_3
XFILLER_5_175 VGND VGND VPWR VPWR sky130_fd_sc_hd__fill_2
XFILLER_1_370 VGND VGND VPWR VPWR sky130_fd_sc_hd__decap_3
XFILLER_38_6 VGND VGND VPWR VPWR sky130_fd_sc_hd__decap_3
XFILLER_49_352 VGND VGND VPWR VPWR sky130_fd_sc_hd__decap_3
XFILLER_49_396 VGND VGND VPWR VPWR sky130_fd_sc_hd__decap_3
XFILLER_49_385 VGND VGND VPWR VPWR sky130_fd_sc_hd__decap_3
XFILLER_64_355 VGND VGND VPWR VPWR sky130_fd_sc_hd__decap_3
XFILLER_64_377 VGND VGND VPWR VPWR sky130_fd_sc_hd__decap_3
XFILLER_64_399 VGND VGND VPWR VPWR sky130_fd_sc_hd__decap_3
XFILLER_32_230 VGND VGND VPWR VPWR sky130_fd_sc_hd__decap_3
XFILLER_32_274 VGND VGND VPWR VPWR sky130_fd_sc_hd__decap_3
XFILLER_59_105 VGND VGND VPWR VPWR sky130_fd_sc_hd__decap_3
XFILLER_59_138 VGND VGND VPWR VPWR sky130_fd_sc_hd__decap_3
XFILLER_55_311 VGND VGND VPWR VPWR sky130_fd_sc_hd__decap_3
XFILLER_55_355 VGND VGND VPWR VPWR sky130_fd_sc_hd__decap_3
XFILLER_55_399 VGND VGND VPWR VPWR sky130_fd_sc_hd__decap_3
XFILLER_55_388 VGND VGND VPWR VPWR sky130_fd_sc_hd__decap_3
XFILLER_11_403 VGND VGND VPWR VPWR sky130_fd_sc_hd__decap_3
XFILLER_23_252 VGND VGND VPWR VPWR sky130_fd_sc_hd__decap_3
XTAP_TAPCELL_ROW_25_269 VGND VPWR sky130_fd_sc_hd__tapvpwrvgnd_1
XFILLER_23_296 VGND VGND VPWR VPWR sky130_fd_sc_hd__decap_3
XFILLER_23_66 VGND VGND VPWR VPWR sky130_fd_sc_hd__decap_3
XFILLER_23_99 VGND VGND VPWR VPWR sky130_fd_sc_hd__decap_3
XFILLER_2_112 VGND VGND VPWR VPWR sky130_fd_sc_hd__decap_3
XFILLER_3_3 VGND VGND VPWR VPWR sky130_fd_sc_hd__decap_3
XFILLER_2_156 VGND VGND VPWR VPWR sky130_fd_sc_hd__decap_3
XFILLER_48_52 VGND VGND VPWR VPWR sky130_fd_sc_hd__fill_1
XFILLER_48_85 VGND VGND VPWR VPWR sky130_fd_sc_hd__decap_3
XFILLER_0_15 VGND VGND VPWR VPWR sky130_fd_sc_hd__decap_3
XFILLER_58_171 VGND VGND VPWR VPWR sky130_fd_sc_hd__decap_3
XFILLER_46_333 VGND VGND VPWR VPWR sky130_fd_sc_hd__decap_3
XFILLER_61_314 VGND VGND VPWR VPWR sky130_fd_sc_hd__decap_3
XFILLER_46_377 VGND VGND VPWR VPWR sky130_fd_sc_hd__decap_3
XFILLER_61_358 VGND VGND VPWR VPWR sky130_fd_sc_hd__decap_3
XFILLER_9_46 VGND VGND VPWR VPWR sky130_fd_sc_hd__decap_3
XFILLER_9_57 VGND VGND VPWR VPWR sky130_fd_sc_hd__decap_3
X_258_ clknet_2_0__leaf_clk_regs genblk1\[3\].fa_inst.s _003_ VGND VGND VPWR VPWR
+ net48 sky130_fd_sc_hd__dfrtp_1
X_189_ _099_ _100_ VGND VGND VPWR VPWR genblk1\[12\].fa_inst.s sky130_fd_sc_hd__xnor2_1
XFILLER_49_193 VGND VGND VPWR VPWR sky130_fd_sc_hd__decap_3
XFILLER_37_311 VGND VGND VPWR VPWR sky130_fd_sc_hd__decap_3
XFILLER_64_141 VGND VGND VPWR VPWR sky130_fd_sc_hd__decap_3
XFILLER_37_355 VGND VGND VPWR VPWR sky130_fd_sc_hd__decap_3
XFILLER_37_399 VGND VGND VPWR VPWR sky130_fd_sc_hd__decap_3
XFILLER_37_388 VGND VGND VPWR VPWR sky130_fd_sc_hd__decap_3
XFILLER_52_336 VGND VGND VPWR VPWR sky130_fd_sc_hd__decap_3
XFILLER_60_380 VGND VGND VPWR VPWR sky130_fd_sc_hd__decap_3
XFILLER_47_119 VGND VGND VPWR VPWR sky130_fd_sc_hd__decap_3
XFILLER_47_108 VGND VGND VPWR VPWR sky130_fd_sc_hd__decap_3
XFILLER_18_44 VGND VGND VPWR VPWR sky130_fd_sc_hd__decap_3
XFILLER_28_333 VGND VGND VPWR VPWR sky130_fd_sc_hd__decap_3
XFILLER_18_77 VGND VGND VPWR VPWR sky130_fd_sc_hd__decap_3
XFILLER_55_152 VGND VGND VPWR VPWR sky130_fd_sc_hd__decap_3
XFILLER_18_88 VGND VGND VPWR VPWR sky130_fd_sc_hd__decap_3
XTAP_TAPCELL_ROW_38_361 VGND VPWR sky130_fd_sc_hd__tapvpwrvgnd_1
XFILLER_43_314 VGND VGND VPWR VPWR sky130_fd_sc_hd__decap_3
XFILLER_28_377 VGND VGND VPWR VPWR sky130_fd_sc_hd__decap_3
XFILLER_55_196 VGND VGND VPWR VPWR sky130_fd_sc_hd__decap_3
XFILLER_43_358 VGND VGND VPWR VPWR sky130_fd_sc_hd__decap_3
XFILLER_34_21 VGND VGND VPWR VPWR sky130_fd_sc_hd__decap_3
XFILLER_34_32 VGND VGND VPWR VPWR sky130_fd_sc_hd__decap_3
XFILLER_51_391 VGND VGND VPWR VPWR sky130_fd_sc_hd__fill_1
XFILLER_34_65 VGND VGND VPWR VPWR sky130_fd_sc_hd__decap_3
XFILLER_50_53 VGND VGND VPWR VPWR sky130_fd_sc_hd__decap_3
XFILLER_50_97 VGND VGND VPWR VPWR sky130_fd_sc_hd__decap_3
XFILLER_59_51 VGND VGND VPWR VPWR sky130_fd_sc_hd__decap_3
XFILLER_59_84 VGND VGND VPWR VPWR sky130_fd_sc_hd__decap_3
XFILLER_22_9 VGND VGND VPWR VPWR sky130_fd_sc_hd__decap_3
XTAP_TAPCELL_ROW_6_1_189 VGND VPWR sky130_fd_sc_hd__tapvpwrvgnd_1
XFILLER_19_355 VGND VGND VPWR VPWR sky130_fd_sc_hd__decap_3
XFILLER_46_141 VGND VGND VPWR VPWR sky130_fd_sc_hd__decap_3
XFILLER_46_130 VGND VGND VPWR VPWR sky130_fd_sc_hd__decap_3
XFILLER_19_388 VGND VGND VPWR VPWR sky130_fd_sc_hd__decap_3
XFILLER_46_174 VGND VGND VPWR VPWR sky130_fd_sc_hd__decap_3
XFILLER_61_122 VGND VGND VPWR VPWR sky130_fd_sc_hd__decap_3
XFILLER_61_111 VGND VGND VPWR VPWR sky130_fd_sc_hd__fill_1
XFILLER_34_336 VGND VGND VPWR VPWR sky130_fd_sc_hd__decap_3
XFILLER_61_155 VGND VGND VPWR VPWR sky130_fd_sc_hd__decap_3
XFILLER_61_199 VGND VGND VPWR VPWR sky130_fd_sc_hd__decap_3
XFILLER_42_380 VGND VGND VPWR VPWR sky130_fd_sc_hd__decap_3
XFILLER_29_119 VGND VGND VPWR VPWR sky130_fd_sc_hd__decap_3
XFILLER_25_314 VGND VGND VPWR VPWR sky130_fd_sc_hd__decap_3
XFILLER_37_152 VGND VGND VPWR VPWR sky130_fd_sc_hd__decap_3
XFILLER_25_358 VGND VGND VPWR VPWR sky130_fd_sc_hd__decap_3
XFILLER_52_122 VGND VGND VPWR VPWR sky130_fd_sc_hd__decap_3
XFILLER_37_196 VGND VGND VPWR VPWR sky130_fd_sc_hd__decap_3
XTAP_TAPCELL_ROW_35_342 VGND VPWR sky130_fd_sc_hd__tapvpwrvgnd_1
XFILLER_52_177 VGND VGND VPWR VPWR sky130_fd_sc_hd__decap_3
XFILLER_52_144 VGND VGND VPWR VPWR sky130_fd_sc_hd__decap_3
XFILLER_40_339 VGND VGND VPWR VPWR sky130_fd_sc_hd__decap_3
XFILLER_33_391 VGND VGND VPWR VPWR sky130_fd_sc_hd__fill_1
XFILLER_20_12 VGND VGND VPWR VPWR sky130_fd_sc_hd__decap_3
XFILLER_20_56 VGND VGND VPWR VPWR sky130_fd_sc_hd__decap_3
XFILLER_29_87 VGND VGND VPWR VPWR sky130_fd_sc_hd__decap_3
XFILLER_28_141 VGND VGND VPWR VPWR sky130_fd_sc_hd__fill_1
XFILLER_28_174 VGND VGND VPWR VPWR sky130_fd_sc_hd__decap_3
XFILLER_43_122 VGND VGND VPWR VPWR sky130_fd_sc_hd__decap_3
XFILLER_16_369 VGND VGND VPWR VPWR sky130_fd_sc_hd__decap_3
XFILLER_45_97 VGND VGND VPWR VPWR sky130_fd_sc_hd__decap_3
XFILLER_43_155 VGND VGND VPWR VPWR sky130_fd_sc_hd__decap_3
XFILLER_31_317 VGND VGND VPWR VPWR sky130_fd_sc_hd__decap_3
XFILLER_24_380 VGND VGND VPWR VPWR sky130_fd_sc_hd__decap_3
XFILLER_43_199 VGND VGND VPWR VPWR sky130_fd_sc_hd__decap_3
XFILLER_61_30 VGND VGND VPWR VPWR sky130_fd_sc_hd__decap_3
XFILLER_61_63 VGND VGND VPWR VPWR sky130_fd_sc_hd__decap_3
XFILLER_61_96 VGND VGND VPWR VPWR sky130_fd_sc_hd__decap_3
XFILLER_6_47 VGND VGND VPWR VPWR sky130_fd_sc_hd__decap_3
XFILLER_20_6 VGND VGND VPWR VPWR sky130_fd_sc_hd__decap_3
XFILLER_19_152 VGND VGND VPWR VPWR sky130_fd_sc_hd__decap_3
XFILLER_34_100 VGND VGND VPWR VPWR sky130_fd_sc_hd__decap_3
XFILLER_34_133 VGND VGND VPWR VPWR sky130_fd_sc_hd__decap_3
XFILLER_34_144 VGND VGND VPWR VPWR sky130_fd_sc_hd__decap_3
XFILLER_22_339 VGND VGND VPWR VPWR sky130_fd_sc_hd__decap_3
XFILLER_34_177 VGND VGND VPWR VPWR sky130_fd_sc_hd__decap_3
XFILLER_15_391 VGND VGND VPWR VPWR sky130_fd_sc_hd__decap_3
XFILLER_30_383 VGND VGND VPWR VPWR sky130_fd_sc_hd__decap_3
XFILLER_57_225 VGND VGND VPWR VPWR sky130_fd_sc_hd__decap_3
XFILLER_57_214 VGND VGND VPWR VPWR sky130_fd_sc_hd__decap_3
XFILLER_57_258 VGND VGND VPWR VPWR sky130_fd_sc_hd__decap_3
XFILLER_25_100 VGND VGND VPWR VPWR sky130_fd_sc_hd__decap_3
XFILLER_25_122 VGND VGND VPWR VPWR sky130_fd_sc_hd__decap_3
XFILLER_15_12 VGND VGND VPWR VPWR sky130_fd_sc_hd__fill_2
XFILLER_25_155 VGND VGND VPWR VPWR sky130_fd_sc_hd__decap_3
XFILLER_13_328 VGND VGND VPWR VPWR sky130_fd_sc_hd__decap_3
XFILLER_25_199 VGND VGND VPWR VPWR sky130_fd_sc_hd__decap_3
XFILLER_15_78 VGND VGND VPWR VPWR sky130_fd_sc_hd__decap_3
XFILLER_40_147 VGND VGND VPWR VPWR sky130_fd_sc_hd__decap_3
XFILLER_40_136 VGND VGND VPWR VPWR sky130_fd_sc_hd__decap_3
XFILLER_21_361 VGND VGND VPWR VPWR sky130_fd_sc_hd__decap_3
XFILLER_21_383 VGND VGND VPWR VPWR sky130_fd_sc_hd__decap_3
XFILLER_31_44 VGND VGND VPWR VPWR sky130_fd_sc_hd__decap_3
XFILLER_31_66 VGND VGND VPWR VPWR sky130_fd_sc_hd__decap_3
XFILLER_31_99 VGND VGND VPWR VPWR sky130_fd_sc_hd__decap_3
Xoutput44 net44 VGND VGND VPWR VPWR s[14] sky130_fd_sc_hd__buf_2
Xoutput55 net55 VGND VGND VPWR VPWR tdo sky130_fd_sc_hd__buf_2
XFILLER_48_203 VGND VGND VPWR VPWR sky130_fd_sc_hd__decap_3
XFILLER_56_41 VGND VGND VPWR VPWR sky130_fd_sc_hd__decap_3
XFILLER_48_236 VGND VGND VPWR VPWR sky130_fd_sc_hd__decap_3
XFILLER_63_217 VGND VGND VPWR VPWR sky130_fd_sc_hd__decap_3
XFILLER_63_228 VGND VGND VPWR VPWR sky130_fd_sc_hd__decap_3
XTAP_TAPCELL_ROW_46_415 VGND VPWR sky130_fd_sc_hd__tapvpwrvgnd_1
XFILLER_56_74 VGND VGND VPWR VPWR sky130_fd_sc_hd__fill_1
XFILLER_16_122 VGND VGND VPWR VPWR sky130_fd_sc_hd__decap_3
XFILLER_56_85 VGND VGND VPWR VPWR sky130_fd_sc_hd__decap_3
XFILLER_56_280 VGND VGND VPWR VPWR sky130_fd_sc_hd__decap_3
XFILLER_16_144 VGND VGND VPWR VPWR sky130_fd_sc_hd__decap_3
XTAP_TAPCELL_ROW_0_1_555 VGND VPWR sky130_fd_sc_hd__tapvpwrvgnd_1
XFILLER_16_177 VGND VGND VPWR VPWR sky130_fd_sc_hd__decap_3
XTAP_TAPCELL_ROW_54_470 VGND VPWR sky130_fd_sc_hd__tapvpwrvgnd_1
XFILLER_31_125 VGND VGND VPWR VPWR sky130_fd_sc_hd__decap_3
XFILLER_31_158 VGND VGND VPWR VPWR sky130_fd_sc_hd__decap_3
XFILLER_12_372 VGND VGND VPWR VPWR sky130_fd_sc_hd__decap_3
XFILLER_31_169 VGND VGND VPWR VPWR sky130_fd_sc_hd__decap_3
XFILLER_8_343 VGND VGND VPWR VPWR sky130_fd_sc_hd__decap_3
XFILLER_8_354 VGND VGND VPWR VPWR sky130_fd_sc_hd__decap_3
XFILLER_8_387 VGND VGND VPWR VPWR sky130_fd_sc_hd__decap_3
XFILLER_39_225 VGND VGND VPWR VPWR sky130_fd_sc_hd__decap_3
XFILLER_39_214 VGND VGND VPWR VPWR sky130_fd_sc_hd__decap_3
XFILLER_39_258 VGND VGND VPWR VPWR sky130_fd_sc_hd__decap_3
XFILLER_54_206 VGND VGND VPWR VPWR sky130_fd_sc_hd__decap_3
XFILLER_54_239 VGND VGND VPWR VPWR sky130_fd_sc_hd__decap_3
XFILLER_22_103 VGND VGND VPWR VPWR sky130_fd_sc_hd__decap_3
XFILLER_62_283 VGND VGND VPWR VPWR sky130_fd_sc_hd__decap_3
XFILLER_50_401 VGND VGND VPWR VPWR sky130_fd_sc_hd__decap_3
XFILLER_22_136 VGND VGND VPWR VPWR sky130_fd_sc_hd__decap_3
XFILLER_22_147 VGND VGND VPWR VPWR sky130_fd_sc_hd__decap_3
XFILLER_30_180 VGND VGND VPWR VPWR sky130_fd_sc_hd__decap_3
XTAP_TAPCELL_ROW_1_1_172 VGND VPWR sky130_fd_sc_hd__tapvpwrvgnd_1
XFILLER_45_217 VGND VGND VPWR VPWR sky130_fd_sc_hd__decap_3
XFILLER_45_228 VGND VGND VPWR VPWR sky130_fd_sc_hd__decap_3
XFILLER_38_280 VGND VGND VPWR VPWR sky130_fd_sc_hd__decap_3
XFILLER_26_44 VGND VGND VPWR VPWR sky130_fd_sc_hd__decap_3
XFILLER_60_209 VGND VGND VPWR VPWR sky130_fd_sc_hd__decap_3
XFILLER_26_88 VGND VGND VPWR VPWR sky130_fd_sc_hd__decap_3
XFILLER_53_261 VGND VGND VPWR VPWR sky130_fd_sc_hd__decap_3
XFILLER_13_125 VGND VGND VPWR VPWR sky130_fd_sc_hd__decap_3
XFILLER_13_158 VGND VGND VPWR VPWR sky130_fd_sc_hd__decap_3
XFILLER_13_169 VGND VGND VPWR VPWR sky130_fd_sc_hd__decap_3
XTAP_TAPCELL_ROW_51_451 VGND VPWR sky130_fd_sc_hd__tapvpwrvgnd_1
X_291_ clknet_2_1__leaf_clk_regs net26 _036_ VGND VGND VPWR VPWR genblk1\[3\].fa_inst.b
+ sky130_fd_sc_hd__dfrtp_1
XFILLER_42_32 VGND VGND VPWR VPWR sky130_fd_sc_hd__decap_3
XFILLER_42_21 VGND VGND VPWR VPWR sky130_fd_sc_hd__decap_3
XFILLER_42_65 VGND VGND VPWR VPWR sky130_fd_sc_hd__decap_3
XFILLER_5_346 VGND VGND VPWR VPWR sky130_fd_sc_hd__decap_3
XFILLER_5_379 VGND VGND VPWR VPWR sky130_fd_sc_hd__fill_2
XFILLER_36_206 VGND VGND VPWR VPWR sky130_fd_sc_hd__decap_3
XFILLER_36_239 VGND VGND VPWR VPWR sky130_fd_sc_hd__decap_3
XFILLER_44_283 VGND VGND VPWR VPWR sky130_fd_sc_hd__decap_3
XFILLER_32_401 VGND VGND VPWR VPWR sky130_fd_sc_hd__decap_3
XFILLER_8_162 VGND VGND VPWR VPWR sky130_fd_sc_hd__decap_3
XFILLER_4_390 VGND VGND VPWR VPWR sky130_fd_sc_hd__decap_3
XFILLER_27_217 VGND VGND VPWR VPWR sky130_fd_sc_hd__decap_3
XFILLER_27_228 VGND VGND VPWR VPWR sky130_fd_sc_hd__decap_3
XFILLER_42_209 VGND VGND VPWR VPWR sky130_fd_sc_hd__decap_3
XFILLER_35_261 VGND VGND VPWR VPWR sky130_fd_sc_hd__decap_3
XFILLER_50_242 VGND VGND VPWR VPWR sky130_fd_sc_hd__decap_3
XFILLER_10_106 VGND VGND VPWR VPWR sky130_fd_sc_hd__decap_3
XFILLER_50_253 VGND VGND VPWR VPWR sky130_fd_sc_hd__decap_3
XFILLER_10_139 VGND VGND VPWR VPWR sky130_fd_sc_hd__fill_1
XFILLER_50_286 VGND VGND VPWR VPWR sky130_fd_sc_hd__decap_3
XFILLER_12_35 VGND VGND VPWR VPWR sky130_fd_sc_hd__decap_3
XFILLER_12_68 VGND VGND VPWR VPWR sky130_fd_sc_hd__decap_3
XFILLER_2_349 VGND VGND VPWR VPWR sky130_fd_sc_hd__decap_3
XFILLER_58_342 VGND VGND VPWR VPWR sky130_fd_sc_hd__decap_3
XFILLER_58_386 VGND VGND VPWR VPWR sky130_fd_sc_hd__decap_3
XFILLER_37_43 VGND VGND VPWR VPWR sky130_fd_sc_hd__decap_3
XFILLER_37_98 VGND VGND VPWR VPWR sky130_fd_sc_hd__decap_3
XTAP_TAPCELL_ROW_28_289 VGND VPWR sky130_fd_sc_hd__tapvpwrvgnd_1
XFILLER_26_283 VGND VGND VPWR VPWR sky130_fd_sc_hd__decap_3
XFILLER_41_231 VGND VGND VPWR VPWR sky130_fd_sc_hd__decap_3
XFILLER_41_220 VGND VGND VPWR VPWR sky130_fd_sc_hd__decap_3
XFILLER_53_75 VGND VGND VPWR VPWR sky130_fd_sc_hd__decap_3
XFILLER_41_264 VGND VGND VPWR VPWR sky130_fd_sc_hd__decap_3
X_274_ clknet_2_0__leaf_clk_regs net9 _019_ VGND VGND VPWR VPWR genblk1\[2\].fa_inst.a
+ sky130_fd_sc_hd__dfrtp_1
XFILLER_5_143 VGND VGND VPWR VPWR sky130_fd_sc_hd__decap_3
XFILLER_1_382 VGND VGND VPWR VPWR sky130_fd_sc_hd__decap_3
XFILLER_49_320 VGND VGND VPWR VPWR sky130_fd_sc_hd__decap_3
XFILLER_49_364 VGND VGND VPWR VPWR sky130_fd_sc_hd__decap_3
XFILLER_64_312 VGND VGND VPWR VPWR sky130_fd_sc_hd__fill_2
XFILLER_64_323 VGND VGND VPWR VPWR sky130_fd_sc_hd__decap_3
XFILLER_24_209 VGND VGND VPWR VPWR sky130_fd_sc_hd__decap_3
XFILLER_64_389 VGND VGND VPWR VPWR sky130_fd_sc_hd__decap_3
XFILLER_32_253 VGND VGND VPWR VPWR sky130_fd_sc_hd__decap_3
XFILLER_32_242 VGND VGND VPWR VPWR sky130_fd_sc_hd__decap_3
XFILLER_32_286 VGND VGND VPWR VPWR sky130_fd_sc_hd__decap_3
XFILLER_4_91 VGND VGND VPWR VPWR sky130_fd_sc_hd__decap_3
XFILLER_4_80 VGND VGND VPWR VPWR sky130_fd_sc_hd__decap_3
XFILLER_55_323 VGND VGND VPWR VPWR sky130_fd_sc_hd__decap_3
XFILLER_55_367 VGND VGND VPWR VPWR sky130_fd_sc_hd__decap_3
XFILLER_23_220 VGND VGND VPWR VPWR sky130_fd_sc_hd__decap_3
XFILLER_23_231 VGND VGND VPWR VPWR sky130_fd_sc_hd__decap_3
XFILLER_23_12 VGND VGND VPWR VPWR sky130_fd_sc_hd__decap_3
XFILLER_23_264 VGND VGND VPWR VPWR sky130_fd_sc_hd__decap_3
XFILLER_2_124 VGND VGND VPWR VPWR sky130_fd_sc_hd__decap_3
XFILLER_2_168 VGND VGND VPWR VPWR sky130_fd_sc_hd__decap_3
XFILLER_58_150 VGND VGND VPWR VPWR sky130_fd_sc_hd__decap_3
XFILLER_48_64 VGND VGND VPWR VPWR sky130_fd_sc_hd__fill_2
XFILLER_58_183 VGND VGND VPWR VPWR sky130_fd_sc_hd__decap_3
XFILLER_46_312 VGND VGND VPWR VPWR sky130_fd_sc_hd__decap_3
XFILLER_46_301 VGND VGND VPWR VPWR sky130_fd_sc_hd__decap_3
XFILLER_0_27 VGND VGND VPWR VPWR sky130_fd_sc_hd__fill_1
XFILLER_0_38 VGND VGND VPWR VPWR sky130_fd_sc_hd__decap_3
XFILLER_46_345 VGND VGND VPWR VPWR sky130_fd_sc_hd__decap_3
XFILLER_64_41 VGND VGND VPWR VPWR sky130_fd_sc_hd__decap_3
XFILLER_64_63 VGND VGND VPWR VPWR sky130_fd_sc_hd__decap_3
XFILLER_61_326 VGND VGND VPWR VPWR sky130_fd_sc_hd__decap_3
XFILLER_46_389 VGND VGND VPWR VPWR sky130_fd_sc_hd__decap_3
XFILLER_64_85 VGND VGND VPWR VPWR sky130_fd_sc_hd__decap_3
XFILLER_61_337 VGND VGND VPWR VPWR sky130_fd_sc_hd__decap_3
XFILLER_9_69 VGND VGND VPWR VPWR sky130_fd_sc_hd__decap_3
X_257_ clknet_2_0__leaf_clk_regs genblk1\[2\].fa_inst.s _002_ VGND VGND VPWR VPWR
+ net47 sky130_fd_sc_hd__dfrtp_1
X_188_ _093_ _096_ _094_ VGND VGND VPWR VPWR _100_ sky130_fd_sc_hd__a21bo_1
XFILLER_50_6 VGND VGND VPWR VPWR sky130_fd_sc_hd__decap_3
XFILLER_56_109 VGND VGND VPWR VPWR sky130_fd_sc_hd__decap_3
XFILLER_29_3 VGND VGND VPWR VPWR sky130_fd_sc_hd__decap_3
XFILLER_49_172 VGND VGND VPWR VPWR sky130_fd_sc_hd__decap_3
XFILLER_49_161 VGND VGND VPWR VPWR sky130_fd_sc_hd__decap_3
XFILLER_37_323 VGND VGND VPWR VPWR sky130_fd_sc_hd__decap_3
XFILLER_64_131 VGND VGND VPWR VPWR sky130_fd_sc_hd__decap_3
XFILLER_37_367 VGND VGND VPWR VPWR sky130_fd_sc_hd__decap_3
XFILLER_64_153 VGND VGND VPWR VPWR sky130_fd_sc_hd__decap_3
XFILLER_64_175 VGND VGND VPWR VPWR sky130_fd_sc_hd__decap_3
XFILLER_52_315 VGND VGND VPWR VPWR sky130_fd_sc_hd__decap_3
XFILLER_52_304 VGND VGND VPWR VPWR sky130_fd_sc_hd__decap_3
XFILLER_64_197 VGND VGND VPWR VPWR sky130_fd_sc_hd__decap_3
XFILLER_52_348 VGND VGND VPWR VPWR sky130_fd_sc_hd__decap_3
XFILLER_60_392 VGND VGND VPWR VPWR sky130_fd_sc_hd__decap_3
XFILLER_18_12 VGND VGND VPWR VPWR sky130_fd_sc_hd__decap_3
XFILLER_28_312 VGND VGND VPWR VPWR sky130_fd_sc_hd__decap_3
XFILLER_28_301 VGND VGND VPWR VPWR sky130_fd_sc_hd__decap_3
XFILLER_55_131 VGND VGND VPWR VPWR sky130_fd_sc_hd__decap_3
XFILLER_28_345 VGND VGND VPWR VPWR sky130_fd_sc_hd__decap_3
XTAP_TAPCELL_ROW_38_362 VGND VPWR sky130_fd_sc_hd__tapvpwrvgnd_1
XFILLER_55_175 VGND VGND VPWR VPWR sky130_fd_sc_hd__decap_3
XFILLER_55_164 VGND VGND VPWR VPWR sky130_fd_sc_hd__decap_3
XFILLER_43_326 VGND VGND VPWR VPWR sky130_fd_sc_hd__decap_3
XFILLER_28_389 VGND VGND VPWR VPWR sky130_fd_sc_hd__decap_3
XFILLER_43_337 VGND VGND VPWR VPWR sky130_fd_sc_hd__decap_3
XFILLER_34_44 VGND VGND VPWR VPWR sky130_fd_sc_hd__decap_3
XFILLER_51_370 VGND VGND VPWR VPWR sky130_fd_sc_hd__decap_3
XFILLER_34_88 VGND VGND VPWR VPWR sky130_fd_sc_hd__decap_3
XFILLER_34_77 VGND VGND VPWR VPWR sky130_fd_sc_hd__decap_3
XPHY_EDGE_ROW_14_2_Left_35 VGND VGND VPWR VPWR sky130_fd_sc_hd__decap_3
XTAP_TAPCELL_ROW_21_240 VGND VPWR sky130_fd_sc_hd__tapvpwrvgnd_1
XFILLER_50_32 VGND VGND VPWR VPWR sky130_fd_sc_hd__decap_3
XFILLER_50_21 VGND VGND VPWR VPWR sky130_fd_sc_hd__decap_3
XFILLER_50_65 VGND VGND VPWR VPWR sky130_fd_sc_hd__decap_3
XFILLER_3_400 VGND VGND VPWR VPWR sky130_fd_sc_hd__decap_3
XFILLER_59_30 VGND VGND VPWR VPWR sky130_fd_sc_hd__decap_3
XFILLER_59_63 VGND VGND VPWR VPWR sky130_fd_sc_hd__decap_3
XFILLER_59_96 VGND VGND VPWR VPWR sky130_fd_sc_hd__decap_3
XFILLER_38_109 VGND VGND VPWR VPWR sky130_fd_sc_hd__decap_3
XFILLER_15_9 VGND VGND VPWR VPWR sky130_fd_sc_hd__decap_3
XFILLER_19_334 VGND VGND VPWR VPWR sky130_fd_sc_hd__decap_3
XFILLER_19_367 VGND VGND VPWR VPWR sky130_fd_sc_hd__decap_3
XFILLER_46_153 VGND VGND VPWR VPWR sky130_fd_sc_hd__decap_3
XFILLER_34_315 VGND VGND VPWR VPWR sky130_fd_sc_hd__decap_3
XFILLER_34_304 VGND VGND VPWR VPWR sky130_fd_sc_hd__decap_3
XFILLER_61_134 VGND VGND VPWR VPWR sky130_fd_sc_hd__decap_3
XFILLER_46_197 VGND VGND VPWR VPWR sky130_fd_sc_hd__decap_3
XFILLER_46_186 VGND VGND VPWR VPWR sky130_fd_sc_hd__decap_3
XFILLER_34_348 VGND VGND VPWR VPWR sky130_fd_sc_hd__decap_3
XFILLER_61_178 VGND VGND VPWR VPWR sky130_fd_sc_hd__decap_3
XFILLER_61_167 VGND VGND VPWR VPWR sky130_fd_sc_hd__fill_1
XFILLER_42_392 VGND VGND VPWR VPWR sky130_fd_sc_hd__decap_3
XFILLER_29_109 VGND VGND VPWR VPWR sky130_fd_sc_hd__decap_3
XFILLER_37_131 VGND VGND VPWR VPWR sky130_fd_sc_hd__decap_3
XFILLER_1_81 VGND VGND VPWR VPWR sky130_fd_sc_hd__decap_3
XFILLER_37_175 VGND VGND VPWR VPWR sky130_fd_sc_hd__decap_3
XFILLER_37_164 VGND VGND VPWR VPWR sky130_fd_sc_hd__decap_3
XFILLER_25_326 VGND VGND VPWR VPWR sky130_fd_sc_hd__decap_3
XFILLER_25_337 VGND VGND VPWR VPWR sky130_fd_sc_hd__decap_3
XFILLER_52_134 VGND VGND VPWR VPWR sky130_fd_sc_hd__decap_3
XTAP_TAPCELL_ROW_35_343 VGND VPWR sky130_fd_sc_hd__tapvpwrvgnd_1
XFILLER_52_156 VGND VGND VPWR VPWR sky130_fd_sc_hd__decap_3
XFILLER_40_307 VGND VGND VPWR VPWR sky130_fd_sc_hd__fill_1
XFILLER_52_189 VGND VGND VPWR VPWR sky130_fd_sc_hd__decap_3
XFILLER_40_318 VGND VGND VPWR VPWR sky130_fd_sc_hd__decap_3
XFILLER_33_370 VGND VGND VPWR VPWR sky130_fd_sc_hd__decap_3
XFILLER_20_24 VGND VGND VPWR VPWR sky130_fd_sc_hd__decap_3
XFILLER_20_35 VGND VGND VPWR VPWR sky130_fd_sc_hd__decap_3
XFILLER_0_403 VGND VGND VPWR VPWR sky130_fd_sc_hd__decap_3
XFILLER_20_79 VGND VGND VPWR VPWR sky130_fd_sc_hd__decap_3
XFILLER_29_66 VGND VGND VPWR VPWR sky130_fd_sc_hd__decap_3
XFILLER_29_55 VGND VGND VPWR VPWR sky130_fd_sc_hd__fill_1
XFILLER_29_99 VGND VGND VPWR VPWR sky130_fd_sc_hd__fill_1
XFILLER_28_120 VGND VGND VPWR VPWR sky130_fd_sc_hd__decap_3
XFILLER_16_337 VGND VGND VPWR VPWR sky130_fd_sc_hd__decap_3
XFILLER_43_134 VGND VGND VPWR VPWR sky130_fd_sc_hd__decap_3
XFILLER_28_197 VGND VGND VPWR VPWR sky130_fd_sc_hd__decap_3
XFILLER_28_186 VGND VGND VPWR VPWR sky130_fd_sc_hd__decap_3
XFILLER_45_76 VGND VGND VPWR VPWR sky130_fd_sc_hd__decap_3
XFILLER_43_167 VGND VGND VPWR VPWR sky130_fd_sc_hd__fill_1
XFILLER_43_178 VGND VGND VPWR VPWR sky130_fd_sc_hd__decap_3
XFILLER_31_329 VGND VGND VPWR VPWR sky130_fd_sc_hd__decap_3
XFILLER_24_392 VGND VGND VPWR VPWR sky130_fd_sc_hd__decap_3
XFILLER_61_42 VGND VGND VPWR VPWR sky130_fd_sc_hd__decap_3
XTAP_TAPCELL_ROW_41_379 VGND VPWR sky130_fd_sc_hd__tapvpwrvgnd_1
XFILLER_61_75 VGND VGND VPWR VPWR sky130_fd_sc_hd__decap_3
XFILLER_6_15 VGND VGND VPWR VPWR sky130_fd_sc_hd__decap_3
XFILLER_6_59 VGND VGND VPWR VPWR sky130_fd_sc_hd__decap_3
XFILLER_13_6 VGND VGND VPWR VPWR sky130_fd_sc_hd__decap_3
XFILLER_19_131 VGND VGND VPWR VPWR sky130_fd_sc_hd__decap_3
XTAP_TAPCELL_ROW_49_435 VGND VPWR sky130_fd_sc_hd__tapvpwrvgnd_1
XFILLER_19_164 VGND VGND VPWR VPWR sky130_fd_sc_hd__decap_3
XFILLER_19_175 VGND VGND VPWR VPWR sky130_fd_sc_hd__decap_3
XFILLER_34_112 VGND VGND VPWR VPWR sky130_fd_sc_hd__decap_3
XFILLER_22_307 VGND VGND VPWR VPWR sky130_fd_sc_hd__fill_1
XFILLER_34_156 VGND VGND VPWR VPWR sky130_fd_sc_hd__decap_3
XFILLER_15_370 VGND VGND VPWR VPWR sky130_fd_sc_hd__decap_3
XFILLER_22_318 VGND VGND VPWR VPWR sky130_fd_sc_hd__decap_3
XFILLER_34_189 VGND VGND VPWR VPWR sky130_fd_sc_hd__decap_3
XFILLER_30_351 VGND VGND VPWR VPWR sky130_fd_sc_hd__decap_3
XFILLER_30_395 VGND VGND VPWR VPWR sky130_fd_sc_hd__decap_3
XFILLER_57_237 VGND VGND VPWR VPWR sky130_fd_sc_hd__decap_3
XFILLER_25_134 VGND VGND VPWR VPWR sky130_fd_sc_hd__decap_3
XFILLER_25_167 VGND VGND VPWR VPWR sky130_fd_sc_hd__fill_1
XFILLER_15_46 VGND VGND VPWR VPWR sky130_fd_sc_hd__decap_3
XFILLER_15_57 VGND VGND VPWR VPWR sky130_fd_sc_hd__decap_3
XFILLER_25_178 VGND VGND VPWR VPWR sky130_fd_sc_hd__decap_3
XFILLER_40_115 VGND VGND VPWR VPWR sky130_fd_sc_hd__decap_3
XFILLER_40_159 VGND VGND VPWR VPWR sky130_fd_sc_hd__decap_3
XFILLER_21_340 VGND VGND VPWR VPWR sky130_fd_sc_hd__decap_3
XFILLER_31_12 VGND VGND VPWR VPWR sky130_fd_sc_hd__decap_3
XFILLER_31_78 VGND VGND VPWR VPWR sky130_fd_sc_hd__decap_3
Xoutput45 net45 VGND VGND VPWR VPWR s[15] sky130_fd_sc_hd__buf_2
XFILLER_48_215 VGND VGND VPWR VPWR sky130_fd_sc_hd__decap_3
XFILLER_48_259 VGND VGND VPWR VPWR sky130_fd_sc_hd__decap_3
XFILLER_48_248 VGND VGND VPWR VPWR sky130_fd_sc_hd__decap_3
XFILLER_56_53 VGND VGND VPWR VPWR sky130_fd_sc_hd__decap_3
XTAP_TAPCELL_ROW_46_416 VGND VPWR sky130_fd_sc_hd__tapvpwrvgnd_1
XFILLER_56_97 VGND VGND VPWR VPWR sky130_fd_sc_hd__decap_3
XFILLER_56_292 VGND VGND VPWR VPWR sky130_fd_sc_hd__decap_3
XFILLER_16_134 VGND VGND VPWR VPWR sky130_fd_sc_hd__decap_3
XFILLER_16_156 VGND VGND VPWR VPWR sky130_fd_sc_hd__decap_3
XTAP_TAPCELL_ROW_0_1_556 VGND VPWR sky130_fd_sc_hd__tapvpwrvgnd_1
XTAP_TAPCELL_ROW_54_471 VGND VPWR sky130_fd_sc_hd__tapvpwrvgnd_1
XFILLER_31_137 VGND VGND VPWR VPWR sky130_fd_sc_hd__decap_3
XFILLER_12_340 VGND VGND VPWR VPWR sky130_fd_sc_hd__decap_3
XFILLER_12_384 VGND VGND VPWR VPWR sky130_fd_sc_hd__decap_3
XFILLER_8_366 VGND VGND VPWR VPWR sky130_fd_sc_hd__decap_3
XFILLER_8_399 VGND VGND VPWR VPWR sky130_fd_sc_hd__decap_3
XPHY_EDGE_ROW_28_Right_49 VGND VGND VPWR VPWR sky130_fd_sc_hd__decap_3
XFILLER_11_3 VGND VGND VPWR VPWR sky130_fd_sc_hd__decap_3
XFILLER_39_237 VGND VGND VPWR VPWR sky130_fd_sc_hd__decap_3
XFILLER_54_218 VGND VGND VPWR VPWR sky130_fd_sc_hd__decap_3
XPHY_EDGE_ROW_37_Right_58 VGND VGND VPWR VPWR sky130_fd_sc_hd__decap_3
XFILLER_47_281 VGND VGND VPWR VPWR sky130_fd_sc_hd__decap_3
XFILLER_47_270 VGND VGND VPWR VPWR sky130_fd_sc_hd__decap_3
XFILLER_62_251 VGND VGND VPWR VPWR sky130_fd_sc_hd__fill_1
XFILLER_22_115 VGND VGND VPWR VPWR sky130_fd_sc_hd__decap_3
XFILLER_62_262 VGND VGND VPWR VPWR sky130_fd_sc_hd__decap_3
XFILLER_62_295 VGND VGND VPWR VPWR sky130_fd_sc_hd__decap_3
XFILLER_22_159 VGND VGND VPWR VPWR sky130_fd_sc_hd__decap_3
XFILLER_30_192 VGND VGND VPWR VPWR sky130_fd_sc_hd__decap_3
XFILLER_7_91 VGND VGND VPWR VPWR sky130_fd_sc_hd__decap_3
XPHY_EDGE_ROW_46_Right_67 VGND VGND VPWR VPWR sky130_fd_sc_hd__decap_3
XTAP_TAPCELL_ROW_1_1_173 VGND VPWR sky130_fd_sc_hd__tapvpwrvgnd_1
XPHY_EDGE_ROW_55_Right_76 VGND VGND VPWR VPWR sky130_fd_sc_hd__decap_3
XFILLER_26_12 VGND VGND VPWR VPWR sky130_fd_sc_hd__decap_3
XFILLER_53_240 VGND VGND VPWR VPWR sky130_fd_sc_hd__decap_3
XFILLER_38_292 VGND VGND VPWR VPWR sky130_fd_sc_hd__decap_3
XFILLER_26_78 VGND VGND VPWR VPWR sky130_fd_sc_hd__decap_3
XFILLER_53_284 VGND VGND VPWR VPWR sky130_fd_sc_hd__decap_3
XFILLER_53_273 VGND VGND VPWR VPWR sky130_fd_sc_hd__decap_3
XFILLER_41_402 VGND VGND VPWR VPWR sky130_fd_sc_hd__fill_1
XFILLER_13_137 VGND VGND VPWR VPWR sky130_fd_sc_hd__decap_3
X_290_ clknet_2_1__leaf_clk_regs net25 _035_ VGND VGND VPWR VPWR genblk1\[2\].fa_inst.b
+ sky130_fd_sc_hd__dfrtp_1
XFILLER_9_108 VGND VGND VPWR VPWR sky130_fd_sc_hd__decap_3
XFILLER_9_119 VGND VGND VPWR VPWR sky130_fd_sc_hd__decap_3
XTAP_TAPCELL_ROW_51_452 VGND VPWR sky130_fd_sc_hd__tapvpwrvgnd_1
XFILLER_42_44 VGND VGND VPWR VPWR sky130_fd_sc_hd__decap_3
XFILLER_21_181 VGND VGND VPWR VPWR sky130_fd_sc_hd__decap_3
XFILLER_42_77 VGND VGND VPWR VPWR sky130_fd_sc_hd__decap_3
XPHY_EDGE_ROW_64_Right_85 VGND VGND VPWR VPWR sky130_fd_sc_hd__decap_3
XFILLER_42_88 VGND VGND VPWR VPWR sky130_fd_sc_hd__decap_3
XFILLER_5_358 VGND VGND VPWR VPWR sky130_fd_sc_hd__decap_3
XTAP_TAPCELL_ROW_20_1_229 VGND VPWR sky130_fd_sc_hd__tapvpwrvgnd_1
XFILLER_36_218 VGND VGND VPWR VPWR sky130_fd_sc_hd__decap_3
XFILLER_29_281 VGND VGND VPWR VPWR sky130_fd_sc_hd__decap_3
XFILLER_29_270 VGND VGND VPWR VPWR sky130_fd_sc_hd__decap_3
XFILLER_44_262 VGND VGND VPWR VPWR sky130_fd_sc_hd__decap_3
XFILLER_44_251 VGND VGND VPWR VPWR sky130_fd_sc_hd__fill_1
XFILLER_44_295 VGND VGND VPWR VPWR sky130_fd_sc_hd__decap_3
XFILLER_8_130 VGND VGND VPWR VPWR sky130_fd_sc_hd__decap_3
XFILLER_8_141 VGND VGND VPWR VPWR sky130_fd_sc_hd__decap_3
XFILLER_8_174 VGND VGND VPWR VPWR sky130_fd_sc_hd__decap_3
XFILLER_59_3 VGND VGND VPWR VPWR sky130_fd_sc_hd__decap_3
XFILLER_35_240 VGND VGND VPWR VPWR sky130_fd_sc_hd__decap_3
XFILLER_23_402 VGND VGND VPWR VPWR sky130_fd_sc_hd__decap_3
XFILLER_35_273 VGND VGND VPWR VPWR sky130_fd_sc_hd__decap_3
XFILLER_50_221 VGND VGND VPWR VPWR sky130_fd_sc_hd__decap_3
XFILLER_35_284 VGND VGND VPWR VPWR sky130_fd_sc_hd__decap_3
XFILLER_50_265 VGND VGND VPWR VPWR sky130_fd_sc_hd__decap_3
XFILLER_10_118 VGND VGND VPWR VPWR sky130_fd_sc_hd__decap_3
XFILLER_50_298 VGND VGND VPWR VPWR sky130_fd_sc_hd__decap_3
XFILLER_12_47 VGND VGND VPWR VPWR sky130_fd_sc_hd__decap_3
XFILLER_58_321 VGND VGND VPWR VPWR sky130_fd_sc_hd__decap_3
XFILLER_58_365 VGND VGND VPWR VPWR sky130_fd_sc_hd__decap_3
XFILLER_58_354 VGND VGND VPWR VPWR sky130_fd_sc_hd__decap_3
XFILLER_58_398 VGND VGND VPWR VPWR sky130_fd_sc_hd__decap_3
XFILLER_37_77 VGND VGND VPWR VPWR sky130_fd_sc_hd__decap_3
XFILLER_14_402 VGND VGND VPWR VPWR sky130_fd_sc_hd__decap_3
XFILLER_26_251 VGND VGND VPWR VPWR sky130_fd_sc_hd__fill_1
XFILLER_26_262 VGND VGND VPWR VPWR sky130_fd_sc_hd__decap_3
XFILLER_26_295 VGND VGND VPWR VPWR sky130_fd_sc_hd__decap_3
XFILLER_53_43 VGND VGND VPWR VPWR sky130_fd_sc_hd__decap_3
XFILLER_53_87 VGND VGND VPWR VPWR sky130_fd_sc_hd__decap_3
XFILLER_41_243 VGND VGND VPWR VPWR sky130_fd_sc_hd__decap_3
X_273_ clknet_2_1__leaf_clk_regs net8 _018_ VGND VGND VPWR VPWR genblk1\[1\].fa_inst.a
+ sky130_fd_sc_hd__dfrtp_1
XFILLER_41_287 VGND VGND VPWR VPWR sky130_fd_sc_hd__decap_3
XFILLER_41_276 VGND VGND VPWR VPWR sky130_fd_sc_hd__decap_3
XFILLER_5_122 VGND VGND VPWR VPWR sky130_fd_sc_hd__decap_3
XFILLER_5_100 VGND VGND VPWR VPWR sky130_fd_sc_hd__decap_3
XFILLER_5_155 VGND VGND VPWR VPWR sky130_fd_sc_hd__decap_3
XFILLER_45_9 VGND VGND VPWR VPWR sky130_fd_sc_hd__decap_3
XFILLER_1_361 VGND VGND VPWR VPWR sky130_fd_sc_hd__decap_3
XFILLER_1_394 VGND VGND VPWR VPWR sky130_fd_sc_hd__decap_3
XFILLER_49_332 VGND VGND VPWR VPWR sky130_fd_sc_hd__decap_3
XFILLER_49_343 VGND VGND VPWR VPWR sky130_fd_sc_hd__decap_3
XFILLER_64_302 VGND VGND VPWR VPWR sky130_fd_sc_hd__decap_3
XFILLER_64_335 VGND VGND VPWR VPWR sky130_fd_sc_hd__fill_1
XFILLER_49_376 VGND VGND VPWR VPWR sky130_fd_sc_hd__decap_3
XFILLER_64_346 VGND VGND VPWR VPWR sky130_fd_sc_hd__decap_3
XFILLER_64_368 VGND VGND VPWR VPWR sky130_fd_sc_hd__decap_3
XFILLER_32_221 VGND VGND VPWR VPWR sky130_fd_sc_hd__decap_3
XFILLER_20_405 VGND VGND VPWR VPWR sky130_fd_sc_hd__fill_2
XFILLER_32_265 VGND VGND VPWR VPWR sky130_fd_sc_hd__decap_3
XFILLER_32_298 VGND VGND VPWR VPWR sky130_fd_sc_hd__decap_3
XFILLER_59_129 VGND VGND VPWR VPWR sky130_fd_sc_hd__decap_3
XFILLER_55_302 VGND VGND VPWR VPWR sky130_fd_sc_hd__decap_3
XFILLER_55_346 VGND VGND VPWR VPWR sky130_fd_sc_hd__decap_3
XFILLER_55_335 VGND VGND VPWR VPWR sky130_fd_sc_hd__fill_1
XFILLER_55_379 VGND VGND VPWR VPWR sky130_fd_sc_hd__decap_3
XFILLER_23_243 VGND VGND VPWR VPWR sky130_fd_sc_hd__decap_3
XFILLER_23_276 VGND VGND VPWR VPWR sky130_fd_sc_hd__decap_3
XFILLER_23_287 VGND VGND VPWR VPWR sky130_fd_sc_hd__decap_3
XFILLER_23_57 VGND VGND VPWR VPWR sky130_fd_sc_hd__decap_3
XFILLER_2_103 VGND VGND VPWR VPWR sky130_fd_sc_hd__decap_3
XFILLER_2_147 VGND VGND VPWR VPWR sky130_fd_sc_hd__decap_3
XFILLER_2_136 VGND VGND VPWR VPWR sky130_fd_sc_hd__decap_3
XPHY_EDGE_ROW_2_1_Right_1 VGND VGND VPWR VPWR sky130_fd_sc_hd__decap_3
XFILLER_48_21 VGND VGND VPWR VPWR sky130_fd_sc_hd__decap_3
XFILLER_58_162 VGND VGND VPWR VPWR sky130_fd_sc_hd__decap_3
XFILLER_46_324 VGND VGND VPWR VPWR sky130_fd_sc_hd__decap_3
XFILLER_64_20 VGND VGND VPWR VPWR sky130_fd_sc_hd__decap_3
XFILLER_58_195 VGND VGND VPWR VPWR sky130_fd_sc_hd__fill_1
XFILLER_46_357 VGND VGND VPWR VPWR sky130_fd_sc_hd__decap_3
XFILLER_64_53 VGND VGND VPWR VPWR sky130_fd_sc_hd__decap_3
XFILLER_61_305 VGND VGND VPWR VPWR sky130_fd_sc_hd__decap_3
XFILLER_46_368 VGND VGND VPWR VPWR sky130_fd_sc_hd__decap_3
XFILLER_64_75 VGND VGND VPWR VPWR sky130_fd_sc_hd__decap_3
XFILLER_64_97 VGND VGND VPWR VPWR sky130_fd_sc_hd__decap_3
XFILLER_61_349 VGND VGND VPWR VPWR sky130_fd_sc_hd__decap_3
XFILLER_9_37 VGND VGND VPWR VPWR sky130_fd_sc_hd__decap_3
XTAP_TAPCELL_ROW_24_260 VGND VPWR sky130_fd_sc_hd__tapvpwrvgnd_1
X_256_ clknet_2_0__leaf_clk_regs genblk1\[1\].fa_inst.s _001_ VGND VGND VPWR VPWR
+ net46 sky130_fd_sc_hd__dfrtp_1
XFILLER_13_90 VGND VGND VPWR VPWR sky130_fd_sc_hd__fill_2
X_187_ _097_ _098_ VGND VGND VPWR VPWR _099_ sky130_fd_sc_hd__nand2_1
XFILLER_43_6 VGND VGND VPWR VPWR sky130_fd_sc_hd__decap_3
XFILLER_49_140 VGND VGND VPWR VPWR sky130_fd_sc_hd__decap_3
XFILLER_49_184 VGND VGND VPWR VPWR sky130_fd_sc_hd__decap_3
XFILLER_37_302 VGND VGND VPWR VPWR sky130_fd_sc_hd__decap_3
XFILLER_37_346 VGND VGND VPWR VPWR sky130_fd_sc_hd__decap_3
XFILLER_37_335 VGND VGND VPWR VPWR sky130_fd_sc_hd__fill_1
XFILLER_64_165 VGND VGND VPWR VPWR sky130_fd_sc_hd__decap_3
XFILLER_37_379 VGND VGND VPWR VPWR sky130_fd_sc_hd__decap_3
XFILLER_64_187 VGND VGND VPWR VPWR sky130_fd_sc_hd__decap_3
XFILLER_52_327 VGND VGND VPWR VPWR sky130_fd_sc_hd__decap_3
XFILLER_60_371 VGND VGND VPWR VPWR sky130_fd_sc_hd__decap_3
XFILLER_60_360 VGND VGND VPWR VPWR sky130_fd_sc_hd__decap_3
XPHY_EDGE_ROW_9_2_Right_95 VGND VGND VPWR VPWR sky130_fd_sc_hd__decap_3
XFILLER_18_24 VGND VGND VPWR VPWR sky130_fd_sc_hd__decap_3
XFILLER_18_35 VGND VGND VPWR VPWR sky130_fd_sc_hd__decap_3
XFILLER_28_324 VGND VGND VPWR VPWR sky130_fd_sc_hd__decap_3
XFILLER_18_57 VGND VGND VPWR VPWR sky130_fd_sc_hd__decap_3
XFILLER_18_68 VGND VGND VPWR VPWR sky130_fd_sc_hd__decap_3
XFILLER_55_143 VGND VGND VPWR VPWR sky130_fd_sc_hd__decap_3
XFILLER_28_357 VGND VGND VPWR VPWR sky130_fd_sc_hd__decap_3
XTAP_TAPCELL_ROW_38_363 VGND VPWR sky130_fd_sc_hd__tapvpwrvgnd_1
XFILLER_43_305 VGND VGND VPWR VPWR sky130_fd_sc_hd__decap_3
XFILLER_28_368 VGND VGND VPWR VPWR sky130_fd_sc_hd__decap_3
XFILLER_55_187 VGND VGND VPWR VPWR sky130_fd_sc_hd__decap_3
XFILLER_43_349 VGND VGND VPWR VPWR sky130_fd_sc_hd__decap_3
XFILLER_34_12 VGND VGND VPWR VPWR sky130_fd_sc_hd__decap_3
XFILLER_51_382 VGND VGND VPWR VPWR sky130_fd_sc_hd__decap_3
XFILLER_34_56 VGND VGND VPWR VPWR sky130_fd_sc_hd__decap_3
XFILLER_51_393 VGND VGND VPWR VPWR sky130_fd_sc_hd__decap_3
XTAP_TAPCELL_ROW_21_241 VGND VPWR sky130_fd_sc_hd__tapvpwrvgnd_1
Xclkload0 clknet_2_0__leaf_clk_regs VGND VGND VPWR VPWR clkload0/Y sky130_fd_sc_hd__bufinv_16
XFILLER_50_44 VGND VGND VPWR VPWR sky130_fd_sc_hd__decap_3
XFILLER_50_88 VGND VGND VPWR VPWR sky130_fd_sc_hd__decap_3
XFILLER_50_77 VGND VGND VPWR VPWR sky130_fd_sc_hd__decap_3
XFILLER_59_42 VGND VGND VPWR VPWR sky130_fd_sc_hd__decap_3
XFILLER_59_75 VGND VGND VPWR VPWR sky130_fd_sc_hd__decap_3
XFILLER_19_346 VGND VGND VPWR VPWR sky130_fd_sc_hd__decap_3
XFILLER_46_121 VGND VGND VPWR VPWR sky130_fd_sc_hd__decap_3
XFILLER_19_379 VGND VGND VPWR VPWR sky130_fd_sc_hd__fill_2
XFILLER_46_165 VGND VGND VPWR VPWR sky130_fd_sc_hd__decap_3
XFILLER_61_113 VGND VGND VPWR VPWR sky130_fd_sc_hd__decap_3
XFILLER_61_102 VGND VGND VPWR VPWR sky130_fd_sc_hd__decap_3
XFILLER_34_327 VGND VGND VPWR VPWR sky130_fd_sc_hd__decap_3
XFILLER_61_146 VGND VGND VPWR VPWR sky130_fd_sc_hd__decap_3
XFILLER_42_371 VGND VGND VPWR VPWR sky130_fd_sc_hd__decap_3
XFILLER_42_360 VGND VGND VPWR VPWR sky130_fd_sc_hd__decap_3
X_239_ net56 VGND VGND VPWR VPWR _034_ sky130_fd_sc_hd__inv_2
XFILLER_41_3 VGND VGND VPWR VPWR sky130_fd_sc_hd__decap_3
XFILLER_37_110 VGND VGND VPWR VPWR sky130_fd_sc_hd__fill_2
XFILLER_1_60 VGND VGND VPWR VPWR sky130_fd_sc_hd__decap_3
XFILLER_25_305 VGND VGND VPWR VPWR sky130_fd_sc_hd__decap_3
XFILLER_37_143 VGND VGND VPWR VPWR sky130_fd_sc_hd__decap_3
XFILLER_1_93 VGND VGND VPWR VPWR sky130_fd_sc_hd__decap_3
XFILLER_25_349 VGND VGND VPWR VPWR sky130_fd_sc_hd__decap_3
XFILLER_37_187 VGND VGND VPWR VPWR sky130_fd_sc_hd__decap_3
XFILLER_18_390 VGND VGND VPWR VPWR sky130_fd_sc_hd__decap_3
XFILLER_52_168 VGND VGND VPWR VPWR sky130_fd_sc_hd__decap_3
XFILLER_33_382 VGND VGND VPWR VPWR sky130_fd_sc_hd__decap_3
XFILLER_33_393 VGND VGND VPWR VPWR sky130_fd_sc_hd__decap_3
XFILLER_20_47 VGND VGND VPWR VPWR sky130_fd_sc_hd__decap_3
XFILLER_29_12 VGND VGND VPWR VPWR sky130_fd_sc_hd__decap_3
XFILLER_29_78 VGND VGND VPWR VPWR sky130_fd_sc_hd__decap_3
XFILLER_29_45 VGND VGND VPWR VPWR sky130_fd_sc_hd__decap_3
XFILLER_28_132 VGND VGND VPWR VPWR sky130_fd_sc_hd__decap_3
XFILLER_28_165 VGND VGND VPWR VPWR sky130_fd_sc_hd__decap_3
XFILLER_16_349 VGND VGND VPWR VPWR sky130_fd_sc_hd__decap_3
XTAP_TAPCELL_ROW_2_1_175 VGND VPWR sky130_fd_sc_hd__tapvpwrvgnd_1
XFILLER_45_44 VGND VGND VPWR VPWR sky130_fd_sc_hd__decap_3
XFILLER_43_113 VGND VGND VPWR VPWR sky130_fd_sc_hd__decap_3
XFILLER_45_88 VGND VGND VPWR VPWR sky130_fd_sc_hd__decap_3
XFILLER_43_146 VGND VGND VPWR VPWR sky130_fd_sc_hd__decap_3
XFILLER_31_308 VGND VGND VPWR VPWR sky130_fd_sc_hd__decap_3
XFILLER_24_360 VGND VGND VPWR VPWR sky130_fd_sc_hd__decap_3
XFILLER_24_371 VGND VGND VPWR VPWR sky130_fd_sc_hd__decap_3
XFILLER_61_21 VGND VGND VPWR VPWR sky130_fd_sc_hd__decap_3
XFILLER_51_190 VGND VGND VPWR VPWR sky130_fd_sc_hd__decap_3
XFILLER_61_54 VGND VGND VPWR VPWR sky130_fd_sc_hd__fill_2
XFILLER_61_87 VGND VGND VPWR VPWR sky130_fd_sc_hd__decap_3
XFILLER_6_27 VGND VGND VPWR VPWR sky130_fd_sc_hd__fill_1
XFILLER_6_38 VGND VGND VPWR VPWR sky130_fd_sc_hd__decap_3
XFILLER_10_80 VGND VGND VPWR VPWR sky130_fd_sc_hd__decap_3
XFILLER_10_91 VGND VGND VPWR VPWR sky130_fd_sc_hd__decap_3
XTAP_TAPCELL_ROW_49_436 VGND VPWR sky130_fd_sc_hd__tapvpwrvgnd_1
XFILLER_59_290 VGND VGND VPWR VPWR sky130_fd_sc_hd__decap_3
XFILLER_19_143 VGND VGND VPWR VPWR sky130_fd_sc_hd__decap_3
XFILLER_34_124 VGND VGND VPWR VPWR sky130_fd_sc_hd__decap_3
XTAP_TAPCELL_ROW_57_491 VGND VPWR sky130_fd_sc_hd__tapvpwrvgnd_1
XFILLER_34_168 VGND VGND VPWR VPWR sky130_fd_sc_hd__decap_3
XFILLER_15_382 VGND VGND VPWR VPWR sky130_fd_sc_hd__decap_3
XFILLER_30_330 VGND VGND VPWR VPWR sky130_fd_sc_hd__decap_3
XFILLER_30_363 VGND VGND VPWR VPWR sky130_fd_sc_hd__fill_1
XPHY_EDGE_ROW_8_2_Left_29 VGND VGND VPWR VPWR sky130_fd_sc_hd__decap_3
XFILLER_30_374 VGND VGND VPWR VPWR sky130_fd_sc_hd__decap_3
XFILLER_57_205 VGND VGND VPWR VPWR sky130_fd_sc_hd__decap_3
XFILLER_57_249 VGND VGND VPWR VPWR sky130_fd_sc_hd__decap_3
XFILLER_25_113 VGND VGND VPWR VPWR sky130_fd_sc_hd__decap_3
XFILLER_25_146 VGND VGND VPWR VPWR sky130_fd_sc_hd__decap_3
XFILLER_15_69 VGND VGND VPWR VPWR sky130_fd_sc_hd__decap_3
XFILLER_21_330 VGND VGND VPWR VPWR sky130_fd_sc_hd__decap_3
XFILLER_40_127 VGND VGND VPWR VPWR sky130_fd_sc_hd__decap_3
XFILLER_33_190 VGND VGND VPWR VPWR sky130_fd_sc_hd__decap_3
XFILLER_21_352 VGND VGND VPWR VPWR sky130_fd_sc_hd__decap_3
XFILLER_21_374 VGND VGND VPWR VPWR sky130_fd_sc_hd__decap_3
XFILLER_21_396 VGND VGND VPWR VPWR sky130_fd_sc_hd__decap_3
XFILLER_31_57 VGND VGND VPWR VPWR sky130_fd_sc_hd__decap_3
Xoutput46 net46 VGND VGND VPWR VPWR s[1] sky130_fd_sc_hd__buf_2
XFILLER_56_32 VGND VGND VPWR VPWR sky130_fd_sc_hd__decap_3
XFILLER_56_21 VGND VGND VPWR VPWR sky130_fd_sc_hd__decap_3
XFILLER_48_227 VGND VGND VPWR VPWR sky130_fd_sc_hd__decap_3
XFILLER_63_208 VGND VGND VPWR VPWR sky130_fd_sc_hd__decap_3
XFILLER_56_65 VGND VGND VPWR VPWR sky130_fd_sc_hd__decap_3
XFILLER_16_113 VGND VGND VPWR VPWR sky130_fd_sc_hd__decap_3
XTAP_TAPCELL_ROW_46_417 VGND VPWR sky130_fd_sc_hd__tapvpwrvgnd_1
XFILLER_56_271 VGND VGND VPWR VPWR sky130_fd_sc_hd__decap_3
XTAP_TAPCELL_ROW_0_1_557 VGND VPWR sky130_fd_sc_hd__tapvpwrvgnd_1
XFILLER_16_168 VGND VGND VPWR VPWR sky130_fd_sc_hd__decap_3
XTAP_TAPCELL_ROW_54_472 VGND VPWR sky130_fd_sc_hd__tapvpwrvgnd_1
XFILLER_31_116 VGND VGND VPWR VPWR sky130_fd_sc_hd__decap_3
XFILLER_31_105 VGND VGND VPWR VPWR sky130_fd_sc_hd__decap_3
XFILLER_31_149 VGND VGND VPWR VPWR sky130_fd_sc_hd__decap_3
XFILLER_12_352 VGND VGND VPWR VPWR sky130_fd_sc_hd__fill_1
XFILLER_12_363 VGND VGND VPWR VPWR sky130_fd_sc_hd__decap_3
XFILLER_12_396 VGND VGND VPWR VPWR sky130_fd_sc_hd__decap_3
XFILLER_8_334 VGND VGND VPWR VPWR sky130_fd_sc_hd__decap_3
XFILLER_8_378 VGND VGND VPWR VPWR sky130_fd_sc_hd__decap_3
XFILLER_39_205 VGND VGND VPWR VPWR sky130_fd_sc_hd__decap_3
XFILLER_39_249 VGND VGND VPWR VPWR sky130_fd_sc_hd__decap_3
XFILLER_62_230 VGND VGND VPWR VPWR sky130_fd_sc_hd__decap_3
XFILLER_47_293 VGND VGND VPWR VPWR sky130_fd_sc_hd__decap_3
XFILLER_62_274 VGND VGND VPWR VPWR sky130_fd_sc_hd__decap_3
XFILLER_22_127 VGND VGND VPWR VPWR sky130_fd_sc_hd__decap_3
XFILLER_30_171 VGND VGND VPWR VPWR sky130_fd_sc_hd__decap_3
XFILLER_7_70 VGND VGND VPWR VPWR sky130_fd_sc_hd__fill_1
XTAP_TAPCELL_ROW_1_1_174 VGND VPWR sky130_fd_sc_hd__tapvpwrvgnd_1
XFILLER_45_208 VGND VGND VPWR VPWR sky130_fd_sc_hd__decap_3
XFILLER_26_24 VGND VGND VPWR VPWR sky130_fd_sc_hd__decap_3
XFILLER_38_271 VGND VGND VPWR VPWR sky130_fd_sc_hd__decap_3
XFILLER_26_35 VGND VGND VPWR VPWR sky130_fd_sc_hd__decap_3
XFILLER_53_252 VGND VGND VPWR VPWR sky130_fd_sc_hd__decap_3
XFILLER_13_116 VGND VGND VPWR VPWR sky130_fd_sc_hd__decap_3
XFILLER_13_149 VGND VGND VPWR VPWR sky130_fd_sc_hd__decap_3
XFILLER_53_296 VGND VGND VPWR VPWR sky130_fd_sc_hd__decap_3
XTAP_TAPCELL_ROW_51_453 VGND VPWR sky130_fd_sc_hd__tapvpwrvgnd_1
XFILLER_42_12 VGND VGND VPWR VPWR sky130_fd_sc_hd__decap_3
XFILLER_42_56 VGND VGND VPWR VPWR sky130_fd_sc_hd__decap_3
XFILLER_21_193 VGND VGND VPWR VPWR sky130_fd_sc_hd__decap_3
XFILLER_5_337 VGND VGND VPWR VPWR sky130_fd_sc_hd__decap_3
XFILLER_17_400 VGND VGND VPWR VPWR sky130_fd_sc_hd__decap_3
XFILLER_44_230 VGND VGND VPWR VPWR sky130_fd_sc_hd__decap_3
XFILLER_29_293 VGND VGND VPWR VPWR sky130_fd_sc_hd__decap_3
XFILLER_44_274 VGND VGND VPWR VPWR sky130_fd_sc_hd__decap_3
XFILLER_12_171 VGND VGND VPWR VPWR sky130_fd_sc_hd__decap_3
XFILLER_8_153 VGND VGND VPWR VPWR sky130_fd_sc_hd__decap_3
XPHY_EDGE_ROW_26_Left_132 VGND VGND VPWR VPWR sky130_fd_sc_hd__decap_3
XFILLER_4_381 VGND VGND VPWR VPWR sky130_fd_sc_hd__decap_3
XFILLER_27_208 VGND VGND VPWR VPWR sky130_fd_sc_hd__decap_3
XPHY_EDGE_ROW_35_Left_141 VGND VGND VPWR VPWR sky130_fd_sc_hd__decap_3
XFILLER_50_200 VGND VGND VPWR VPWR sky130_fd_sc_hd__decap_3
XFILLER_35_252 VGND VGND VPWR VPWR sky130_fd_sc_hd__decap_3
XFILLER_50_233 VGND VGND VPWR VPWR sky130_fd_sc_hd__decap_3
XFILLER_35_296 VGND VGND VPWR VPWR sky130_fd_sc_hd__decap_3
XFILLER_50_277 VGND VGND VPWR VPWR sky130_fd_sc_hd__decap_3
XFILLER_12_59 VGND VGND VPWR VPWR sky130_fd_sc_hd__decap_3
XPHY_EDGE_ROW_44_Left_150 VGND VGND VPWR VPWR sky130_fd_sc_hd__decap_3
XFILLER_5_9 VGND VGND VPWR VPWR sky130_fd_sc_hd__fill_1
XFILLER_58_333 VGND VGND VPWR VPWR sky130_fd_sc_hd__decap_3
XFILLER_37_12 VGND VGND VPWR VPWR sky130_fd_sc_hd__decap_3
XFILLER_58_377 VGND VGND VPWR VPWR sky130_fd_sc_hd__decap_3
XFILLER_26_230 VGND VGND VPWR VPWR sky130_fd_sc_hd__decap_3
XFILLER_37_89 VGND VGND VPWR VPWR sky130_fd_sc_hd__decap_3
XFILLER_26_274 VGND VGND VPWR VPWR sky130_fd_sc_hd__decap_3
XFILLER_41_211 VGND VGND VPWR VPWR sky130_fd_sc_hd__decap_3
XFILLER_53_66 VGND VGND VPWR VPWR sky130_fd_sc_hd__decap_3
XFILLER_53_55 VGND VGND VPWR VPWR sky130_fd_sc_hd__fill_1
XFILLER_41_255 VGND VGND VPWR VPWR sky130_fd_sc_hd__decap_3
X_272_ clknet_2_0__leaf_clk_regs net1 _017_ VGND VGND VPWR VPWR genblk1\[0\].fa_inst.a
+ sky130_fd_sc_hd__dfrtp_1
XFILLER_53_99 VGND VGND VPWR VPWR sky130_fd_sc_hd__decap_3
XFILLER_41_299 VGND VGND VPWR VPWR sky130_fd_sc_hd__decap_3
XFILLER_5_134 VGND VGND VPWR VPWR sky130_fd_sc_hd__decap_3
XFILLER_5_167 VGND VGND VPWR VPWR sky130_fd_sc_hd__fill_1
XFILLER_1_340 VGND VGND VPWR VPWR sky130_fd_sc_hd__decap_3
XFILLER_38_9 VGND VGND VPWR VPWR sky130_fd_sc_hd__decap_3
XFILLER_1_373 VGND VGND VPWR VPWR sky130_fd_sc_hd__decap_3
XFILLER_49_311 VGND VGND VPWR VPWR sky130_fd_sc_hd__decap_3
XFILLER_49_355 VGND VGND VPWR VPWR sky130_fd_sc_hd__decap_3
XFILLER_49_399 VGND VGND VPWR VPWR sky130_fd_sc_hd__fill_2
XFILLER_49_388 VGND VGND VPWR VPWR sky130_fd_sc_hd__decap_3
XFILLER_64_358 VGND VGND VPWR VPWR sky130_fd_sc_hd__decap_3
XTAP_TAPCELL_ROW_62_526 VGND VPWR sky130_fd_sc_hd__tapvpwrvgnd_1
XFILLER_32_200 VGND VGND VPWR VPWR sky130_fd_sc_hd__decap_3
XFILLER_32_233 VGND VGND VPWR VPWR sky130_fd_sc_hd__decap_3
XFILLER_32_277 VGND VGND VPWR VPWR sky130_fd_sc_hd__decap_3
XFILLER_59_108 VGND VGND VPWR VPWR sky130_fd_sc_hd__decap_3
XFILLER_4_71 VGND VGND VPWR VPWR sky130_fd_sc_hd__decap_3
XFILLER_55_314 VGND VGND VPWR VPWR sky130_fd_sc_hd__decap_3
XFILLER_55_358 VGND VGND VPWR VPWR sky130_fd_sc_hd__decap_3
XFILLER_23_211 VGND VGND VPWR VPWR sky130_fd_sc_hd__decap_3
XFILLER_63_391 VGND VGND VPWR VPWR sky130_fd_sc_hd__fill_1
XFILLER_11_406 VGND VGND VPWR VPWR sky130_fd_sc_hd__fill_1
XFILLER_23_255 VGND VGND VPWR VPWR sky130_fd_sc_hd__decap_3
XFILLER_23_299 VGND VGND VPWR VPWR sky130_fd_sc_hd__decap_3
XFILLER_23_69 VGND VGND VPWR VPWR sky130_fd_sc_hd__decap_3
XFILLER_3_6 VGND VGND VPWR VPWR sky130_fd_sc_hd__decap_3
XFILLER_2_115 VGND VGND VPWR VPWR sky130_fd_sc_hd__decap_3
XFILLER_2_159 VGND VGND VPWR VPWR sky130_fd_sc_hd__decap_3
XFILLER_58_141 VGND VGND VPWR VPWR sky130_fd_sc_hd__decap_3
XFILLER_58_174 VGND VGND VPWR VPWR sky130_fd_sc_hd__decap_3
XFILLER_48_88 VGND VGND VPWR VPWR sky130_fd_sc_hd__decap_3
XFILLER_48_77 VGND VGND VPWR VPWR sky130_fd_sc_hd__decap_3
XFILLER_0_18 VGND VGND VPWR VPWR sky130_fd_sc_hd__decap_3
XFILLER_0_29 VGND VGND VPWR VPWR sky130_fd_sc_hd__decap_3
XFILLER_46_336 VGND VGND VPWR VPWR sky130_fd_sc_hd__decap_3
XFILLER_64_32 VGND VGND VPWR VPWR sky130_fd_sc_hd__decap_3
XFILLER_61_317 VGND VGND VPWR VPWR sky130_fd_sc_hd__decap_3
XFILLER_54_380 VGND VGND VPWR VPWR sky130_fd_sc_hd__decap_3
XFILLER_9_49 VGND VGND VPWR VPWR sky130_fd_sc_hd__decap_3
XTAP_TAPCELL_ROW_24_261 VGND VPWR sky130_fd_sc_hd__tapvpwrvgnd_1
X_255_ clknet_2_0__leaf_clk_regs genblk1\[0\].fa_inst.s _000_ VGND VGND VPWR VPWR
+ net39 sky130_fd_sc_hd__dfrtp_1
X_186_ genblk1\[12\].fa_inst.b genblk1\[12\].fa_inst.a VGND VGND VPWR VPWR _098_ sky130_fd_sc_hd__nand2_1
XFILLER_36_6 VGND VGND VPWR VPWR sky130_fd_sc_hd__decap_3
XFILLER_64_100 VGND VGND VPWR VPWR sky130_fd_sc_hd__decap_3
XFILLER_49_152 VGND VGND VPWR VPWR sky130_fd_sc_hd__decap_3
XFILLER_37_314 VGND VGND VPWR VPWR sky130_fd_sc_hd__decap_3
XFILLER_64_122 VGND VGND VPWR VPWR sky130_fd_sc_hd__decap_3
XFILLER_49_196 VGND VGND VPWR VPWR sky130_fd_sc_hd__decap_3
XFILLER_37_358 VGND VGND VPWR VPWR sky130_fd_sc_hd__decap_3
XFILLER_64_144 VGND VGND VPWR VPWR sky130_fd_sc_hd__decap_3
XFILLER_52_339 VGND VGND VPWR VPWR sky130_fd_sc_hd__decap_3
XFILLER_45_391 VGND VGND VPWR VPWR sky130_fd_sc_hd__fill_1
XFILLER_60_383 VGND VGND VPWR VPWR sky130_fd_sc_hd__decap_3
XFILLER_18_47 VGND VGND VPWR VPWR sky130_fd_sc_hd__fill_2
XFILLER_55_122 VGND VGND VPWR VPWR sky130_fd_sc_hd__decap_3
XFILLER_28_336 VGND VGND VPWR VPWR sky130_fd_sc_hd__decap_3
XTAP_TAPCELL_ROW_38_364 VGND VPWR sky130_fd_sc_hd__tapvpwrvgnd_1
XFILLER_55_155 VGND VGND VPWR VPWR sky130_fd_sc_hd__decap_3
XFILLER_43_317 VGND VGND VPWR VPWR sky130_fd_sc_hd__decap_3
XFILLER_55_199 VGND VGND VPWR VPWR sky130_fd_sc_hd__decap_3
XFILLER_36_380 VGND VGND VPWR VPWR sky130_fd_sc_hd__decap_3
XFILLER_34_35 VGND VGND VPWR VPWR sky130_fd_sc_hd__decap_3
XFILLER_34_24 VGND VGND VPWR VPWR sky130_fd_sc_hd__decap_3
XFILLER_51_361 VGND VGND VPWR VPWR sky130_fd_sc_hd__decap_3
XFILLER_34_68 VGND VGND VPWR VPWR sky130_fd_sc_hd__decap_3
XTAP_TAPCELL_ROW_21_242 VGND VPWR sky130_fd_sc_hd__tapvpwrvgnd_1
Xclkload1 clknet_2_2__leaf_clk_regs VGND VGND VPWR VPWR clkload1/Y sky130_fd_sc_hd__clkinvlp_4
XFILLER_50_12 VGND VGND VPWR VPWR sky130_fd_sc_hd__decap_3
XFILLER_50_56 VGND VGND VPWR VPWR sky130_fd_sc_hd__decap_3
XFILLER_1_3 VGND VGND VPWR VPWR sky130_fd_sc_hd__decap_3
XFILLER_59_21 VGND VGND VPWR VPWR sky130_fd_sc_hd__decap_3
XFILLER_59_54 VGND VGND VPWR VPWR sky130_fd_sc_hd__fill_2
XFILLER_59_87 VGND VGND VPWR VPWR sky130_fd_sc_hd__decap_3
XFILLER_46_100 VGND VGND VPWR VPWR sky130_fd_sc_hd__decap_3
XFILLER_46_133 VGND VGND VPWR VPWR sky130_fd_sc_hd__decap_3
XFILLER_19_358 VGND VGND VPWR VPWR sky130_fd_sc_hd__decap_3
XFILLER_46_144 VGND VGND VPWR VPWR sky130_fd_sc_hd__decap_3
XFILLER_61_125 VGND VGND VPWR VPWR sky130_fd_sc_hd__decap_3
XFILLER_46_177 VGND VGND VPWR VPWR sky130_fd_sc_hd__decap_3
XFILLER_34_339 VGND VGND VPWR VPWR sky130_fd_sc_hd__decap_3
XFILLER_27_391 VGND VGND VPWR VPWR sky130_fd_sc_hd__fill_1
XFILLER_61_169 VGND VGND VPWR VPWR sky130_fd_sc_hd__decap_3
XFILLER_61_158 VGND VGND VPWR VPWR sky130_fd_sc_hd__decap_3
XFILLER_42_383 VGND VGND VPWR VPWR sky130_fd_sc_hd__decap_3
X_238_ net56 VGND VGND VPWR VPWR _033_ sky130_fd_sc_hd__inv_2
X_169_ _083_ _084_ VGND VGND VPWR VPWR genblk1\[8\].fa_inst.s sky130_fd_sc_hd__xnor2_1
XFILLER_37_122 VGND VGND VPWR VPWR sky130_fd_sc_hd__decap_3
XFILLER_1_72 VGND VGND VPWR VPWR sky130_fd_sc_hd__decap_3
XFILLER_37_155 VGND VGND VPWR VPWR sky130_fd_sc_hd__decap_3
XFILLER_25_317 VGND VGND VPWR VPWR sky130_fd_sc_hd__decap_3
XFILLER_52_125 VGND VGND VPWR VPWR sky130_fd_sc_hd__decap_3
XFILLER_37_199 VGND VGND VPWR VPWR sky130_fd_sc_hd__decap_3
XFILLER_52_147 VGND VGND VPWR VPWR sky130_fd_sc_hd__decap_3
XFILLER_40_309 VGND VGND VPWR VPWR sky130_fd_sc_hd__decap_3
XFILLER_33_361 VGND VGND VPWR VPWR sky130_fd_sc_hd__decap_3
XFILLER_60_180 VGND VGND VPWR VPWR sky130_fd_sc_hd__decap_3
XFILLER_20_15 VGND VGND VPWR VPWR sky130_fd_sc_hd__decap_3
XFILLER_20_59 VGND VGND VPWR VPWR sky130_fd_sc_hd__decap_3
XFILLER_28_111 VGND VGND VPWR VPWR sky130_fd_sc_hd__decap_3
XFILLER_45_12 VGND VGND VPWR VPWR sky130_fd_sc_hd__decap_3
XFILLER_16_328 VGND VGND VPWR VPWR sky130_fd_sc_hd__decap_3
XTAP_TAPCELL_ROW_2_1_176 VGND VPWR sky130_fd_sc_hd__tapvpwrvgnd_1
XFILLER_43_125 VGND VGND VPWR VPWR sky130_fd_sc_hd__decap_3
XFILLER_28_177 VGND VGND VPWR VPWR sky130_fd_sc_hd__decap_3
XFILLER_43_158 VGND VGND VPWR VPWR sky130_fd_sc_hd__decap_3
XFILLER_43_169 VGND VGND VPWR VPWR sky130_fd_sc_hd__decap_3
XFILLER_24_383 VGND VGND VPWR VPWR sky130_fd_sc_hd__decap_3
XFILLER_61_33 VGND VGND VPWR VPWR sky130_fd_sc_hd__decap_3
XFILLER_61_66 VGND VGND VPWR VPWR sky130_fd_sc_hd__decap_3
XFILLER_61_99 VGND VGND VPWR VPWR sky130_fd_sc_hd__decap_3
XFILLER_20_9 VGND VGND VPWR VPWR sky130_fd_sc_hd__decap_3
XFILLER_19_122 VGND VGND VPWR VPWR sky130_fd_sc_hd__decap_3
XTAP_TAPCELL_ROW_49_437 VGND VPWR sky130_fd_sc_hd__tapvpwrvgnd_1
XFILLER_19_155 VGND VGND VPWR VPWR sky130_fd_sc_hd__decap_3
XFILLER_19_90 VGND VGND VPWR VPWR sky130_fd_sc_hd__fill_2
XFILLER_62_401 VGND VGND VPWR VPWR sky130_fd_sc_hd__decap_3
XFILLER_34_103 VGND VGND VPWR VPWR sky130_fd_sc_hd__decap_3
XTAP_TAPCELL_ROW_57_492 VGND VPWR sky130_fd_sc_hd__tapvpwrvgnd_1
XFILLER_34_147 VGND VGND VPWR VPWR sky130_fd_sc_hd__decap_3
XFILLER_34_136 VGND VGND VPWR VPWR sky130_fd_sc_hd__decap_3
XFILLER_15_361 VGND VGND VPWR VPWR sky130_fd_sc_hd__decap_3
XFILLER_22_309 VGND VGND VPWR VPWR sky130_fd_sc_hd__decap_3
XFILLER_15_394 VGND VGND VPWR VPWR sky130_fd_sc_hd__decap_3
XFILLER_42_180 VGND VGND VPWR VPWR sky130_fd_sc_hd__decap_3
XFILLER_30_342 VGND VGND VPWR VPWR sky130_fd_sc_hd__decap_3
XFILLER_30_386 VGND VGND VPWR VPWR sky130_fd_sc_hd__decap_3
XFILLER_57_217 VGND VGND VPWR VPWR sky130_fd_sc_hd__decap_3
XFILLER_57_228 VGND VGND VPWR VPWR sky130_fd_sc_hd__decap_3
XFILLER_25_103 VGND VGND VPWR VPWR sky130_fd_sc_hd__decap_3
XFILLER_25_125 VGND VGND VPWR VPWR sky130_fd_sc_hd__decap_3
XFILLER_25_158 VGND VGND VPWR VPWR sky130_fd_sc_hd__decap_3
XFILLER_15_37 VGND VGND VPWR VPWR sky130_fd_sc_hd__decap_3
XFILLER_25_169 VGND VGND VPWR VPWR sky130_fd_sc_hd__decap_3
XFILLER_40_139 VGND VGND VPWR VPWR sky130_fd_sc_hd__fill_1
XFILLER_21_386 VGND VGND VPWR VPWR sky130_fd_sc_hd__decap_3
XFILLER_31_47 VGND VGND VPWR VPWR sky130_fd_sc_hd__decap_3
XFILLER_31_69 VGND VGND VPWR VPWR sky130_fd_sc_hd__decap_3
Xoutput47 net47 VGND VGND VPWR VPWR s[2] sky130_fd_sc_hd__buf_2
XFILLER_48_206 VGND VGND VPWR VPWR sky130_fd_sc_hd__decap_3
XFILLER_48_239 VGND VGND VPWR VPWR sky130_fd_sc_hd__decap_3
XFILLER_56_44 VGND VGND VPWR VPWR sky130_fd_sc_hd__decap_3
XTAP_TAPCELL_ROW_46_418 VGND VPWR sky130_fd_sc_hd__tapvpwrvgnd_1
XFILLER_56_88 VGND VGND VPWR VPWR sky130_fd_sc_hd__decap_3
XFILLER_56_283 VGND VGND VPWR VPWR sky130_fd_sc_hd__decap_3
XFILLER_44_401 VGND VGND VPWR VPWR sky130_fd_sc_hd__decap_3
XFILLER_16_125 VGND VGND VPWR VPWR sky130_fd_sc_hd__decap_3
XFILLER_16_147 VGND VGND VPWR VPWR sky130_fd_sc_hd__decap_3
XTAP_TAPCELL_ROW_0_1_558 VGND VPWR sky130_fd_sc_hd__tapvpwrvgnd_1
XFILLER_24_180 VGND VGND VPWR VPWR sky130_fd_sc_hd__decap_3
XTAP_TAPCELL_ROW_54_473 VGND VPWR sky130_fd_sc_hd__tapvpwrvgnd_1
XFILLER_31_128 VGND VGND VPWR VPWR sky130_fd_sc_hd__decap_3
XFILLER_12_331 VGND VGND VPWR VPWR sky130_fd_sc_hd__decap_3
XFILLER_12_375 VGND VGND VPWR VPWR sky130_fd_sc_hd__decap_3
XFILLER_8_346 VGND VGND VPWR VPWR sky130_fd_sc_hd__decap_3
XFILLER_8_357 VGND VGND VPWR VPWR sky130_fd_sc_hd__decap_3
XFILLER_21_80 VGND VGND VPWR VPWR sky130_fd_sc_hd__decap_3
XFILLER_39_228 VGND VGND VPWR VPWR sky130_fd_sc_hd__decap_3
XFILLER_39_217 VGND VGND VPWR VPWR sky130_fd_sc_hd__decap_3
XFILLER_54_209 VGND VGND VPWR VPWR sky130_fd_sc_hd__decap_3
XFILLER_47_261 VGND VGND VPWR VPWR sky130_fd_sc_hd__decap_3
XFILLER_62_242 VGND VGND VPWR VPWR sky130_fd_sc_hd__decap_3
XFILLER_22_106 VGND VGND VPWR VPWR sky130_fd_sc_hd__decap_3
XFILLER_62_253 VGND VGND VPWR VPWR sky130_fd_sc_hd__decap_3
XFILLER_50_404 VGND VGND VPWR VPWR sky130_fd_sc_hd__decap_3
XFILLER_22_139 VGND VGND VPWR VPWR sky130_fd_sc_hd__fill_1
XFILLER_62_286 VGND VGND VPWR VPWR sky130_fd_sc_hd__decap_3
XFILLER_30_150 VGND VGND VPWR VPWR sky130_fd_sc_hd__decap_3
XFILLER_30_183 VGND VGND VPWR VPWR sky130_fd_sc_hd__decap_3
XFILLER_7_60 VGND VGND VPWR VPWR sky130_fd_sc_hd__fill_2
XFILLER_7_82 VGND VGND VPWR VPWR sky130_fd_sc_hd__decap_3
XFILLER_26_401 VGND VGND VPWR VPWR sky130_fd_sc_hd__decap_3
XFILLER_26_47 VGND VGND VPWR VPWR sky130_fd_sc_hd__decap_3
XFILLER_53_231 VGND VGND VPWR VPWR sky130_fd_sc_hd__decap_3
XFILLER_53_220 VGND VGND VPWR VPWR sky130_fd_sc_hd__decap_3
XFILLER_38_283 VGND VGND VPWR VPWR sky130_fd_sc_hd__decap_3
XFILLER_26_58 VGND VGND VPWR VPWR sky130_fd_sc_hd__decap_3
XFILLER_26_69 VGND VGND VPWR VPWR sky130_fd_sc_hd__decap_3
XFILLER_53_264 VGND VGND VPWR VPWR sky130_fd_sc_hd__decap_3
XFILLER_13_128 VGND VGND VPWR VPWR sky130_fd_sc_hd__decap_3
XTAP_TAPCELL_ROW_51_454 VGND VPWR sky130_fd_sc_hd__tapvpwrvgnd_1
XFILLER_42_35 VGND VGND VPWR VPWR sky130_fd_sc_hd__decap_3
XFILLER_42_24 VGND VGND VPWR VPWR sky130_fd_sc_hd__decap_3
XFILLER_21_150 VGND VGND VPWR VPWR sky130_fd_sc_hd__decap_3
XFILLER_21_172 VGND VGND VPWR VPWR sky130_fd_sc_hd__decap_3
XFILLER_42_68 VGND VGND VPWR VPWR sky130_fd_sc_hd__decap_3
XFILLER_5_349 VGND VGND VPWR VPWR sky130_fd_sc_hd__decap_3
XTAP_TAPCELL_ROW_59_510 VGND VPWR sky130_fd_sc_hd__tapvpwrvgnd_1
XFILLER_36_209 VGND VGND VPWR VPWR sky130_fd_sc_hd__decap_3
XFILLER_29_261 VGND VGND VPWR VPWR sky130_fd_sc_hd__decap_3
XFILLER_44_253 VGND VGND VPWR VPWR sky130_fd_sc_hd__decap_3
XFILLER_44_242 VGND VGND VPWR VPWR sky130_fd_sc_hd__decap_3
XFILLER_32_404 VGND VGND VPWR VPWR sky130_fd_sc_hd__decap_3
XFILLER_16_80 VGND VGND VPWR VPWR sky130_fd_sc_hd__decap_3
XFILLER_44_286 VGND VGND VPWR VPWR sky130_fd_sc_hd__decap_3
XFILLER_12_150 VGND VGND VPWR VPWR sky130_fd_sc_hd__decap_3
XFILLER_8_121 VGND VGND VPWR VPWR sky130_fd_sc_hd__decap_3
XFILLER_8_165 VGND VGND VPWR VPWR sky130_fd_sc_hd__decap_3
XFILLER_4_360 VGND VGND VPWR VPWR sky130_fd_sc_hd__decap_3
XFILLER_4_393 VGND VGND VPWR VPWR sky130_fd_sc_hd__decap_3
XFILLER_35_231 VGND VGND VPWR VPWR sky130_fd_sc_hd__decap_3
XFILLER_35_220 VGND VGND VPWR VPWR sky130_fd_sc_hd__decap_3
XFILLER_35_264 VGND VGND VPWR VPWR sky130_fd_sc_hd__decap_3
XFILLER_50_212 VGND VGND VPWR VPWR sky130_fd_sc_hd__decap_3
XFILLER_50_256 VGND VGND VPWR VPWR sky130_fd_sc_hd__decap_3
XFILLER_50_245 VGND VGND VPWR VPWR sky130_fd_sc_hd__decap_3
XFILLER_10_109 VGND VGND VPWR VPWR sky130_fd_sc_hd__decap_3
XFILLER_50_289 VGND VGND VPWR VPWR sky130_fd_sc_hd__decap_3
XFILLER_12_38 VGND VGND VPWR VPWR sky130_fd_sc_hd__decap_3
XFILLER_58_312 VGND VGND VPWR VPWR sky130_fd_sc_hd__decap_3
XFILLER_58_301 VGND VGND VPWR VPWR sky130_fd_sc_hd__decap_3
XFILLER_58_345 VGND VGND VPWR VPWR sky130_fd_sc_hd__decap_3
XFILLER_58_389 VGND VGND VPWR VPWR sky130_fd_sc_hd__decap_3
XFILLER_37_46 VGND VGND VPWR VPWR sky130_fd_sc_hd__decap_3
XFILLER_26_242 VGND VGND VPWR VPWR sky130_fd_sc_hd__decap_3
XFILLER_26_253 VGND VGND VPWR VPWR sky130_fd_sc_hd__decap_3
XFILLER_26_286 VGND VGND VPWR VPWR sky130_fd_sc_hd__decap_3
XFILLER_53_12 VGND VGND VPWR VPWR sky130_fd_sc_hd__decap_3
XFILLER_41_223 VGND VGND VPWR VPWR sky130_fd_sc_hd__fill_1
XFILLER_53_78 VGND VGND VPWR VPWR sky130_fd_sc_hd__decap_3
XFILLER_41_234 VGND VGND VPWR VPWR sky130_fd_sc_hd__decap_3
X_271_ clknet_2_3__leaf_clk_regs cout_next _016_ VGND VGND VPWR VPWR net38 sky130_fd_sc_hd__dfrtp_1
XFILLER_41_267 VGND VGND VPWR VPWR sky130_fd_sc_hd__decap_3
XFILLER_5_113 VGND VGND VPWR VPWR sky130_fd_sc_hd__decap_3
XFILLER_5_146 VGND VGND VPWR VPWR sky130_fd_sc_hd__decap_3
XFILLER_1_352 VGND VGND VPWR VPWR sky130_fd_sc_hd__decap_3
XFILLER_1_385 VGND VGND VPWR VPWR sky130_fd_sc_hd__decap_3
XFILLER_49_323 VGND VGND VPWR VPWR sky130_fd_sc_hd__decap_3
XFILLER_64_326 VGND VGND VPWR VPWR sky130_fd_sc_hd__decap_3
XFILLER_49_367 VGND VGND VPWR VPWR sky130_fd_sc_hd__decap_3
XFILLER_64_337 VGND VGND VPWR VPWR sky130_fd_sc_hd__decap_3
XFILLER_27_90 VGND VGND VPWR VPWR sky130_fd_sc_hd__decap_3
XTAP_TAPCELL_ROW_62_527 VGND VPWR sky130_fd_sc_hd__tapvpwrvgnd_1
XFILLER_32_212 VGND VGND VPWR VPWR sky130_fd_sc_hd__decap_3
XTAP_TAPCELL_ROW_27_281 VGND VPWR sky130_fd_sc_hd__tapvpwrvgnd_1
XFILLER_32_256 VGND VGND VPWR VPWR sky130_fd_sc_hd__decap_3
XFILLER_32_245 VGND VGND VPWR VPWR sky130_fd_sc_hd__decap_3
XFILLER_32_289 VGND VGND VPWR VPWR sky130_fd_sc_hd__decap_3
XFILLER_4_50 VGND VGND VPWR VPWR sky130_fd_sc_hd__decap_3
XFILLER_4_94 VGND VGND VPWR VPWR sky130_fd_sc_hd__decap_3
XFILLER_4_83 VGND VGND VPWR VPWR sky130_fd_sc_hd__fill_1
XFILLER_55_337 VGND VGND VPWR VPWR sky130_fd_sc_hd__decap_3
XFILLER_55_326 VGND VGND VPWR VPWR sky130_fd_sc_hd__decap_3
XFILLER_23_223 VGND VGND VPWR VPWR sky130_fd_sc_hd__fill_1
XFILLER_63_370 VGND VGND VPWR VPWR sky130_fd_sc_hd__decap_3
XFILLER_23_234 VGND VGND VPWR VPWR sky130_fd_sc_hd__decap_3
XFILLER_23_15 VGND VGND VPWR VPWR sky130_fd_sc_hd__fill_1
XFILLER_23_267 VGND VGND VPWR VPWR sky130_fd_sc_hd__decap_3
XFILLER_2_127 VGND VGND VPWR VPWR sky130_fd_sc_hd__decap_3
XFILLER_48_12 VGND VGND VPWR VPWR sky130_fd_sc_hd__decap_3
XFILLER_58_131 VGND VGND VPWR VPWR sky130_fd_sc_hd__decap_3
XFILLER_58_153 VGND VGND VPWR VPWR sky130_fd_sc_hd__decap_3
XFILLER_46_315 VGND VGND VPWR VPWR sky130_fd_sc_hd__decap_3
XFILLER_46_304 VGND VGND VPWR VPWR sky130_fd_sc_hd__decap_3
XFILLER_64_11 VGND VGND VPWR VPWR sky130_fd_sc_hd__decap_3
XFILLER_58_197 VGND VGND VPWR VPWR sky130_fd_sc_hd__decap_3
XFILLER_58_186 VGND VGND VPWR VPWR sky130_fd_sc_hd__decap_3
XFILLER_46_348 VGND VGND VPWR VPWR sky130_fd_sc_hd__decap_3
XFILLER_64_44 VGND VGND VPWR VPWR sky130_fd_sc_hd__decap_3
XFILLER_64_66 VGND VGND VPWR VPWR sky130_fd_sc_hd__decap_3
XFILLER_64_88 VGND VGND VPWR VPWR sky130_fd_sc_hd__decap_3
XFILLER_61_329 VGND VGND VPWR VPWR sky130_fd_sc_hd__decap_3
XFILLER_54_392 VGND VGND VPWR VPWR sky130_fd_sc_hd__decap_3
XTAP_TAPCELL_ROW_24_262 VGND VPWR sky130_fd_sc_hd__tapvpwrvgnd_1
Xfanout60 net61 VGND VGND VPWR VPWR net60 sky130_fd_sc_hd__buf_4
X_254_ net56 VGND VGND VPWR VPWR _049_ sky130_fd_sc_hd__inv_2
XFILLER_13_81 VGND VGND VPWR VPWR sky130_fd_sc_hd__decap_3
X_185_ genblk1\[12\].fa_inst.b genblk1\[12\].fa_inst.a VGND VGND VPWR VPWR _097_ sky130_fd_sc_hd__or2_1
XTAP_TAPCELL_ROW_3_1_178 VGND VPWR sky130_fd_sc_hd__tapvpwrvgnd_1
XFILLER_50_9 VGND VGND VPWR VPWR sky130_fd_sc_hd__decap_3
XPHY_EDGE_ROW_19_1_Right_18 VGND VGND VPWR VPWR sky130_fd_sc_hd__decap_3
XPHY_EDGE_ROW_63_Left_169 VGND VGND VPWR VPWR sky130_fd_sc_hd__decap_3
XFILLER_49_131 VGND VGND VPWR VPWR sky130_fd_sc_hd__decap_3
XFILLER_29_6 VGND VGND VPWR VPWR sky130_fd_sc_hd__decap_3
XFILLER_49_175 VGND VGND VPWR VPWR sky130_fd_sc_hd__decap_3
XFILLER_49_164 VGND VGND VPWR VPWR sky130_fd_sc_hd__decap_3
XFILLER_64_134 VGND VGND VPWR VPWR sky130_fd_sc_hd__decap_3
XFILLER_37_337 VGND VGND VPWR VPWR sky130_fd_sc_hd__decap_3
XFILLER_37_326 VGND VGND VPWR VPWR sky130_fd_sc_hd__decap_3
XFILLER_64_156 VGND VGND VPWR VPWR sky130_fd_sc_hd__decap_3
XFILLER_52_307 VGND VGND VPWR VPWR sky130_fd_sc_hd__fill_1
XFILLER_64_178 VGND VGND VPWR VPWR sky130_fd_sc_hd__decap_3
XFILLER_52_318 VGND VGND VPWR VPWR sky130_fd_sc_hd__decap_3
XFILLER_45_370 VGND VGND VPWR VPWR sky130_fd_sc_hd__decap_3
XFILLER_60_351 VGND VGND VPWR VPWR sky130_fd_sc_hd__decap_3
XFILLER_60_395 VGND VGND VPWR VPWR sky130_fd_sc_hd__decap_3
XFILLER_18_15 VGND VGND VPWR VPWR sky130_fd_sc_hd__decap_3
XFILLER_28_315 VGND VGND VPWR VPWR sky130_fd_sc_hd__decap_3
XFILLER_28_304 VGND VGND VPWR VPWR sky130_fd_sc_hd__decap_3
XFILLER_55_134 VGND VGND VPWR VPWR sky130_fd_sc_hd__decap_3
XFILLER_28_348 VGND VGND VPWR VPWR sky130_fd_sc_hd__decap_3
XFILLER_55_167 VGND VGND VPWR VPWR sky130_fd_sc_hd__fill_1
XFILLER_55_178 VGND VGND VPWR VPWR sky130_fd_sc_hd__decap_3
XFILLER_43_329 VGND VGND VPWR VPWR sky130_fd_sc_hd__decap_3
XFILLER_51_340 VGND VGND VPWR VPWR sky130_fd_sc_hd__decap_3
XFILLER_36_392 VGND VGND VPWR VPWR sky130_fd_sc_hd__decap_3
XFILLER_51_373 VGND VGND VPWR VPWR sky130_fd_sc_hd__decap_3
XFILLER_34_47 VGND VGND VPWR VPWR sky130_fd_sc_hd__decap_3
XTAP_TAPCELL_ROW_21_232 VGND VPWR sky130_fd_sc_hd__tapvpwrvgnd_1
XTAP_TAPCELL_ROW_21_243 VGND VPWR sky130_fd_sc_hd__tapvpwrvgnd_1
Xclkload2 clknet_2_3__leaf_clk_regs VGND VGND VPWR VPWR clkload2/X sky130_fd_sc_hd__clkbuf_4
XFILLER_50_24 VGND VGND VPWR VPWR sky130_fd_sc_hd__decap_3
XFILLER_50_35 VGND VGND VPWR VPWR sky130_fd_sc_hd__decap_3
XFILLER_50_68 VGND VGND VPWR VPWR sky130_fd_sc_hd__decap_3
XFILLER_3_403 VGND VGND VPWR VPWR sky130_fd_sc_hd__decap_3
XFILLER_59_33 VGND VGND VPWR VPWR sky130_fd_sc_hd__decap_3
XFILLER_59_66 VGND VGND VPWR VPWR sky130_fd_sc_hd__decap_3
XFILLER_59_99 VGND VGND VPWR VPWR sky130_fd_sc_hd__decap_3
XFILLER_19_337 VGND VGND VPWR VPWR sky130_fd_sc_hd__decap_3
XFILLER_46_112 VGND VGND VPWR VPWR sky130_fd_sc_hd__decap_3
XFILLER_46_156 VGND VGND VPWR VPWR sky130_fd_sc_hd__decap_3
XFILLER_34_307 VGND VGND VPWR VPWR sky130_fd_sc_hd__fill_1
XFILLER_27_370 VGND VGND VPWR VPWR sky130_fd_sc_hd__decap_3
XFILLER_46_189 VGND VGND VPWR VPWR sky130_fd_sc_hd__decap_3
XFILLER_34_318 VGND VGND VPWR VPWR sky130_fd_sc_hd__decap_3
XFILLER_61_137 VGND VGND VPWR VPWR sky130_fd_sc_hd__decap_3
XFILLER_42_351 VGND VGND VPWR VPWR sky130_fd_sc_hd__decap_3
XFILLER_42_395 VGND VGND VPWR VPWR sky130_fd_sc_hd__decap_3
XFILLER_24_80 VGND VGND VPWR VPWR sky130_fd_sc_hd__decap_3
X_237_ net60 VGND VGND VPWR VPWR _032_ sky130_fd_sc_hd__inv_2
X_168_ _077_ _080_ _078_ VGND VGND VPWR VPWR _084_ sky130_fd_sc_hd__a21bo_1
XFILLER_27_3 VGND VGND VPWR VPWR sky130_fd_sc_hd__decap_3
XFILLER_37_101 VGND VGND VPWR VPWR sky130_fd_sc_hd__decap_3
XFILLER_1_51 VGND VGND VPWR VPWR sky130_fd_sc_hd__decap_3
XFILLER_37_134 VGND VGND VPWR VPWR sky130_fd_sc_hd__decap_3
XFILLER_1_84 VGND VGND VPWR VPWR sky130_fd_sc_hd__decap_3
XFILLER_25_329 VGND VGND VPWR VPWR sky130_fd_sc_hd__decap_3
XFILLER_37_178 VGND VGND VPWR VPWR sky130_fd_sc_hd__decap_3
XFILLER_37_167 VGND VGND VPWR VPWR sky130_fd_sc_hd__fill_1
XFILLER_18_381 VGND VGND VPWR VPWR sky130_fd_sc_hd__decap_3
XFILLER_52_159 VGND VGND VPWR VPWR sky130_fd_sc_hd__decap_3
XFILLER_52_137 VGND VGND VPWR VPWR sky130_fd_sc_hd__decap_3
XFILLER_33_373 VGND VGND VPWR VPWR sky130_fd_sc_hd__decap_3
XFILLER_33_340 VGND VGND VPWR VPWR sky130_fd_sc_hd__decap_3
XFILLER_60_192 VGND VGND VPWR VPWR sky130_fd_sc_hd__decap_3
XFILLER_20_27 VGND VGND VPWR VPWR sky130_fd_sc_hd__fill_1
XFILLER_20_38 VGND VGND VPWR VPWR sky130_fd_sc_hd__decap_3
XFILLER_0_406 VGND VGND VPWR VPWR sky130_fd_sc_hd__fill_1
XFILLER_29_69 VGND VGND VPWR VPWR sky130_fd_sc_hd__decap_3
XFILLER_29_36 VGND VGND VPWR VPWR sky130_fd_sc_hd__decap_3
XFILLER_28_123 VGND VGND VPWR VPWR sky130_fd_sc_hd__decap_3
XTAP_TAPCELL_ROW_2_1_177 VGND VPWR sky130_fd_sc_hd__tapvpwrvgnd_1
XFILLER_28_189 VGND VGND VPWR VPWR sky130_fd_sc_hd__decap_3
XFILLER_45_79 VGND VGND VPWR VPWR sky130_fd_sc_hd__decap_3
XFILLER_43_137 VGND VGND VPWR VPWR sky130_fd_sc_hd__decap_3
XFILLER_24_351 VGND VGND VPWR VPWR sky130_fd_sc_hd__decap_3
XFILLER_24_395 VGND VGND VPWR VPWR sky130_fd_sc_hd__decap_3
XFILLER_61_12 VGND VGND VPWR VPWR sky130_fd_sc_hd__decap_3
XFILLER_51_181 VGND VGND VPWR VPWR sky130_fd_sc_hd__decap_3
XFILLER_61_45 VGND VGND VPWR VPWR sky130_fd_sc_hd__decap_3
XFILLER_61_78 VGND VGND VPWR VPWR sky130_fd_sc_hd__decap_3
XFILLER_6_18 VGND VGND VPWR VPWR sky130_fd_sc_hd__decap_3
XFILLER_6_29 VGND VGND VPWR VPWR sky130_fd_sc_hd__decap_3
XFILLER_13_9 VGND VGND VPWR VPWR sky130_fd_sc_hd__decap_3
XTAP_TAPCELL_ROW_49_438 VGND VPWR sky130_fd_sc_hd__tapvpwrvgnd_1
XFILLER_59_281 VGND VGND VPWR VPWR sky130_fd_sc_hd__decap_3
XFILLER_59_270 VGND VGND VPWR VPWR sky130_fd_sc_hd__decap_3
XFILLER_19_134 VGND VGND VPWR VPWR sky130_fd_sc_hd__decap_3
XPHY_EDGE_ROW_8_2_Right_94 VGND VGND VPWR VPWR sky130_fd_sc_hd__decap_3
XFILLER_19_167 VGND VGND VPWR VPWR sky130_fd_sc_hd__fill_1
XFILLER_19_178 VGND VGND VPWR VPWR sky130_fd_sc_hd__fill_2
XFILLER_34_115 VGND VGND VPWR VPWR sky130_fd_sc_hd__decap_3
XTAP_TAPCELL_ROW_57_493 VGND VPWR sky130_fd_sc_hd__tapvpwrvgnd_1
XFILLER_15_340 VGND VGND VPWR VPWR sky130_fd_sc_hd__decap_3
XFILLER_34_159 VGND VGND VPWR VPWR sky130_fd_sc_hd__decap_3
XFILLER_15_373 VGND VGND VPWR VPWR sky130_fd_sc_hd__decap_3
XTAP_TAPCELL_ROW_32_316 VGND VPWR sky130_fd_sc_hd__tapvpwrvgnd_1
XFILLER_35_90 VGND VGND VPWR VPWR sky130_fd_sc_hd__decap_3
XFILLER_30_321 VGND VGND VPWR VPWR sky130_fd_sc_hd__decap_3
XFILLER_42_192 VGND VGND VPWR VPWR sky130_fd_sc_hd__decap_3
XFILLER_30_354 VGND VGND VPWR VPWR sky130_fd_sc_hd__decap_3
XFILLER_30_398 VGND VGND VPWR VPWR sky130_fd_sc_hd__decap_3
XFILLER_30_365 VGND VGND VPWR VPWR sky130_fd_sc_hd__decap_3
XFILLER_53_402 VGND VGND VPWR VPWR sky130_fd_sc_hd__fill_1
XFILLER_25_137 VGND VGND VPWR VPWR sky130_fd_sc_hd__decap_3
XFILLER_15_49 VGND VGND VPWR VPWR sky130_fd_sc_hd__decap_3
XFILLER_21_321 VGND VGND VPWR VPWR sky130_fd_sc_hd__decap_3
XFILLER_40_118 VGND VGND VPWR VPWR sky130_fd_sc_hd__decap_3
XFILLER_33_181 VGND VGND VPWR VPWR sky130_fd_sc_hd__decap_3
XFILLER_21_343 VGND VGND VPWR VPWR sky130_fd_sc_hd__decap_3
XFILLER_21_365 VGND VGND VPWR VPWR sky130_fd_sc_hd__decap_3
XFILLER_31_15 VGND VGND VPWR VPWR sky130_fd_sc_hd__decap_3
Xoutput48 net48 VGND VGND VPWR VPWR s[3] sky130_fd_sc_hd__buf_2
XFILLER_56_12 VGND VGND VPWR VPWR sky130_fd_sc_hd__decap_3
XFILLER_48_218 VGND VGND VPWR VPWR sky130_fd_sc_hd__decap_3
XFILLER_56_56 VGND VGND VPWR VPWR sky130_fd_sc_hd__decap_3
XTAP_TAPCELL_ROW_46_419 VGND VPWR sky130_fd_sc_hd__tapvpwrvgnd_1
XFILLER_56_262 VGND VGND VPWR VPWR sky130_fd_sc_hd__decap_3
XFILLER_56_251 VGND VGND VPWR VPWR sky130_fd_sc_hd__fill_1
XFILLER_16_137 VGND VGND VPWR VPWR sky130_fd_sc_hd__decap_3
XTAP_TAPCELL_ROW_0_1_559 VGND VPWR sky130_fd_sc_hd__tapvpwrvgnd_1
XFILLER_16_159 VGND VGND VPWR VPWR sky130_fd_sc_hd__decap_3
XTAP_TAPCELL_ROW_54_474 VGND VPWR sky130_fd_sc_hd__tapvpwrvgnd_1
XFILLER_12_343 VGND VGND VPWR VPWR sky130_fd_sc_hd__decap_3
XFILLER_12_354 VGND VGND VPWR VPWR sky130_fd_sc_hd__decap_3
XFILLER_24_192 VGND VGND VPWR VPWR sky130_fd_sc_hd__decap_3
XFILLER_12_387 VGND VGND VPWR VPWR sky130_fd_sc_hd__decap_3
XFILLER_8_369 VGND VGND VPWR VPWR sky130_fd_sc_hd__decap_3
XFILLER_11_6 VGND VGND VPWR VPWR sky130_fd_sc_hd__decap_3
XFILLER_47_240 VGND VGND VPWR VPWR sky130_fd_sc_hd__decap_3
XFILLER_47_273 VGND VGND VPWR VPWR sky130_fd_sc_hd__decap_3
XFILLER_35_402 VGND VGND VPWR VPWR sky130_fd_sc_hd__decap_3
XFILLER_62_221 VGND VGND VPWR VPWR sky130_fd_sc_hd__decap_3
XFILLER_47_284 VGND VGND VPWR VPWR sky130_fd_sc_hd__decap_3
XFILLER_62_265 VGND VGND VPWR VPWR sky130_fd_sc_hd__decap_3
XFILLER_22_118 VGND VGND VPWR VPWR sky130_fd_sc_hd__decap_3
XFILLER_62_298 VGND VGND VPWR VPWR sky130_fd_sc_hd__decap_3
XFILLER_30_162 VGND VGND VPWR VPWR sky130_fd_sc_hd__decap_3
XFILLER_30_195 VGND VGND VPWR VPWR sky130_fd_sc_hd__fill_1
XFILLER_7_391 VGND VGND VPWR VPWR sky130_fd_sc_hd__decap_3
XFILLER_7_94 VGND VGND VPWR VPWR sky130_fd_sc_hd__decap_3
XFILLER_26_15 VGND VGND VPWR VPWR sky130_fd_sc_hd__decap_3
XFILLER_38_262 VGND VGND VPWR VPWR sky130_fd_sc_hd__decap_3
XFILLER_38_251 VGND VGND VPWR VPWR sky130_fd_sc_hd__fill_1
XFILLER_38_295 VGND VGND VPWR VPWR sky130_fd_sc_hd__decap_3
XFILLER_53_243 VGND VGND VPWR VPWR sky130_fd_sc_hd__decap_3
XPHY_EDGE_ROW_24_Right_45 VGND VGND VPWR VPWR sky130_fd_sc_hd__decap_3
XFILLER_53_287 VGND VGND VPWR VPWR sky130_fd_sc_hd__decap_3
XFILLER_53_276 VGND VGND VPWR VPWR sky130_fd_sc_hd__decap_3
XTAP_TAPCELL_ROW_51_455 VGND VPWR sky130_fd_sc_hd__tapvpwrvgnd_1
XFILLER_21_162 VGND VGND VPWR VPWR sky130_fd_sc_hd__decap_3
XFILLER_42_47 VGND VGND VPWR VPWR sky130_fd_sc_hd__decap_3
XFILLER_21_184 VGND VGND VPWR VPWR sky130_fd_sc_hd__decap_3
XPHY_EDGE_ROW_33_Right_54 VGND VGND VPWR VPWR sky130_fd_sc_hd__decap_3
XTAP_TAPCELL_ROW_59_511 VGND VPWR sky130_fd_sc_hd__tapvpwrvgnd_1
XFILLER_29_273 VGND VGND VPWR VPWR sky130_fd_sc_hd__decap_3
XFILLER_29_240 VGND VGND VPWR VPWR sky130_fd_sc_hd__decap_3
XPHY_EDGE_ROW_42_Right_63 VGND VGND VPWR VPWR sky130_fd_sc_hd__decap_3
XFILLER_44_221 VGND VGND VPWR VPWR sky130_fd_sc_hd__decap_3
XFILLER_29_284 VGND VGND VPWR VPWR sky130_fd_sc_hd__decap_3
XFILLER_44_265 VGND VGND VPWR VPWR sky130_fd_sc_hd__decap_3
XFILLER_44_298 VGND VGND VPWR VPWR sky130_fd_sc_hd__decap_3
XFILLER_12_162 VGND VGND VPWR VPWR sky130_fd_sc_hd__decap_3
XFILLER_8_100 VGND VGND VPWR VPWR sky130_fd_sc_hd__fill_1
XFILLER_8_133 VGND VGND VPWR VPWR sky130_fd_sc_hd__decap_3
XFILLER_8_144 VGND VGND VPWR VPWR sky130_fd_sc_hd__decap_3
XFILLER_8_177 VGND VGND VPWR VPWR sky130_fd_sc_hd__decap_3
XPHY_EDGE_ROW_51_Right_72 VGND VGND VPWR VPWR sky130_fd_sc_hd__decap_3
XFILLER_59_6 VGND VGND VPWR VPWR sky130_fd_sc_hd__decap_3
XFILLER_4_372 VGND VGND VPWR VPWR sky130_fd_sc_hd__decap_3
XPHY_EDGE_ROW_60_Right_81 VGND VGND VPWR VPWR sky130_fd_sc_hd__decap_3
XFILLER_23_405 VGND VGND VPWR VPWR sky130_fd_sc_hd__fill_2
XFILLER_35_243 VGND VGND VPWR VPWR sky130_fd_sc_hd__decap_3
XFILLER_50_224 VGND VGND VPWR VPWR sky130_fd_sc_hd__decap_3
XFILLER_35_287 VGND VGND VPWR VPWR sky130_fd_sc_hd__decap_3
XFILLER_35_276 VGND VGND VPWR VPWR sky130_fd_sc_hd__decap_3
XFILLER_50_268 VGND VGND VPWR VPWR sky130_fd_sc_hd__decap_3
XFILLER_58_324 VGND VGND VPWR VPWR sky130_fd_sc_hd__decap_3
XFILLER_58_357 VGND VGND VPWR VPWR sky130_fd_sc_hd__decap_3
XFILLER_58_368 VGND VGND VPWR VPWR sky130_fd_sc_hd__decap_3
XFILLER_26_221 VGND VGND VPWR VPWR sky130_fd_sc_hd__decap_3
XFILLER_14_405 VGND VGND VPWR VPWR sky130_fd_sc_hd__fill_2
XFILLER_26_265 VGND VGND VPWR VPWR sky130_fd_sc_hd__decap_3
XFILLER_26_298 VGND VGND VPWR VPWR sky130_fd_sc_hd__decap_3
XFILLER_41_202 VGND VGND VPWR VPWR sky130_fd_sc_hd__decap_3
XFILLER_53_57 VGND VGND VPWR VPWR sky130_fd_sc_hd__decap_3
XFILLER_53_46 VGND VGND VPWR VPWR sky130_fd_sc_hd__decap_3
XFILLER_41_246 VGND VGND VPWR VPWR sky130_fd_sc_hd__decap_3
X_270_ clknet_2_3__leaf_clk_regs genblk1\[15\].fa_inst.s _015_ VGND VGND VPWR VPWR
+ net45 sky130_fd_sc_hd__dfrtp_1
XFILLER_41_279 VGND VGND VPWR VPWR sky130_fd_sc_hd__fill_1
XFILLER_5_103 VGND VGND VPWR VPWR sky130_fd_sc_hd__decap_3
XFILLER_5_125 VGND VGND VPWR VPWR sky130_fd_sc_hd__decap_3
XFILLER_5_169 VGND VGND VPWR VPWR sky130_fd_sc_hd__decap_3
XFILLER_5_158 VGND VGND VPWR VPWR sky130_fd_sc_hd__decap_3
XFILLER_1_331 VGND VGND VPWR VPWR sky130_fd_sc_hd__decap_3
XFILLER_1_364 VGND VGND VPWR VPWR sky130_fd_sc_hd__decap_3
XFILLER_49_302 VGND VGND VPWR VPWR sky130_fd_sc_hd__decap_3
XFILLER_1_397 VGND VGND VPWR VPWR sky130_fd_sc_hd__decap_3
XFILLER_49_346 VGND VGND VPWR VPWR sky130_fd_sc_hd__decap_3
XFILLER_49_335 VGND VGND VPWR VPWR sky130_fd_sc_hd__fill_1
XFILLER_64_305 VGND VGND VPWR VPWR sky130_fd_sc_hd__decap_3
XFILLER_49_379 VGND VGND VPWR VPWR sky130_fd_sc_hd__decap_3
XFILLER_64_349 VGND VGND VPWR VPWR sky130_fd_sc_hd__decap_3
XTAP_TAPCELL_ROW_62_528 VGND VPWR sky130_fd_sc_hd__tapvpwrvgnd_1
XTAP_TAPCELL_ROW_27_282 VGND VPWR sky130_fd_sc_hd__tapvpwrvgnd_1
XFILLER_32_224 VGND VGND VPWR VPWR sky130_fd_sc_hd__decap_3
XFILLER_32_268 VGND VGND VPWR VPWR sky130_fd_sc_hd__decap_3
XFILLER_43_90 VGND VGND VPWR VPWR sky130_fd_sc_hd__fill_2
XFILLER_57_3 VGND VGND VPWR VPWR sky130_fd_sc_hd__decap_3
XFILLER_55_305 VGND VGND VPWR VPWR sky130_fd_sc_hd__decap_3
XFILLER_55_349 VGND VGND VPWR VPWR sky130_fd_sc_hd__decap_3
XFILLER_23_202 VGND VGND VPWR VPWR sky130_fd_sc_hd__decap_3
XFILLER_63_382 VGND VGND VPWR VPWR sky130_fd_sc_hd__decap_3
XFILLER_23_246 VGND VGND VPWR VPWR sky130_fd_sc_hd__decap_3
XFILLER_63_393 VGND VGND VPWR VPWR sky130_fd_sc_hd__decap_3
XFILLER_23_279 VGND VGND VPWR VPWR sky130_fd_sc_hd__fill_1
XFILLER_31_290 VGND VGND VPWR VPWR sky130_fd_sc_hd__decap_3
XFILLER_2_106 VGND VGND VPWR VPWR sky130_fd_sc_hd__decap_3
XFILLER_2_139 VGND VGND VPWR VPWR sky130_fd_sc_hd__fill_1
XFILLER_48_24 VGND VGND VPWR VPWR sky130_fd_sc_hd__decap_3
XFILLER_58_165 VGND VGND VPWR VPWR sky130_fd_sc_hd__decap_3
XFILLER_46_327 VGND VGND VPWR VPWR sky130_fd_sc_hd__decap_3
XFILLER_64_23 VGND VGND VPWR VPWR sky130_fd_sc_hd__decap_3
XFILLER_61_308 VGND VGND VPWR VPWR sky130_fd_sc_hd__decap_3
XFILLER_64_78 VGND VGND VPWR VPWR sky130_fd_sc_hd__decap_3
XFILLER_54_371 VGND VGND VPWR VPWR sky130_fd_sc_hd__decap_3
XFILLER_54_360 VGND VGND VPWR VPWR sky130_fd_sc_hd__decap_3
XTAP_TAPCELL_ROW_24_263 VGND VPWR sky130_fd_sc_hd__tapvpwrvgnd_1
Xfanout61 net62 VGND VGND VPWR VPWR net61 sky130_fd_sc_hd__buf_2
X_253_ net60 VGND VGND VPWR VPWR _048_ sky130_fd_sc_hd__inv_2
XFILLER_13_60 VGND VGND VPWR VPWR sky130_fd_sc_hd__decap_3
X_184_ _095_ _096_ VGND VGND VPWR VPWR genblk1\[11\].fa_inst.s sky130_fd_sc_hd__xnor2_1
XTAP_TAPCELL_ROW_3_1_179 VGND VPWR sky130_fd_sc_hd__tapvpwrvgnd_1
XFILLER_43_9 VGND VGND VPWR VPWR sky130_fd_sc_hd__decap_3
XFILLER_1_161 VGND VGND VPWR VPWR sky130_fd_sc_hd__decap_3
XFILLER_1_172 VGND VGND VPWR VPWR sky130_fd_sc_hd__decap_3
XFILLER_49_143 VGND VGND VPWR VPWR sky130_fd_sc_hd__decap_3
XFILLER_37_305 VGND VGND VPWR VPWR sky130_fd_sc_hd__decap_3
XFILLER_64_113 VGND VGND VPWR VPWR sky130_fd_sc_hd__decap_3
XFILLER_49_187 VGND VGND VPWR VPWR sky130_fd_sc_hd__decap_3
XFILLER_37_349 VGND VGND VPWR VPWR sky130_fd_sc_hd__decap_3
XFILLER_60_330 VGND VGND VPWR VPWR sky130_fd_sc_hd__decap_3
XFILLER_45_393 VGND VGND VPWR VPWR sky130_fd_sc_hd__decap_3
XFILLER_45_382 VGND VGND VPWR VPWR sky130_fd_sc_hd__decap_3
XFILLER_60_374 VGND VGND VPWR VPWR sky130_fd_sc_hd__decap_3
XFILLER_60_363 VGND VGND VPWR VPWR sky130_fd_sc_hd__fill_1
XFILLER_18_27 VGND VGND VPWR VPWR sky130_fd_sc_hd__fill_1
XFILLER_18_38 VGND VGND VPWR VPWR sky130_fd_sc_hd__decap_3
XFILLER_55_113 VGND VGND VPWR VPWR sky130_fd_sc_hd__decap_3
XFILLER_55_102 VGND VGND VPWR VPWR sky130_fd_sc_hd__decap_3
XFILLER_28_327 VGND VGND VPWR VPWR sky130_fd_sc_hd__decap_3
XFILLER_55_146 VGND VGND VPWR VPWR sky130_fd_sc_hd__decap_3
XFILLER_43_308 VGND VGND VPWR VPWR sky130_fd_sc_hd__decap_3
XFILLER_36_371 VGND VGND VPWR VPWR sky130_fd_sc_hd__decap_3
XFILLER_36_360 VGND VGND VPWR VPWR sky130_fd_sc_hd__decap_3
XFILLER_63_190 VGND VGND VPWR VPWR sky130_fd_sc_hd__decap_3
XFILLER_34_15 VGND VGND VPWR VPWR sky130_fd_sc_hd__decap_3
XFILLER_51_352 VGND VGND VPWR VPWR sky130_fd_sc_hd__decap_3
XFILLER_34_59 VGND VGND VPWR VPWR sky130_fd_sc_hd__decap_3
XFILLER_51_396 VGND VGND VPWR VPWR sky130_fd_sc_hd__decap_3
XFILLER_51_385 VGND VGND VPWR VPWR sky130_fd_sc_hd__decap_3
XTAP_TAPCELL_ROW_21_233 VGND VPWR sky130_fd_sc_hd__tapvpwrvgnd_1
XTAP_TAPCELL_ROW_21_244 VGND VPWR sky130_fd_sc_hd__tapvpwrvgnd_1
XPHY_EDGE_ROW_3_2_Left_24 VGND VGND VPWR VPWR sky130_fd_sc_hd__decap_3
XFILLER_50_47 VGND VGND VPWR VPWR sky130_fd_sc_hd__decap_3
XFILLER_59_12 VGND VGND VPWR VPWR sky130_fd_sc_hd__decap_3
XFILLER_59_45 VGND VGND VPWR VPWR sky130_fd_sc_hd__decap_3
XFILLER_59_78 VGND VGND VPWR VPWR sky130_fd_sc_hd__decap_3
XTAP_TAPCELL_ROW_29_300 VGND VPWR sky130_fd_sc_hd__tapvpwrvgnd_1
XFILLER_46_124 VGND VGND VPWR VPWR sky130_fd_sc_hd__decap_3
XFILLER_19_349 VGND VGND VPWR VPWR sky130_fd_sc_hd__decap_3
XFILLER_61_116 VGND VGND VPWR VPWR sky130_fd_sc_hd__decap_3
XFILLER_61_105 VGND VGND VPWR VPWR sky130_fd_sc_hd__decap_3
XFILLER_46_168 VGND VGND VPWR VPWR sky130_fd_sc_hd__decap_3
XFILLER_27_382 VGND VGND VPWR VPWR sky130_fd_sc_hd__decap_3
XFILLER_27_393 VGND VGND VPWR VPWR sky130_fd_sc_hd__decap_3
XFILLER_61_149 VGND VGND VPWR VPWR sky130_fd_sc_hd__decap_3
XFILLER_42_330 VGND VGND VPWR VPWR sky130_fd_sc_hd__decap_3
XFILLER_42_363 VGND VGND VPWR VPWR sky130_fd_sc_hd__fill_1
XFILLER_42_374 VGND VGND VPWR VPWR sky130_fd_sc_hd__decap_3
X_236_ net60 VGND VGND VPWR VPWR _031_ sky130_fd_sc_hd__inv_2
X_167_ _081_ _082_ VGND VGND VPWR VPWR _083_ sky130_fd_sc_hd__nand2_1
XFILLER_41_6 VGND VGND VPWR VPWR sky130_fd_sc_hd__decap_3
XFILLER_40_91 VGND VGND VPWR VPWR sky130_fd_sc_hd__fill_1
XFILLER_1_30 VGND VGND VPWR VPWR sky130_fd_sc_hd__decap_3
XFILLER_37_113 VGND VGND VPWR VPWR sky130_fd_sc_hd__decap_3
XFILLER_1_63 VGND VGND VPWR VPWR sky130_fd_sc_hd__decap_3
XFILLER_37_146 VGND VGND VPWR VPWR sky130_fd_sc_hd__decap_3
XFILLER_18_360 VGND VGND VPWR VPWR sky130_fd_sc_hd__decap_3
XFILLER_1_96 VGND VGND VPWR VPWR sky130_fd_sc_hd__decap_3
XFILLER_25_308 VGND VGND VPWR VPWR sky130_fd_sc_hd__decap_3
XFILLER_18_393 VGND VGND VPWR VPWR sky130_fd_sc_hd__decap_3
XFILLER_45_190 VGND VGND VPWR VPWR sky130_fd_sc_hd__decap_3
XFILLER_33_352 VGND VGND VPWR VPWR sky130_fd_sc_hd__decap_3
XFILLER_60_171 VGND VGND VPWR VPWR sky130_fd_sc_hd__decap_3
XFILLER_33_396 VGND VGND VPWR VPWR sky130_fd_sc_hd__decap_3
XFILLER_33_385 VGND VGND VPWR VPWR sky130_fd_sc_hd__decap_3
XFILLER_29_15 VGND VGND VPWR VPWR sky130_fd_sc_hd__fill_1
XFILLER_29_48 VGND VGND VPWR VPWR sky130_fd_sc_hd__fill_2
XFILLER_28_135 VGND VGND VPWR VPWR sky130_fd_sc_hd__decap_3
XFILLER_45_47 VGND VGND VPWR VPWR sky130_fd_sc_hd__decap_3
XFILLER_43_116 VGND VGND VPWR VPWR sky130_fd_sc_hd__decap_3
XFILLER_28_168 VGND VGND VPWR VPWR sky130_fd_sc_hd__decap_3
XFILLER_24_330 VGND VGND VPWR VPWR sky130_fd_sc_hd__decap_3
XFILLER_43_149 VGND VGND VPWR VPWR sky130_fd_sc_hd__decap_3
XFILLER_24_363 VGND VGND VPWR VPWR sky130_fd_sc_hd__fill_1
XFILLER_24_374 VGND VGND VPWR VPWR sky130_fd_sc_hd__decap_3
XFILLER_61_24 VGND VGND VPWR VPWR sky130_fd_sc_hd__decap_3
XFILLER_61_57 VGND VGND VPWR VPWR sky130_fd_sc_hd__decap_3
XFILLER_51_193 VGND VGND VPWR VPWR sky130_fd_sc_hd__decap_3
XFILLER_10_83 VGND VGND VPWR VPWR sky130_fd_sc_hd__fill_1
XFILLER_10_94 VGND VGND VPWR VPWR sky130_fd_sc_hd__decap_3
XFILLER_19_113 VGND VGND VPWR VPWR sky130_fd_sc_hd__decap_3
XTAP_TAPCELL_ROW_49_439 VGND VPWR sky130_fd_sc_hd__tapvpwrvgnd_1
XFILLER_19_146 VGND VGND VPWR VPWR sky130_fd_sc_hd__decap_3
XFILLER_19_81 VGND VGND VPWR VPWR sky130_fd_sc_hd__decap_3
XFILLER_59_293 VGND VGND VPWR VPWR sky130_fd_sc_hd__decap_3
XTAP_TAPCELL_ROW_57_494 VGND VPWR sky130_fd_sc_hd__tapvpwrvgnd_1
XFILLER_34_127 VGND VGND VPWR VPWR sky130_fd_sc_hd__decap_3
XFILLER_15_352 VGND VGND VPWR VPWR sky130_fd_sc_hd__decap_3
XFILLER_27_190 VGND VGND VPWR VPWR sky130_fd_sc_hd__decap_3
XFILLER_15_385 VGND VGND VPWR VPWR sky130_fd_sc_hd__decap_3
XTAP_TAPCELL_ROW_32_317 VGND VPWR sky130_fd_sc_hd__tapvpwrvgnd_1
XFILLER_42_171 VGND VGND VPWR VPWR sky130_fd_sc_hd__decap_3
XFILLER_30_333 VGND VGND VPWR VPWR sky130_fd_sc_hd__decap_3
XFILLER_30_377 VGND VGND VPWR VPWR sky130_fd_sc_hd__decap_3
XTAP_TAPCELL_ROW_40_372 VGND VPWR sky130_fd_sc_hd__tapvpwrvgnd_1
X_219_ net61 VGND VGND VPWR VPWR _014_ sky130_fd_sc_hd__inv_2
XFILLER_57_208 VGND VGND VPWR VPWR sky130_fd_sc_hd__decap_3
XFILLER_25_116 VGND VGND VPWR VPWR sky130_fd_sc_hd__decap_3
XFILLER_25_149 VGND VGND VPWR VPWR sky130_fd_sc_hd__decap_3
XFILLER_21_333 VGND VGND VPWR VPWR sky130_fd_sc_hd__decap_3
XFILLER_21_355 VGND VGND VPWR VPWR sky130_fd_sc_hd__decap_3
XFILLER_33_193 VGND VGND VPWR VPWR sky130_fd_sc_hd__decap_3
XFILLER_21_377 VGND VGND VPWR VPWR sky130_fd_sc_hd__decap_3
XFILLER_21_399 VGND VGND VPWR VPWR sky130_fd_sc_hd__decap_3
XFILLER_31_38 VGND VGND VPWR VPWR sky130_fd_sc_hd__decap_3
Xoutput38 net38 VGND VGND VPWR VPWR cout sky130_fd_sc_hd__buf_2
Xoutput49 net49 VGND VGND VPWR VPWR s[4] sky130_fd_sc_hd__buf_2
XFILLER_56_35 VGND VGND VPWR VPWR sky130_fd_sc_hd__decap_3
XFILLER_56_24 VGND VGND VPWR VPWR sky130_fd_sc_hd__fill_1
XFILLER_56_230 VGND VGND VPWR VPWR sky130_fd_sc_hd__decap_3
XFILLER_56_68 VGND VGND VPWR VPWR sky130_fd_sc_hd__decap_3
XFILLER_56_274 VGND VGND VPWR VPWR sky130_fd_sc_hd__decap_3
XFILLER_16_116 VGND VGND VPWR VPWR sky130_fd_sc_hd__decap_3
XFILLER_24_171 VGND VGND VPWR VPWR sky130_fd_sc_hd__decap_3
XTAP_TAPCELL_ROW_54_475 VGND VPWR sky130_fd_sc_hd__tapvpwrvgnd_1
XFILLER_31_119 VGND VGND VPWR VPWR sky130_fd_sc_hd__decap_3
XFILLER_31_108 VGND VGND VPWR VPWR sky130_fd_sc_hd__decap_3
XFILLER_12_366 VGND VGND VPWR VPWR sky130_fd_sc_hd__decap_3
XFILLER_8_337 VGND VGND VPWR VPWR sky130_fd_sc_hd__decap_3
XFILLER_12_399 VGND VGND VPWR VPWR sky130_fd_sc_hd__decap_3
XFILLER_21_60 VGND VGND VPWR VPWR sky130_fd_sc_hd__fill_2
XFILLER_21_71 VGND VGND VPWR VPWR sky130_fd_sc_hd__decap_3
XFILLER_39_208 VGND VGND VPWR VPWR sky130_fd_sc_hd__decap_3
XFILLER_47_252 VGND VGND VPWR VPWR sky130_fd_sc_hd__decap_3
XFILLER_62_200 VGND VGND VPWR VPWR sky130_fd_sc_hd__decap_3
XFILLER_62_233 VGND VGND VPWR VPWR sky130_fd_sc_hd__decap_3
XFILLER_47_296 VGND VGND VPWR VPWR sky130_fd_sc_hd__decap_3
XFILLER_62_277 VGND VGND VPWR VPWR sky130_fd_sc_hd__decap_3
Xclkbuf_0_clk clk VGND VGND VPWR VPWR clknet_0_clk sky130_fd_sc_hd__clkbuf_16
XFILLER_30_130 VGND VGND VPWR VPWR sky130_fd_sc_hd__decap_3
XFILLER_30_141 VGND VGND VPWR VPWR sky130_fd_sc_hd__decap_3
XFILLER_30_174 VGND VGND VPWR VPWR sky130_fd_sc_hd__decap_3
XFILLER_7_370 VGND VGND VPWR VPWR sky130_fd_sc_hd__decap_3
XFILLER_38_230 VGND VGND VPWR VPWR sky130_fd_sc_hd__decap_3
XFILLER_26_27 VGND VGND VPWR VPWR sky130_fd_sc_hd__fill_1
XFILLER_26_38 VGND VGND VPWR VPWR sky130_fd_sc_hd__decap_3
XFILLER_53_211 VGND VGND VPWR VPWR sky130_fd_sc_hd__decap_3
XFILLER_38_274 VGND VGND VPWR VPWR sky130_fd_sc_hd__decap_3
XFILLER_53_255 VGND VGND VPWR VPWR sky130_fd_sc_hd__decap_3
XFILLER_13_119 VGND VGND VPWR VPWR sky130_fd_sc_hd__decap_3
XFILLER_53_299 VGND VGND VPWR VPWR sky130_fd_sc_hd__decap_3
XFILLER_42_15 VGND VGND VPWR VPWR sky130_fd_sc_hd__decap_3
XFILLER_21_141 VGND VGND VPWR VPWR sky130_fd_sc_hd__decap_3
XFILLER_42_59 VGND VGND VPWR VPWR sky130_fd_sc_hd__decap_3
XFILLER_29_252 VGND VGND VPWR VPWR sky130_fd_sc_hd__decap_3
XFILLER_44_200 VGND VGND VPWR VPWR sky130_fd_sc_hd__decap_3
XFILLER_29_296 VGND VGND VPWR VPWR sky130_fd_sc_hd__decap_3
XFILLER_44_233 VGND VGND VPWR VPWR sky130_fd_sc_hd__decap_3
XFILLER_16_71 VGND VGND VPWR VPWR sky130_fd_sc_hd__decap_3
XFILLER_44_277 VGND VGND VPWR VPWR sky130_fd_sc_hd__decap_3
XFILLER_12_130 VGND VGND VPWR VPWR sky130_fd_sc_hd__decap_3
XFILLER_12_141 VGND VGND VPWR VPWR sky130_fd_sc_hd__decap_3
XFILLER_12_174 VGND VGND VPWR VPWR sky130_fd_sc_hd__decap_3
XFILLER_8_156 VGND VGND VPWR VPWR sky130_fd_sc_hd__decap_3
XFILLER_32_81 VGND VGND VPWR VPWR sky130_fd_sc_hd__decap_3
XFILLER_4_340 VGND VGND VPWR VPWR sky130_fd_sc_hd__decap_3
XFILLER_4_384 VGND VGND VPWR VPWR sky130_fd_sc_hd__decap_3
XFILLER_35_211 VGND VGND VPWR VPWR sky130_fd_sc_hd__decap_3
XFILLER_35_255 VGND VGND VPWR VPWR sky130_fd_sc_hd__decap_3
XFILLER_50_203 VGND VGND VPWR VPWR sky130_fd_sc_hd__decap_3
XFILLER_50_236 VGND VGND VPWR VPWR sky130_fd_sc_hd__decap_3
XFILLER_35_299 VGND VGND VPWR VPWR sky130_fd_sc_hd__decap_3
XFILLER_12_29 VGND VGND VPWR VPWR sky130_fd_sc_hd__decap_3
XFILLER_58_336 VGND VGND VPWR VPWR sky130_fd_sc_hd__decap_3
XFILLER_37_15 VGND VGND VPWR VPWR sky130_fd_sc_hd__fill_2
XFILLER_37_37 VGND VGND VPWR VPWR sky130_fd_sc_hd__decap_3
XFILLER_26_200 VGND VGND VPWR VPWR sky130_fd_sc_hd__decap_3
XFILLER_26_233 VGND VGND VPWR VPWR sky130_fd_sc_hd__decap_3
XFILLER_26_277 VGND VGND VPWR VPWR sky130_fd_sc_hd__decap_3
XFILLER_41_214 VGND VGND VPWR VPWR sky130_fd_sc_hd__decap_3
XFILLER_53_69 VGND VGND VPWR VPWR sky130_fd_sc_hd__decap_3
XFILLER_41_225 VGND VGND VPWR VPWR sky130_fd_sc_hd__decap_3
XFILLER_41_258 VGND VGND VPWR VPWR sky130_fd_sc_hd__decap_3
XFILLER_5_137 VGND VGND VPWR VPWR sky130_fd_sc_hd__decap_3
XFILLER_1_343 VGND VGND VPWR VPWR sky130_fd_sc_hd__decap_3
XFILLER_1_376 VGND VGND VPWR VPWR sky130_fd_sc_hd__decap_3
XFILLER_49_314 VGND VGND VPWR VPWR sky130_fd_sc_hd__decap_3
XFILLER_64_317 VGND VGND VPWR VPWR sky130_fd_sc_hd__decap_3
XFILLER_49_358 VGND VGND VPWR VPWR sky130_fd_sc_hd__decap_3
XFILLER_27_81 VGND VGND VPWR VPWR sky130_fd_sc_hd__decap_3
XFILLER_57_391 VGND VGND VPWR VPWR sky130_fd_sc_hd__fill_1
XTAP_TAPCELL_ROW_62_529 VGND VPWR sky130_fd_sc_hd__tapvpwrvgnd_1
XFILLER_32_203 VGND VGND VPWR VPWR sky130_fd_sc_hd__decap_3
XTAP_TAPCELL_ROW_27_283 VGND VPWR sky130_fd_sc_hd__tapvpwrvgnd_1
XFILLER_32_236 VGND VGND VPWR VPWR sky130_fd_sc_hd__decap_3
XFILLER_40_280 VGND VGND VPWR VPWR sky130_fd_sc_hd__decap_3
XFILLER_4_41 VGND VGND VPWR VPWR sky130_fd_sc_hd__decap_3
XFILLER_4_85 VGND VGND VPWR VPWR sky130_fd_sc_hd__decap_3
XFILLER_4_74 VGND VGND VPWR VPWR sky130_fd_sc_hd__decap_3
XFILLER_55_317 VGND VGND VPWR VPWR sky130_fd_sc_hd__decap_3
XFILLER_48_380 VGND VGND VPWR VPWR sky130_fd_sc_hd__decap_3
XPHY_EDGE_ROW_13_2_Right_99 VGND VGND VPWR VPWR sky130_fd_sc_hd__decap_3
XFILLER_23_214 VGND VGND VPWR VPWR sky130_fd_sc_hd__decap_3
XFILLER_63_361 VGND VGND VPWR VPWR sky130_fd_sc_hd__decap_3
XFILLER_23_225 VGND VGND VPWR VPWR sky130_fd_sc_hd__decap_3
XFILLER_23_258 VGND VGND VPWR VPWR sky130_fd_sc_hd__decap_3
XFILLER_2_118 VGND VGND VPWR VPWR sky130_fd_sc_hd__decap_3
XFILLER_3_9 VGND VGND VPWR VPWR sky130_fd_sc_hd__fill_2
XFILLER_58_122 VGND VGND VPWR VPWR sky130_fd_sc_hd__decap_3
XFILLER_58_144 VGND VGND VPWR VPWR sky130_fd_sc_hd__decap_3
XFILLER_48_69 VGND VGND VPWR VPWR sky130_fd_sc_hd__fill_1
XFILLER_58_177 VGND VGND VPWR VPWR sky130_fd_sc_hd__decap_3
XFILLER_46_339 VGND VGND VPWR VPWR sky130_fd_sc_hd__decap_3
XFILLER_64_35 VGND VGND VPWR VPWR sky130_fd_sc_hd__decap_3
XFILLER_39_391 VGND VGND VPWR VPWR sky130_fd_sc_hd__fill_1
XFILLER_64_57 VGND VGND VPWR VPWR sky130_fd_sc_hd__decap_3
XFILLER_54_383 VGND VGND VPWR VPWR sky130_fd_sc_hd__decap_3
XTAP_TAPCELL_ROW_24_264 VGND VPWR sky130_fd_sc_hd__tapvpwrvgnd_1
Xfanout62 net37 VGND VGND VPWR VPWR net62 sky130_fd_sc_hd__clkbuf_8
X_252_ net60 VGND VGND VPWR VPWR _047_ sky130_fd_sc_hd__inv_2
XFILLER_22_280 VGND VGND VPWR VPWR sky130_fd_sc_hd__decap_3
XFILLER_6_402 VGND VGND VPWR VPWR sky130_fd_sc_hd__decap_3
X_183_ _089_ _092_ _090_ VGND VGND VPWR VPWR _096_ sky130_fd_sc_hd__a21bo_1
XFILLER_13_72 VGND VGND VPWR VPWR sky130_fd_sc_hd__decap_3
XFILLER_1_140 VGND VGND VPWR VPWR sky130_fd_sc_hd__decap_3
XFILLER_36_9 VGND VGND VPWR VPWR sky130_fd_sc_hd__decap_3
XFILLER_49_122 VGND VGND VPWR VPWR sky130_fd_sc_hd__decap_3
XFILLER_49_100 VGND VGND VPWR VPWR sky130_fd_sc_hd__decap_3
XFILLER_49_155 VGND VGND VPWR VPWR sky130_fd_sc_hd__decap_3
XFILLER_64_103 VGND VGND VPWR VPWR sky130_fd_sc_hd__decap_3
XFILLER_64_125 VGND VGND VPWR VPWR sky130_fd_sc_hd__decap_3
XFILLER_49_199 VGND VGND VPWR VPWR sky130_fd_sc_hd__decap_3
XFILLER_37_317 VGND VGND VPWR VPWR sky130_fd_sc_hd__decap_3
XFILLER_64_147 VGND VGND VPWR VPWR sky130_fd_sc_hd__decap_3
XFILLER_38_91 VGND VGND VPWR VPWR sky130_fd_sc_hd__decap_3
XFILLER_64_169 VGND VGND VPWR VPWR sky130_fd_sc_hd__decap_3
XFILLER_52_309 VGND VGND VPWR VPWR sky130_fd_sc_hd__decap_3
XFILLER_45_361 VGND VGND VPWR VPWR sky130_fd_sc_hd__decap_3
XFILLER_60_342 VGND VGND VPWR VPWR sky130_fd_sc_hd__decap_3
XFILLER_60_386 VGND VGND VPWR VPWR sky130_fd_sc_hd__decap_3
XFILLER_55_125 VGND VGND VPWR VPWR sky130_fd_sc_hd__decap_3
XFILLER_28_339 VGND VGND VPWR VPWR sky130_fd_sc_hd__decap_3
XFILLER_55_158 VGND VGND VPWR VPWR sky130_fd_sc_hd__decap_3
XFILLER_55_169 VGND VGND VPWR VPWR sky130_fd_sc_hd__decap_3
XFILLER_51_320 VGND VGND VPWR VPWR sky130_fd_sc_hd__decap_3
XFILLER_36_383 VGND VGND VPWR VPWR sky130_fd_sc_hd__decap_3
XFILLER_34_27 VGND VGND VPWR VPWR sky130_fd_sc_hd__fill_1
XFILLER_51_364 VGND VGND VPWR VPWR sky130_fd_sc_hd__decap_3
XFILLER_34_38 VGND VGND VPWR VPWR sky130_fd_sc_hd__decap_3
XTAP_TAPCELL_ROW_21_234 VGND VPWR sky130_fd_sc_hd__tapvpwrvgnd_1
XTAP_TAPCELL_ROW_21_245 VGND VPWR sky130_fd_sc_hd__tapvpwrvgnd_1
XFILLER_50_15 VGND VGND VPWR VPWR sky130_fd_sc_hd__decap_3
XPHY_EDGE_ROW_18_2_Left_39 VGND VGND VPWR VPWR sky130_fd_sc_hd__decap_3
XFILLER_50_59 VGND VGND VPWR VPWR sky130_fd_sc_hd__decap_3
XFILLER_1_6 VGND VGND VPWR VPWR sky130_fd_sc_hd__decap_3
XFILLER_59_24 VGND VGND VPWR VPWR sky130_fd_sc_hd__decap_3
XFILLER_59_57 VGND VGND VPWR VPWR sky130_fd_sc_hd__decap_3
XFILLER_19_328 VGND VGND VPWR VPWR sky130_fd_sc_hd__decap_3
XTAP_TAPCELL_ROW_29_301 VGND VPWR sky130_fd_sc_hd__tapvpwrvgnd_1
XFILLER_46_103 VGND VGND VPWR VPWR sky130_fd_sc_hd__decap_3
XFILLER_46_147 VGND VGND VPWR VPWR sky130_fd_sc_hd__decap_3
XFILLER_46_136 VGND VGND VPWR VPWR sky130_fd_sc_hd__decap_3
XFILLER_27_361 VGND VGND VPWR VPWR sky130_fd_sc_hd__decap_3
XFILLER_34_309 VGND VGND VPWR VPWR sky130_fd_sc_hd__decap_3
XFILLER_61_128 VGND VGND VPWR VPWR sky130_fd_sc_hd__decap_3
XFILLER_54_180 VGND VGND VPWR VPWR sky130_fd_sc_hd__decap_3
XFILLER_42_342 VGND VGND VPWR VPWR sky130_fd_sc_hd__decap_3
X_304_ clknet_2_0__leaf_clk_regs net33 _049_ VGND VGND VPWR VPWR cin_q sky130_fd_sc_hd__dfrtp_1
XFILLER_42_386 VGND VGND VPWR VPWR sky130_fd_sc_hd__decap_3
XFILLER_24_71 VGND VGND VPWR VPWR sky130_fd_sc_hd__decap_3
X_235_ net60 VGND VGND VPWR VPWR _030_ sky130_fd_sc_hd__inv_2
X_166_ genblk1\[8\].fa_inst.b genblk1\[8\].fa_inst.a VGND VGND VPWR VPWR _082_ sky130_fd_sc_hd__nand2_1
XFILLER_34_6 VGND VGND VPWR VPWR sky130_fd_sc_hd__decap_3
XFILLER_1_42 VGND VGND VPWR VPWR sky130_fd_sc_hd__decap_3
XFILLER_37_125 VGND VGND VPWR VPWR sky130_fd_sc_hd__decap_3
XFILLER_1_75 VGND VGND VPWR VPWR sky130_fd_sc_hd__decap_3
XFILLER_37_169 VGND VGND VPWR VPWR sky130_fd_sc_hd__decap_3
XFILLER_37_158 VGND VGND VPWR VPWR sky130_fd_sc_hd__decap_3
XFILLER_18_372 VGND VGND VPWR VPWR sky130_fd_sc_hd__decap_3
XTAP_TAPCELL_ROW_35_337 VGND VPWR sky130_fd_sc_hd__tapvpwrvgnd_1
XFILLER_52_128 VGND VGND VPWR VPWR sky130_fd_sc_hd__decap_3
XFILLER_33_320 VGND VGND VPWR VPWR sky130_fd_sc_hd__decap_3
XFILLER_33_364 VGND VGND VPWR VPWR sky130_fd_sc_hd__decap_3
XFILLER_60_183 VGND VGND VPWR VPWR sky130_fd_sc_hd__decap_3
XFILLER_60_150 VGND VGND VPWR VPWR sky130_fd_sc_hd__decap_3
XFILLER_20_18 VGND VGND VPWR VPWR sky130_fd_sc_hd__decap_3
XFILLER_56_401 VGND VGND VPWR VPWR sky130_fd_sc_hd__decap_3
XFILLER_28_114 VGND VGND VPWR VPWR sky130_fd_sc_hd__decap_3
XFILLER_45_15 VGND VGND VPWR VPWR sky130_fd_sc_hd__decap_3
XPHY_EDGE_ROW_18_1_Right_17 VGND VGND VPWR VPWR sky130_fd_sc_hd__decap_3
XFILLER_43_128 VGND VGND VPWR VPWR sky130_fd_sc_hd__decap_3
XFILLER_36_180 VGND VGND VPWR VPWR sky130_fd_sc_hd__decap_3
XFILLER_24_342 VGND VGND VPWR VPWR sky130_fd_sc_hd__decap_3
XFILLER_24_386 VGND VGND VPWR VPWR sky130_fd_sc_hd__decap_3
XFILLER_51_172 VGND VGND VPWR VPWR sky130_fd_sc_hd__decap_3
XFILLER_51_161 VGND VGND VPWR VPWR sky130_fd_sc_hd__decap_3
XFILLER_61_36 VGND VGND VPWR VPWR sky130_fd_sc_hd__decap_3
XFILLER_61_69 VGND VGND VPWR VPWR sky130_fd_sc_hd__decap_3
Xclkbuf_regs_0_clk clk VGND VGND VPWR VPWR clk_regs sky130_fd_sc_hd__clkbuf_16
XFILLER_59_261 VGND VGND VPWR VPWR sky130_fd_sc_hd__decap_3
XFILLER_19_125 VGND VGND VPWR VPWR sky130_fd_sc_hd__decap_3
XFILLER_19_60 VGND VGND VPWR VPWR sky130_fd_sc_hd__decap_3
XFILLER_19_158 VGND VGND VPWR VPWR sky130_fd_sc_hd__decap_3
XFILLER_19_169 VGND VGND VPWR VPWR sky130_fd_sc_hd__decap_3
XFILLER_62_404 VGND VGND VPWR VPWR sky130_fd_sc_hd__decap_3
XFILLER_34_106 VGND VGND VPWR VPWR sky130_fd_sc_hd__decap_3
XTAP_TAPCELL_ROW_57_495 VGND VPWR sky130_fd_sc_hd__tapvpwrvgnd_1
XFILLER_34_139 VGND VGND VPWR VPWR sky130_fd_sc_hd__fill_1
XFILLER_15_331 VGND VGND VPWR VPWR sky130_fd_sc_hd__decap_3
XFILLER_15_364 VGND VGND VPWR VPWR sky130_fd_sc_hd__decap_3
XTAP_TAPCELL_ROW_32_318 VGND VPWR sky130_fd_sc_hd__tapvpwrvgnd_1
XFILLER_42_150 VGND VGND VPWR VPWR sky130_fd_sc_hd__decap_3
XFILLER_35_81 VGND VGND VPWR VPWR sky130_fd_sc_hd__decap_3
XFILLER_30_312 VGND VGND VPWR VPWR sky130_fd_sc_hd__decap_3
XFILLER_30_301 VGND VGND VPWR VPWR sky130_fd_sc_hd__decap_3
XFILLER_15_397 VGND VGND VPWR VPWR sky130_fd_sc_hd__decap_3
XFILLER_42_183 VGND VGND VPWR VPWR sky130_fd_sc_hd__decap_3
XFILLER_30_345 VGND VGND VPWR VPWR sky130_fd_sc_hd__decap_3
XFILLER_30_389 VGND VGND VPWR VPWR sky130_fd_sc_hd__decap_3
XTAP_TAPCELL_ROW_40_373 VGND VPWR sky130_fd_sc_hd__tapvpwrvgnd_1
X_218_ net60 VGND VGND VPWR VPWR _013_ sky130_fd_sc_hd__inv_2
XFILLER_51_80 VGND VGND VPWR VPWR sky130_fd_sc_hd__decap_3
X_149_ _067_ _068_ VGND VGND VPWR VPWR genblk1\[4\].fa_inst.s sky130_fd_sc_hd__xnor2_1
XFILLER_38_401 VGND VGND VPWR VPWR sky130_fd_sc_hd__decap_3
XFILLER_25_106 VGND VGND VPWR VPWR sky130_fd_sc_hd__decap_3
XFILLER_25_128 VGND VGND VPWR VPWR sky130_fd_sc_hd__decap_3
XFILLER_21_312 VGND VGND VPWR VPWR sky130_fd_sc_hd__decap_3
XFILLER_33_172 VGND VGND VPWR VPWR sky130_fd_sc_hd__decap_3
XFILLER_33_161 VGND VGND VPWR VPWR sky130_fd_sc_hd__decap_3
XFILLER_21_389 VGND VGND VPWR VPWR sky130_fd_sc_hd__decap_3
Xoutput39 net39 VGND VGND VPWR VPWR s[0] sky130_fd_sc_hd__buf_2
XPHY_EDGE_ROW_9_1_Left_115 VGND VGND VPWR VPWR sky130_fd_sc_hd__decap_3
XFILLER_48_209 VGND VGND VPWR VPWR sky130_fd_sc_hd__decap_3
XFILLER_56_47 VGND VGND VPWR VPWR sky130_fd_sc_hd__decap_3
XFILLER_56_253 VGND VGND VPWR VPWR sky130_fd_sc_hd__decap_3
XFILLER_56_242 VGND VGND VPWR VPWR sky130_fd_sc_hd__decap_3
XFILLER_44_404 VGND VGND VPWR VPWR sky130_fd_sc_hd__decap_3
XFILLER_16_128 VGND VGND VPWR VPWR sky130_fd_sc_hd__decap_3
XFILLER_56_286 VGND VGND VPWR VPWR sky130_fd_sc_hd__decap_3
XFILLER_24_150 VGND VGND VPWR VPWR sky130_fd_sc_hd__decap_3
XTAP_TAPCELL_ROW_54_476 VGND VPWR sky130_fd_sc_hd__tapvpwrvgnd_1
XFILLER_12_334 VGND VGND VPWR VPWR sky130_fd_sc_hd__decap_3
XFILLER_24_183 VGND VGND VPWR VPWR sky130_fd_sc_hd__decap_3
XFILLER_12_378 VGND VGND VPWR VPWR sky130_fd_sc_hd__decap_3
XFILLER_8_349 VGND VGND VPWR VPWR sky130_fd_sc_hd__decap_3
XFILLER_21_83 VGND VGND VPWR VPWR sky130_fd_sc_hd__fill_1
XFILLER_47_231 VGND VGND VPWR VPWR sky130_fd_sc_hd__decap_3
XFILLER_47_220 VGND VGND VPWR VPWR sky130_fd_sc_hd__decap_3
XFILLER_47_264 VGND VGND VPWR VPWR sky130_fd_sc_hd__decap_3
XFILLER_62_212 VGND VGND VPWR VPWR sky130_fd_sc_hd__decap_3
XTAP_TAPCELL_ROW_45_410 VGND VPWR sky130_fd_sc_hd__tapvpwrvgnd_1
XFILLER_62_245 VGND VGND VPWR VPWR sky130_fd_sc_hd__decap_3
XFILLER_62_256 VGND VGND VPWR VPWR sky130_fd_sc_hd__decap_3
XFILLER_46_91 VGND VGND VPWR VPWR sky130_fd_sc_hd__decap_3
XFILLER_46_80 VGND VGND VPWR VPWR sky130_fd_sc_hd__decap_3
XFILLER_15_161 VGND VGND VPWR VPWR sky130_fd_sc_hd__decap_3
XFILLER_22_109 VGND VGND VPWR VPWR sky130_fd_sc_hd__decap_3
XFILLER_62_289 VGND VGND VPWR VPWR sky130_fd_sc_hd__decap_3
XFILLER_15_172 VGND VGND VPWR VPWR sky130_fd_sc_hd__decap_3
XFILLER_30_153 VGND VGND VPWR VPWR sky130_fd_sc_hd__decap_3
XFILLER_7_30 VGND VGND VPWR VPWR sky130_fd_sc_hd__decap_3
XFILLER_30_197 VGND VGND VPWR VPWR sky130_fd_sc_hd__decap_3
XFILLER_30_186 VGND VGND VPWR VPWR sky130_fd_sc_hd__decap_3
XFILLER_7_382 VGND VGND VPWR VPWR sky130_fd_sc_hd__decap_3
XFILLER_7_85 VGND VGND VPWR VPWR sky130_fd_sc_hd__decap_3
XFILLER_26_404 VGND VGND VPWR VPWR sky130_fd_sc_hd__decap_3
XFILLER_38_253 VGND VGND VPWR VPWR sky130_fd_sc_hd__decap_3
XFILLER_38_242 VGND VGND VPWR VPWR sky130_fd_sc_hd__decap_3
XFILLER_53_223 VGND VGND VPWR VPWR sky130_fd_sc_hd__fill_1
XFILLER_38_286 VGND VGND VPWR VPWR sky130_fd_sc_hd__decap_3
XFILLER_53_234 VGND VGND VPWR VPWR sky130_fd_sc_hd__decap_3
XFILLER_53_267 VGND VGND VPWR VPWR sky130_fd_sc_hd__decap_3
XFILLER_21_131 VGND VGND VPWR VPWR sky130_fd_sc_hd__decap_3
XFILLER_21_153 VGND VGND VPWR VPWR sky130_fd_sc_hd__decap_3
XFILLER_42_38 VGND VGND VPWR VPWR sky130_fd_sc_hd__decap_3
XFILLER_42_27 VGND VGND VPWR VPWR sky130_fd_sc_hd__fill_1
XFILLER_21_175 VGND VGND VPWR VPWR sky130_fd_sc_hd__decap_3
XFILLER_21_197 VGND VGND VPWR VPWR sky130_fd_sc_hd__decap_3
XPHY_EDGE_ROW_7_2_Right_93 VGND VGND VPWR VPWR sky130_fd_sc_hd__decap_3
XFILLER_29_220 VGND VGND VPWR VPWR sky130_fd_sc_hd__decap_3
XFILLER_29_264 VGND VGND VPWR VPWR sky130_fd_sc_hd__decap_3
XFILLER_29_231 VGND VGND VPWR VPWR sky130_fd_sc_hd__decap_3
XFILLER_44_212 VGND VGND VPWR VPWR sky130_fd_sc_hd__decap_3
XFILLER_44_256 VGND VGND VPWR VPWR sky130_fd_sc_hd__decap_3
XFILLER_44_245 VGND VGND VPWR VPWR sky130_fd_sc_hd__decap_3
XFILLER_16_50 VGND VGND VPWR VPWR sky130_fd_sc_hd__decap_3
XFILLER_44_289 VGND VGND VPWR VPWR sky130_fd_sc_hd__decap_3
XFILLER_16_83 VGND VGND VPWR VPWR sky130_fd_sc_hd__fill_1
XFILLER_12_153 VGND VGND VPWR VPWR sky130_fd_sc_hd__decap_3
XFILLER_8_124 VGND VGND VPWR VPWR sky130_fd_sc_hd__decap_3
XFILLER_8_168 VGND VGND VPWR VPWR sky130_fd_sc_hd__decap_3
XFILLER_4_352 VGND VGND VPWR VPWR sky130_fd_sc_hd__fill_1
XFILLER_4_363 VGND VGND VPWR VPWR sky130_fd_sc_hd__decap_3
XFILLER_4_396 VGND VGND VPWR VPWR sky130_fd_sc_hd__decap_3
XFILLER_35_234 VGND VGND VPWR VPWR sky130_fd_sc_hd__decap_3
XFILLER_35_223 VGND VGND VPWR VPWR sky130_fd_sc_hd__fill_1
XFILLER_50_215 VGND VGND VPWR VPWR sky130_fd_sc_hd__decap_3
XFILLER_35_267 VGND VGND VPWR VPWR sky130_fd_sc_hd__decap_3
XFILLER_50_248 VGND VGND VPWR VPWR sky130_fd_sc_hd__decap_3
XFILLER_50_259 VGND VGND VPWR VPWR sky130_fd_sc_hd__decap_3
XFILLER_58_315 VGND VGND VPWR VPWR sky130_fd_sc_hd__decap_3
XFILLER_58_304 VGND VGND VPWR VPWR sky130_fd_sc_hd__decap_3
XFILLER_58_348 VGND VGND VPWR VPWR sky130_fd_sc_hd__decap_3
XFILLER_37_49 VGND VGND VPWR VPWR sky130_fd_sc_hd__fill_2
XFILLER_26_212 VGND VGND VPWR VPWR sky130_fd_sc_hd__decap_3
XFILLER_26_245 VGND VGND VPWR VPWR sky130_fd_sc_hd__decap_3
XFILLER_26_256 VGND VGND VPWR VPWR sky130_fd_sc_hd__decap_3
XFILLER_26_289 VGND VGND VPWR VPWR sky130_fd_sc_hd__decap_3
XFILLER_53_15 VGND VGND VPWR VPWR sky130_fd_sc_hd__fill_2
XFILLER_53_37 VGND VGND VPWR VPWR sky130_fd_sc_hd__decap_3
XFILLER_41_237 VGND VGND VPWR VPWR sky130_fd_sc_hd__decap_3
XFILLER_5_116 VGND VGND VPWR VPWR sky130_fd_sc_hd__decap_3
XFILLER_5_149 VGND VGND VPWR VPWR sky130_fd_sc_hd__decap_3
XFILLER_1_355 VGND VGND VPWR VPWR sky130_fd_sc_hd__decap_3
XFILLER_1_388 VGND VGND VPWR VPWR sky130_fd_sc_hd__decap_3
XFILLER_49_337 VGND VGND VPWR VPWR sky130_fd_sc_hd__decap_3
XFILLER_49_326 VGND VGND VPWR VPWR sky130_fd_sc_hd__decap_3
XFILLER_64_329 VGND VGND VPWR VPWR sky130_fd_sc_hd__decap_3
XFILLER_57_370 VGND VGND VPWR VPWR sky130_fd_sc_hd__decap_3
XFILLER_27_60 VGND VGND VPWR VPWR sky130_fd_sc_hd__decap_3
XFILLER_27_93 VGND VGND VPWR VPWR sky130_fd_sc_hd__decap_3
XTAP_TAPCELL_ROW_27_284 VGND VPWR sky130_fd_sc_hd__tapvpwrvgnd_1
XFILLER_32_248 VGND VGND VPWR VPWR sky130_fd_sc_hd__decap_3
XFILLER_32_215 VGND VGND VPWR VPWR sky130_fd_sc_hd__decap_3
XFILLER_9_400 VGND VGND VPWR VPWR sky130_fd_sc_hd__decap_3
XFILLER_32_259 VGND VGND VPWR VPWR sky130_fd_sc_hd__decap_3
XFILLER_43_81 VGND VGND VPWR VPWR sky130_fd_sc_hd__decap_3
XFILLER_40_292 VGND VGND VPWR VPWR sky130_fd_sc_hd__decap_3
XFILLER_4_171 VGND VGND VPWR VPWR sky130_fd_sc_hd__decap_3
XFILLER_4_53 VGND VGND VPWR VPWR sky130_fd_sc_hd__decap_3
XFILLER_4_97 VGND VGND VPWR VPWR sky130_fd_sc_hd__fill_1
XFILLER_55_329 VGND VGND VPWR VPWR sky130_fd_sc_hd__decap_3
XFILLER_63_340 VGND VGND VPWR VPWR sky130_fd_sc_hd__decap_3
XTAP_TAPCELL_ROW_19_2_580 VGND VPWR sky130_fd_sc_hd__tapvpwrvgnd_1
XFILLER_48_392 VGND VGND VPWR VPWR sky130_fd_sc_hd__decap_3
XFILLER_63_373 VGND VGND VPWR VPWR sky130_fd_sc_hd__decap_3
XFILLER_23_237 VGND VGND VPWR VPWR sky130_fd_sc_hd__decap_3
XTAP_TAPCELL_ROW_9_2_570 VGND VPWR sky130_fd_sc_hd__tapvpwrvgnd_1
XFILLER_31_270 VGND VGND VPWR VPWR sky130_fd_sc_hd__decap_3
XFILLER_31_281 VGND VGND VPWR VPWR sky130_fd_sc_hd__decap_3
XFILLER_48_15 VGND VGND VPWR VPWR sky130_fd_sc_hd__decap_3
XFILLER_58_156 VGND VGND VPWR VPWR sky130_fd_sc_hd__decap_3
XFILLER_58_134 VGND VGND VPWR VPWR sky130_fd_sc_hd__decap_3
XFILLER_46_307 VGND VGND VPWR VPWR sky130_fd_sc_hd__fill_1
XPHY_EDGE_ROW_6_1_Right_5 VGND VGND VPWR VPWR sky130_fd_sc_hd__decap_3
XFILLER_58_189 VGND VGND VPWR VPWR sky130_fd_sc_hd__decap_3
XFILLER_46_318 VGND VGND VPWR VPWR sky130_fd_sc_hd__decap_3
XFILLER_39_370 VGND VGND VPWR VPWR sky130_fd_sc_hd__decap_3
XFILLER_64_14 VGND VGND VPWR VPWR sky130_fd_sc_hd__decap_3
XFILLER_64_47 VGND VGND VPWR VPWR sky130_fd_sc_hd__decap_3
XFILLER_64_69 VGND VGND VPWR VPWR sky130_fd_sc_hd__decap_3
XFILLER_54_351 VGND VGND VPWR VPWR sky130_fd_sc_hd__decap_3
XFILLER_54_395 VGND VGND VPWR VPWR sky130_fd_sc_hd__decap_3
XTAP_TAPCELL_ROW_24_265 VGND VPWR sky130_fd_sc_hd__tapvpwrvgnd_1
X_251_ net60 VGND VGND VPWR VPWR _046_ sky130_fd_sc_hd__inv_2
XFILLER_13_40 VGND VGND VPWR VPWR sky130_fd_sc_hd__decap_3
XFILLER_22_292 VGND VGND VPWR VPWR sky130_fd_sc_hd__decap_3
X_182_ _093_ _094_ VGND VGND VPWR VPWR _095_ sky130_fd_sc_hd__nand2_1
XFILLER_13_84 VGND VGND VPWR VPWR sky130_fd_sc_hd__decap_3
XPHY_EDGE_ROW_23_Left_129 VGND VGND VPWR VPWR sky130_fd_sc_hd__decap_3
XFILLER_1_152 VGND VGND VPWR VPWR sky130_fd_sc_hd__decap_3
XPHY_EDGE_ROW_39_Right_60 VGND VGND VPWR VPWR sky130_fd_sc_hd__decap_3
XFILLER_29_9 VGND VGND VPWR VPWR sky130_fd_sc_hd__decap_3
XFILLER_49_134 VGND VGND VPWR VPWR sky130_fd_sc_hd__decap_3
XFILLER_49_178 VGND VGND VPWR VPWR sky130_fd_sc_hd__decap_3
XFILLER_49_167 VGND VGND VPWR VPWR sky130_fd_sc_hd__fill_1
XFILLER_37_329 VGND VGND VPWR VPWR sky130_fd_sc_hd__decap_3
XFILLER_64_137 VGND VGND VPWR VPWR sky130_fd_sc_hd__decap_3
XFILLER_64_159 VGND VGND VPWR VPWR sky130_fd_sc_hd__decap_3
XPHY_EDGE_ROW_32_Left_138 VGND VGND VPWR VPWR sky130_fd_sc_hd__decap_3
XFILLER_45_340 VGND VGND VPWR VPWR sky130_fd_sc_hd__decap_3
XFILLER_60_321 VGND VGND VPWR VPWR sky130_fd_sc_hd__decap_3
XFILLER_45_373 VGND VGND VPWR VPWR sky130_fd_sc_hd__decap_3
XFILLER_60_365 VGND VGND VPWR VPWR sky130_fd_sc_hd__decap_3
XFILLER_60_354 VGND VGND VPWR VPWR sky130_fd_sc_hd__decap_3
XFILLER_54_91 VGND VGND VPWR VPWR sky130_fd_sc_hd__decap_3
XFILLER_54_80 VGND VGND VPWR VPWR sky130_fd_sc_hd__decap_3
XFILLER_60_398 VGND VGND VPWR VPWR sky130_fd_sc_hd__decap_3
XPHY_EDGE_ROW_41_Left_147 VGND VGND VPWR VPWR sky130_fd_sc_hd__decap_3
XFILLER_18_18 VGND VGND VPWR VPWR sky130_fd_sc_hd__decap_3
XPHY_EDGE_ROW_50_Left_156 VGND VGND VPWR VPWR sky130_fd_sc_hd__decap_3
XFILLER_28_318 VGND VGND VPWR VPWR sky130_fd_sc_hd__decap_3
XFILLER_28_307 VGND VGND VPWR VPWR sky130_fd_sc_hd__fill_1
XFILLER_55_137 VGND VGND VPWR VPWR sky130_fd_sc_hd__decap_3
XFILLER_36_351 VGND VGND VPWR VPWR sky130_fd_sc_hd__decap_3
XFILLER_63_181 VGND VGND VPWR VPWR sky130_fd_sc_hd__decap_3
XFILLER_36_395 VGND VGND VPWR VPWR sky130_fd_sc_hd__decap_3
XFILLER_51_343 VGND VGND VPWR VPWR sky130_fd_sc_hd__decap_3
XFILLER_51_332 VGND VGND VPWR VPWR sky130_fd_sc_hd__decap_3
XFILLER_51_376 VGND VGND VPWR VPWR sky130_fd_sc_hd__decap_3
XTAP_TAPCELL_ROW_21_235 VGND VPWR sky130_fd_sc_hd__tapvpwrvgnd_1
XFILLER_50_38 VGND VGND VPWR VPWR sky130_fd_sc_hd__decap_3
XFILLER_50_27 VGND VGND VPWR VPWR sky130_fd_sc_hd__fill_1
XFILLER_3_406 VGND VGND VPWR VPWR sky130_fd_sc_hd__fill_1
XFILLER_59_36 VGND VGND VPWR VPWR sky130_fd_sc_hd__decap_3
XFILLER_59_69 VGND VGND VPWR VPWR sky130_fd_sc_hd__decap_3
XFILLER_46_115 VGND VGND VPWR VPWR sky130_fd_sc_hd__decap_3
XFILLER_27_340 VGND VGND VPWR VPWR sky130_fd_sc_hd__decap_3
XFILLER_46_159 VGND VGND VPWR VPWR sky130_fd_sc_hd__decap_3
XFILLER_27_373 VGND VGND VPWR VPWR sky130_fd_sc_hd__decap_3
XFILLER_42_321 VGND VGND VPWR VPWR sky130_fd_sc_hd__decap_3
XFILLER_54_192 VGND VGND VPWR VPWR sky130_fd_sc_hd__decap_3
XFILLER_42_354 VGND VGND VPWR VPWR sky130_fd_sc_hd__decap_3
XFILLER_24_50 VGND VGND VPWR VPWR sky130_fd_sc_hd__decap_3
X_303_ clknet_2_3__leaf_clk_regs net23 _048_ VGND VGND VPWR VPWR genblk1\[15\].fa_inst.b
+ sky130_fd_sc_hd__dfrtp_1
XFILLER_42_398 VGND VGND VPWR VPWR sky130_fd_sc_hd__decap_3
XFILLER_42_365 VGND VGND VPWR VPWR sky130_fd_sc_hd__decap_3
XFILLER_24_83 VGND VGND VPWR VPWR sky130_fd_sc_hd__fill_1
X_234_ net59 VGND VGND VPWR VPWR _029_ sky130_fd_sc_hd__inv_2
X_165_ genblk1\[8\].fa_inst.b genblk1\[8\].fa_inst.a VGND VGND VPWR VPWR _081_ sky130_fd_sc_hd__or2_1
XFILLER_40_82 VGND VGND VPWR VPWR sky130_fd_sc_hd__fill_2
XFILLER_27_6 VGND VGND VPWR VPWR sky130_fd_sc_hd__decap_3
XFILLER_49_91 VGND VGND VPWR VPWR sky130_fd_sc_hd__decap_3
XFILLER_1_21 VGND VGND VPWR VPWR sky130_fd_sc_hd__decap_3
XFILLER_37_104 VGND VGND VPWR VPWR sky130_fd_sc_hd__decap_3
XFILLER_1_54 VGND VGND VPWR VPWR sky130_fd_sc_hd__fill_2
XFILLER_37_137 VGND VGND VPWR VPWR sky130_fd_sc_hd__decap_3
XFILLER_18_340 VGND VGND VPWR VPWR sky130_fd_sc_hd__decap_3
XFILLER_1_87 VGND VGND VPWR VPWR sky130_fd_sc_hd__decap_3
XFILLER_18_384 VGND VGND VPWR VPWR sky130_fd_sc_hd__decap_3
XFILLER_45_181 VGND VGND VPWR VPWR sky130_fd_sc_hd__decap_3
XTAP_TAPCELL_ROW_35_338 VGND VPWR sky130_fd_sc_hd__tapvpwrvgnd_1
XFILLER_33_343 VGND VGND VPWR VPWR sky130_fd_sc_hd__decap_3
XFILLER_33_332 VGND VGND VPWR VPWR sky130_fd_sc_hd__decap_3
XFILLER_60_162 VGND VGND VPWR VPWR sky130_fd_sc_hd__decap_3
XFILLER_33_376 VGND VGND VPWR VPWR sky130_fd_sc_hd__decap_3
XTAP_TAPCELL_ROW_43_393 VGND VPWR sky130_fd_sc_hd__tapvpwrvgnd_1
XFILLER_60_195 VGND VGND VPWR VPWR sky130_fd_sc_hd__fill_1
XFILLER_29_39 VGND VGND VPWR VPWR sky130_fd_sc_hd__decap_3
XFILLER_28_126 VGND VGND VPWR VPWR sky130_fd_sc_hd__decap_3
XFILLER_24_321 VGND VGND VPWR VPWR sky130_fd_sc_hd__decap_3
XFILLER_24_354 VGND VGND VPWR VPWR sky130_fd_sc_hd__decap_3
XFILLER_36_192 VGND VGND VPWR VPWR sky130_fd_sc_hd__decap_3
XFILLER_24_365 VGND VGND VPWR VPWR sky130_fd_sc_hd__decap_3
XFILLER_61_15 VGND VGND VPWR VPWR sky130_fd_sc_hd__decap_3
XFILLER_51_140 VGND VGND VPWR VPWR sky130_fd_sc_hd__decap_3
XFILLER_24_398 VGND VGND VPWR VPWR sky130_fd_sc_hd__decap_3
XFILLER_61_48 VGND VGND VPWR VPWR sky130_fd_sc_hd__decap_3
XFILLER_51_184 VGND VGND VPWR VPWR sky130_fd_sc_hd__decap_3
XFILLER_10_41 VGND VGND VPWR VPWR sky130_fd_sc_hd__decap_3
XFILLER_10_74 VGND VGND VPWR VPWR sky130_fd_sc_hd__decap_3
XFILLER_10_85 VGND VGND VPWR VPWR sky130_fd_sc_hd__decap_3
XFILLER_59_240 VGND VGND VPWR VPWR sky130_fd_sc_hd__decap_3
XFILLER_59_273 VGND VGND VPWR VPWR sky130_fd_sc_hd__decap_3
XFILLER_47_402 VGND VGND VPWR VPWR sky130_fd_sc_hd__decap_3
XFILLER_19_137 VGND VGND VPWR VPWR sky130_fd_sc_hd__decap_3
XFILLER_19_72 VGND VGND VPWR VPWR sky130_fd_sc_hd__decap_3
XFILLER_59_284 VGND VGND VPWR VPWR sky130_fd_sc_hd__decap_3
XTAP_TAPCELL_ROW_57_496 VGND VPWR sky130_fd_sc_hd__tapvpwrvgnd_1
XFILLER_34_118 VGND VGND VPWR VPWR sky130_fd_sc_hd__decap_3
XFILLER_15_343 VGND VGND VPWR VPWR sky130_fd_sc_hd__decap_3
XFILLER_27_181 VGND VGND VPWR VPWR sky130_fd_sc_hd__decap_3
XFILLER_35_60 VGND VGND VPWR VPWR sky130_fd_sc_hd__decap_3
XFILLER_15_376 VGND VGND VPWR VPWR sky130_fd_sc_hd__decap_3
XTAP_TAPCELL_ROW_32_319 VGND VPWR sky130_fd_sc_hd__tapvpwrvgnd_1
XFILLER_42_162 VGND VGND VPWR VPWR sky130_fd_sc_hd__decap_3
XFILLER_35_93 VGND VGND VPWR VPWR sky130_fd_sc_hd__decap_3
XFILLER_42_195 VGND VGND VPWR VPWR sky130_fd_sc_hd__fill_1
XFILLER_30_324 VGND VGND VPWR VPWR sky130_fd_sc_hd__decap_3
XFILLER_30_368 VGND VGND VPWR VPWR sky130_fd_sc_hd__decap_3
XFILLER_30_357 VGND VGND VPWR VPWR sky130_fd_sc_hd__decap_3
XTAP_TAPCELL_ROW_40_374 VGND VPWR sky130_fd_sc_hd__tapvpwrvgnd_1
X_217_ net60 VGND VGND VPWR VPWR _012_ sky130_fd_sc_hd__inv_2
X_148_ _061_ _064_ _062_ VGND VGND VPWR VPWR _068_ sky130_fd_sc_hd__a21bo_1
XFILLER_51_92 VGND VGND VPWR VPWR sky130_fd_sc_hd__decap_3
XFILLER_25_3 VGND VGND VPWR VPWR sky130_fd_sc_hd__decap_3
XTAP_TAPCELL_ROW_48_430 VGND VPWR sky130_fd_sc_hd__tapvpwrvgnd_1
XFILLER_21_302 VGND VGND VPWR VPWR sky130_fd_sc_hd__decap_3
XFILLER_33_140 VGND VGND VPWR VPWR sky130_fd_sc_hd__decap_3
XFILLER_21_324 VGND VGND VPWR VPWR sky130_fd_sc_hd__decap_3
XFILLER_21_346 VGND VGND VPWR VPWR sky130_fd_sc_hd__decap_3
XFILLER_33_184 VGND VGND VPWR VPWR sky130_fd_sc_hd__decap_3
XFILLER_21_368 VGND VGND VPWR VPWR sky130_fd_sc_hd__decap_3
XFILLER_56_221 VGND VGND VPWR VPWR sky130_fd_sc_hd__decap_3
XFILLER_56_15 VGND VGND VPWR VPWR sky130_fd_sc_hd__decap_3
XFILLER_56_59 VGND VGND VPWR VPWR sky130_fd_sc_hd__decap_3
XFILLER_56_265 VGND VGND VPWR VPWR sky130_fd_sc_hd__decap_3
XFILLER_56_298 VGND VGND VPWR VPWR sky130_fd_sc_hd__decap_3
XFILLER_24_162 VGND VGND VPWR VPWR sky130_fd_sc_hd__decap_3
XFILLER_24_195 VGND VGND VPWR VPWR sky130_fd_sc_hd__fill_1
XFILLER_12_346 VGND VGND VPWR VPWR sky130_fd_sc_hd__decap_3
XFILLER_12_357 VGND VGND VPWR VPWR sky130_fd_sc_hd__decap_3
XFILLER_8_328 VGND VGND VPWR VPWR sky130_fd_sc_hd__decap_3
XFILLER_20_390 VGND VGND VPWR VPWR sky130_fd_sc_hd__decap_3
XFILLER_11_9 VGND VGND VPWR VPWR sky130_fd_sc_hd__decap_3
XFILLER_47_243 VGND VGND VPWR VPWR sky130_fd_sc_hd__decap_3
XFILLER_35_405 VGND VGND VPWR VPWR sky130_fd_sc_hd__fill_2
XFILLER_62_224 VGND VGND VPWR VPWR sky130_fd_sc_hd__decap_3
XTAP_TAPCELL_ROW_45_411 VGND VPWR sky130_fd_sc_hd__tapvpwrvgnd_1
XFILLER_47_287 VGND VGND VPWR VPWR sky130_fd_sc_hd__decap_3
XFILLER_47_276 VGND VGND VPWR VPWR sky130_fd_sc_hd__decap_3
XFILLER_15_140 VGND VGND VPWR VPWR sky130_fd_sc_hd__decap_3
XFILLER_62_268 VGND VGND VPWR VPWR sky130_fd_sc_hd__decap_3
XFILLER_30_121 VGND VGND VPWR VPWR sky130_fd_sc_hd__decap_3
XFILLER_62_80 VGND VGND VPWR VPWR sky130_fd_sc_hd__decap_3
XFILLER_62_91 VGND VGND VPWR VPWR sky130_fd_sc_hd__decap_3
XFILLER_30_165 VGND VGND VPWR VPWR sky130_fd_sc_hd__decap_3
XFILLER_7_42 VGND VGND VPWR VPWR sky130_fd_sc_hd__decap_3
XFILLER_7_361 VGND VGND VPWR VPWR sky130_fd_sc_hd__decap_3
XFILLER_7_97 VGND VGND VPWR VPWR sky130_fd_sc_hd__decap_3
XFILLER_7_394 VGND VGND VPWR VPWR sky130_fd_sc_hd__decap_3
XFILLER_38_221 VGND VGND VPWR VPWR sky130_fd_sc_hd__decap_3
XFILLER_26_18 VGND VGND VPWR VPWR sky130_fd_sc_hd__decap_3
XFILLER_53_202 VGND VGND VPWR VPWR sky130_fd_sc_hd__decap_3
XFILLER_38_298 VGND VGND VPWR VPWR sky130_fd_sc_hd__decap_3
XFILLER_38_265 VGND VGND VPWR VPWR sky130_fd_sc_hd__decap_3
XFILLER_53_246 VGND VGND VPWR VPWR sky130_fd_sc_hd__decap_3
XFILLER_53_279 VGND VGND VPWR VPWR sky130_fd_sc_hd__fill_1
XFILLER_61_290 VGND VGND VPWR VPWR sky130_fd_sc_hd__decap_3
XFILLER_21_165 VGND VGND VPWR VPWR sky130_fd_sc_hd__decap_3
XFILLER_21_187 VGND VGND VPWR VPWR sky130_fd_sc_hd__decap_3
XFILLER_29_243 VGND VGND VPWR VPWR sky130_fd_sc_hd__decap_3
XFILLER_29_287 VGND VGND VPWR VPWR sky130_fd_sc_hd__decap_3
XFILLER_29_276 VGND VGND VPWR VPWR sky130_fd_sc_hd__decap_3
XFILLER_44_224 VGND VGND VPWR VPWR sky130_fd_sc_hd__decap_3
XFILLER_16_62 VGND VGND VPWR VPWR sky130_fd_sc_hd__decap_3
XFILLER_44_268 VGND VGND VPWR VPWR sky130_fd_sc_hd__decap_3
XFILLER_12_121 VGND VGND VPWR VPWR sky130_fd_sc_hd__decap_3
XFILLER_12_165 VGND VGND VPWR VPWR sky130_fd_sc_hd__decap_3
XFILLER_8_136 VGND VGND VPWR VPWR sky130_fd_sc_hd__decap_3
XFILLER_8_147 VGND VGND VPWR VPWR sky130_fd_sc_hd__decap_3
XFILLER_32_50 VGND VGND VPWR VPWR sky130_fd_sc_hd__decap_3
XFILLER_59_9 VGND VGND VPWR VPWR sky130_fd_sc_hd__decap_3
XFILLER_4_331 VGND VGND VPWR VPWR sky130_fd_sc_hd__decap_3
XFILLER_4_375 VGND VGND VPWR VPWR sky130_fd_sc_hd__decap_3
XFILLER_35_202 VGND VGND VPWR VPWR sky130_fd_sc_hd__decap_3
XFILLER_35_246 VGND VGND VPWR VPWR sky130_fd_sc_hd__decap_3
XFILLER_35_279 VGND VGND VPWR VPWR sky130_fd_sc_hd__fill_1
XFILLER_50_227 VGND VGND VPWR VPWR sky130_fd_sc_hd__decap_3
XFILLER_43_290 VGND VGND VPWR VPWR sky130_fd_sc_hd__decap_3
XFILLER_58_327 VGND VGND VPWR VPWR sky130_fd_sc_hd__decap_3
XFILLER_26_224 VGND VGND VPWR VPWR sky130_fd_sc_hd__decap_3
XFILLER_26_268 VGND VGND VPWR VPWR sky130_fd_sc_hd__decap_3
XTAP_TAPCELL_ROW_64_550 VGND VPWR sky130_fd_sc_hd__tapvpwrvgnd_1
XFILLER_41_205 VGND VGND VPWR VPWR sky130_fd_sc_hd__decap_3
XFILLER_53_49 VGND VGND VPWR VPWR sky130_fd_sc_hd__decap_3
XFILLER_41_249 VGND VGND VPWR VPWR sky130_fd_sc_hd__decap_3
XFILLER_5_128 VGND VGND VPWR VPWR sky130_fd_sc_hd__decap_3
XFILLER_5_106 VGND VGND VPWR VPWR sky130_fd_sc_hd__decap_3
XFILLER_1_334 VGND VGND VPWR VPWR sky130_fd_sc_hd__decap_3
XFILLER_1_367 VGND VGND VPWR VPWR sky130_fd_sc_hd__decap_3
XFILLER_49_305 VGND VGND VPWR VPWR sky130_fd_sc_hd__decap_3
XFILLER_49_349 VGND VGND VPWR VPWR sky130_fd_sc_hd__decap_3
XTAP_TAPCELL_ROW_10_1_199 VGND VPWR sky130_fd_sc_hd__tapvpwrvgnd_1
XFILLER_27_50 VGND VGND VPWR VPWR sky130_fd_sc_hd__decap_3
XFILLER_27_72 VGND VGND VPWR VPWR sky130_fd_sc_hd__decap_3
XFILLER_57_393 VGND VGND VPWR VPWR sky130_fd_sc_hd__decap_3
XFILLER_57_382 VGND VGND VPWR VPWR sky130_fd_sc_hd__decap_3
XTAP_TAPCELL_ROW_27_285 VGND VPWR sky130_fd_sc_hd__tapvpwrvgnd_1
XFILLER_32_227 VGND VGND VPWR VPWR sky130_fd_sc_hd__decap_3
XFILLER_25_290 VGND VGND VPWR VPWR sky130_fd_sc_hd__decap_3
XFILLER_43_60 VGND VGND VPWR VPWR sky130_fd_sc_hd__decap_3
XFILLER_40_271 VGND VGND VPWR VPWR sky130_fd_sc_hd__decap_3
XFILLER_57_6 VGND VGND VPWR VPWR sky130_fd_sc_hd__decap_3
XFILLER_4_150 VGND VGND VPWR VPWR sky130_fd_sc_hd__decap_3
XFILLER_4_32 VGND VGND VPWR VPWR sky130_fd_sc_hd__decap_3
XFILLER_4_65 VGND VGND VPWR VPWR sky130_fd_sc_hd__decap_3
XFILLER_55_308 VGND VGND VPWR VPWR sky130_fd_sc_hd__decap_3
XFILLER_48_371 VGND VGND VPWR VPWR sky130_fd_sc_hd__decap_3
XFILLER_48_360 VGND VGND VPWR VPWR sky130_fd_sc_hd__decap_3
XFILLER_23_205 VGND VGND VPWR VPWR sky130_fd_sc_hd__decap_3
XFILLER_63_352 VGND VGND VPWR VPWR sky130_fd_sc_hd__decap_3
XFILLER_63_385 VGND VGND VPWR VPWR sky130_fd_sc_hd__decap_3
XFILLER_63_396 VGND VGND VPWR VPWR sky130_fd_sc_hd__decap_3
XTAP_TAPCELL_ROW_61_520 VGND VPWR sky130_fd_sc_hd__tapvpwrvgnd_1
XFILLER_23_249 VGND VGND VPWR VPWR sky130_fd_sc_hd__decap_3
XFILLER_31_293 VGND VGND VPWR VPWR sky130_fd_sc_hd__decap_3
XFILLER_2_109 VGND VGND VPWR VPWR sky130_fd_sc_hd__decap_3
XFILLER_48_49 VGND VGND VPWR VPWR sky130_fd_sc_hd__decap_3
XFILLER_48_27 VGND VGND VPWR VPWR sky130_fd_sc_hd__fill_1
XFILLER_58_168 VGND VGND VPWR VPWR sky130_fd_sc_hd__decap_3
XFILLER_64_26 VGND VGND VPWR VPWR sky130_fd_sc_hd__fill_2
XFILLER_54_330 VGND VGND VPWR VPWR sky130_fd_sc_hd__decap_3
XFILLER_39_393 VGND VGND VPWR VPWR sky130_fd_sc_hd__decap_3
XFILLER_39_382 VGND VGND VPWR VPWR sky130_fd_sc_hd__decap_3
XFILLER_54_363 VGND VGND VPWR VPWR sky130_fd_sc_hd__fill_1
XFILLER_54_374 VGND VGND VPWR VPWR sky130_fd_sc_hd__decap_3
XTAP_TAPCELL_ROW_24_266 VGND VPWR sky130_fd_sc_hd__tapvpwrvgnd_1
X_250_ net60 VGND VGND VPWR VPWR _045_ sky130_fd_sc_hd__inv_2
XFILLER_22_271 VGND VGND VPWR VPWR sky130_fd_sc_hd__decap_3
X_181_ genblk1\[11\].fa_inst.b genblk1\[11\].fa_inst.a VGND VGND VPWR VPWR _094_ sky130_fd_sc_hd__nand2_1
XFILLER_13_52 VGND VGND VPWR VPWR sky130_fd_sc_hd__decap_3
XFILLER_13_63 VGND VGND VPWR VPWR sky130_fd_sc_hd__fill_2
XFILLER_1_131 VGND VGND VPWR VPWR sky130_fd_sc_hd__decap_3
XFILLER_1_164 VGND VGND VPWR VPWR sky130_fd_sc_hd__decap_3
XFILLER_1_175 VGND VGND VPWR VPWR sky130_fd_sc_hd__decap_3
XFILLER_49_113 VGND VGND VPWR VPWR sky130_fd_sc_hd__decap_3
XFILLER_49_146 VGND VGND VPWR VPWR sky130_fd_sc_hd__decap_3
XFILLER_64_116 VGND VGND VPWR VPWR sky130_fd_sc_hd__decap_3
XFILLER_37_308 VGND VGND VPWR VPWR sky130_fd_sc_hd__decap_3
XFILLER_38_82 VGND VGND VPWR VPWR sky130_fd_sc_hd__fill_2
XFILLER_57_190 VGND VGND VPWR VPWR sky130_fd_sc_hd__decap_3
XFILLER_45_352 VGND VGND VPWR VPWR sky130_fd_sc_hd__decap_3
XFILLER_45_396 VGND VGND VPWR VPWR sky130_fd_sc_hd__decap_3
XFILLER_45_385 VGND VGND VPWR VPWR sky130_fd_sc_hd__decap_3
XFILLER_60_333 VGND VGND VPWR VPWR sky130_fd_sc_hd__decap_3
XFILLER_60_377 VGND VGND VPWR VPWR sky130_fd_sc_hd__decap_3
XFILLER_55_3 VGND VGND VPWR VPWR sky130_fd_sc_hd__decap_3
XFILLER_55_116 VGND VGND VPWR VPWR sky130_fd_sc_hd__decap_3
XFILLER_55_105 VGND VGND VPWR VPWR sky130_fd_sc_hd__decap_3
XFILLER_55_149 VGND VGND VPWR VPWR sky130_fd_sc_hd__decap_3
XTAP_TAPCELL_ROW_38_358 VGND VPWR sky130_fd_sc_hd__tapvpwrvgnd_1
XFILLER_36_363 VGND VGND VPWR VPWR sky130_fd_sc_hd__fill_1
XFILLER_36_330 VGND VGND VPWR VPWR sky130_fd_sc_hd__decap_3
XFILLER_51_311 VGND VGND VPWR VPWR sky130_fd_sc_hd__decap_3
XFILLER_36_374 VGND VGND VPWR VPWR sky130_fd_sc_hd__decap_3
XFILLER_34_18 VGND VGND VPWR VPWR sky130_fd_sc_hd__decap_3
XFILLER_63_193 VGND VGND VPWR VPWR sky130_fd_sc_hd__decap_3
XFILLER_51_355 VGND VGND VPWR VPWR sky130_fd_sc_hd__decap_3
XFILLER_51_388 VGND VGND VPWR VPWR sky130_fd_sc_hd__decap_3
XTAP_TAPCELL_ROW_21_236 VGND VPWR sky130_fd_sc_hd__tapvpwrvgnd_1
XFILLER_51_399 VGND VGND VPWR VPWR sky130_fd_sc_hd__decap_3
XFILLER_59_15 VGND VGND VPWR VPWR sky130_fd_sc_hd__decap_3
XFILLER_59_48 VGND VGND VPWR VPWR sky130_fd_sc_hd__decap_3
XFILLER_46_127 VGND VGND VPWR VPWR sky130_fd_sc_hd__decap_3
XFILLER_27_352 VGND VGND VPWR VPWR sky130_fd_sc_hd__decap_3
XFILLER_61_108 VGND VGND VPWR VPWR sky130_fd_sc_hd__decap_3
XFILLER_39_190 VGND VGND VPWR VPWR sky130_fd_sc_hd__decap_3
XFILLER_27_385 VGND VGND VPWR VPWR sky130_fd_sc_hd__decap_3
XFILLER_27_396 VGND VGND VPWR VPWR sky130_fd_sc_hd__decap_3
XFILLER_61_119 VGND VGND VPWR VPWR sky130_fd_sc_hd__decap_3
XFILLER_54_171 VGND VGND VPWR VPWR sky130_fd_sc_hd__decap_3
XFILLER_42_333 VGND VGND VPWR VPWR sky130_fd_sc_hd__decap_3
X_302_ clknet_2_2__leaf_clk_regs net22 _047_ VGND VGND VPWR VPWR genblk1\[14\].fa_inst.b
+ sky130_fd_sc_hd__dfrtp_1
XFILLER_42_377 VGND VGND VPWR VPWR sky130_fd_sc_hd__decap_3
XFILLER_24_62 VGND VGND VPWR VPWR sky130_fd_sc_hd__decap_3
X_233_ net59 VGND VGND VPWR VPWR _028_ sky130_fd_sc_hd__inv_2
X_164_ _079_ _080_ VGND VGND VPWR VPWR genblk1\[7\].fa_inst.s sky130_fd_sc_hd__xnor2_1
XPHY_EDGE_ROW_12_2_Right_98 VGND VGND VPWR VPWR sky130_fd_sc_hd__decap_3
XFILLER_40_50 VGND VGND VPWR VPWR sky130_fd_sc_hd__decap_3
XFILLER_41_9 VGND VGND VPWR VPWR sky130_fd_sc_hd__decap_3
XFILLER_1_33 VGND VGND VPWR VPWR sky130_fd_sc_hd__decap_3
XFILLER_37_116 VGND VGND VPWR VPWR sky130_fd_sc_hd__decap_3
XFILLER_18_352 VGND VGND VPWR VPWR sky130_fd_sc_hd__fill_1
XFILLER_1_66 VGND VGND VPWR VPWR sky130_fd_sc_hd__decap_3
XFILLER_1_99 VGND VGND VPWR VPWR sky130_fd_sc_hd__decap_3
XFILLER_37_149 VGND VGND VPWR VPWR sky130_fd_sc_hd__decap_3
XFILLER_18_363 VGND VGND VPWR VPWR sky130_fd_sc_hd__decap_3
XFILLER_33_311 VGND VGND VPWR VPWR sky130_fd_sc_hd__decap_3
XFILLER_18_396 VGND VGND VPWR VPWR sky130_fd_sc_hd__decap_3
XTAP_TAPCELL_ROW_35_339 VGND VPWR sky130_fd_sc_hd__tapvpwrvgnd_1
XFILLER_60_130 VGND VGND VPWR VPWR sky130_fd_sc_hd__decap_3
XFILLER_45_193 VGND VGND VPWR VPWR sky130_fd_sc_hd__decap_3
XFILLER_33_355 VGND VGND VPWR VPWR sky130_fd_sc_hd__decap_3
XFILLER_60_174 VGND VGND VPWR VPWR sky130_fd_sc_hd__decap_3
XFILLER_60_141 VGND VGND VPWR VPWR sky130_fd_sc_hd__decap_3
XFILLER_33_388 VGND VGND VPWR VPWR sky130_fd_sc_hd__decap_3
XTAP_TAPCELL_ROW_43_394 VGND VPWR sky130_fd_sc_hd__tapvpwrvgnd_1
XFILLER_33_399 VGND VGND VPWR VPWR sky130_fd_sc_hd__decap_3
XFILLER_28_138 VGND VGND VPWR VPWR sky130_fd_sc_hd__fill_2
XPHY_EDGE_ROW_58_Right_79 VGND VGND VPWR VPWR sky130_fd_sc_hd__decap_3
XFILLER_43_119 VGND VGND VPWR VPWR sky130_fd_sc_hd__decap_3
XFILLER_36_171 VGND VGND VPWR VPWR sky130_fd_sc_hd__decap_3
XFILLER_24_333 VGND VGND VPWR VPWR sky130_fd_sc_hd__decap_3
XFILLER_24_377 VGND VGND VPWR VPWR sky130_fd_sc_hd__decap_3
XFILLER_51_152 VGND VGND VPWR VPWR sky130_fd_sc_hd__decap_3
XPHY_EDGE_ROW_0_1_Right_20 VGND VGND VPWR VPWR sky130_fd_sc_hd__decap_3
XFILLER_61_27 VGND VGND VPWR VPWR sky130_fd_sc_hd__decap_3
XFILLER_51_196 VGND VGND VPWR VPWR sky130_fd_sc_hd__decap_3
XFILLER_10_53 VGND VGND VPWR VPWR sky130_fd_sc_hd__decap_3
XFILLER_10_64 VGND VGND VPWR VPWR sky130_fd_sc_hd__decap_3
XFILLER_10_97 VGND VGND VPWR VPWR sky130_fd_sc_hd__decap_3
XFILLER_19_40 VGND VGND VPWR VPWR sky130_fd_sc_hd__decap_3
XFILLER_59_252 VGND VGND VPWR VPWR sky130_fd_sc_hd__decap_3
XFILLER_19_116 VGND VGND VPWR VPWR sky130_fd_sc_hd__decap_3
XFILLER_59_296 VGND VGND VPWR VPWR sky130_fd_sc_hd__decap_3
XFILLER_19_149 VGND VGND VPWR VPWR sky130_fd_sc_hd__decap_3
XFILLER_19_84 VGND VGND VPWR VPWR sky130_fd_sc_hd__decap_3
XFILLER_27_193 VGND VGND VPWR VPWR sky130_fd_sc_hd__decap_3
XTAP_TAPCELL_ROW_57_497 VGND VPWR sky130_fd_sc_hd__tapvpwrvgnd_1
XFILLER_35_50 VGND VGND VPWR VPWR sky130_fd_sc_hd__decap_3
XFILLER_15_355 VGND VGND VPWR VPWR sky130_fd_sc_hd__decap_3
XFILLER_42_141 VGND VGND VPWR VPWR sky130_fd_sc_hd__decap_3
XFILLER_35_72 VGND VGND VPWR VPWR sky130_fd_sc_hd__decap_3
XFILLER_15_388 VGND VGND VPWR VPWR sky130_fd_sc_hd__decap_3
XFILLER_42_174 VGND VGND VPWR VPWR sky130_fd_sc_hd__decap_3
XFILLER_30_336 VGND VGND VPWR VPWR sky130_fd_sc_hd__decap_3
XTAP_TAPCELL_ROW_40_375 VGND VPWR sky130_fd_sc_hd__tapvpwrvgnd_1
X_216_ net61 VGND VGND VPWR VPWR _011_ sky130_fd_sc_hd__inv_2
XFILLER_51_60 VGND VGND VPWR VPWR sky130_fd_sc_hd__decap_3
X_147_ _065_ _066_ VGND VGND VPWR VPWR _067_ sky130_fd_sc_hd__nand2_1
XTAP_TAPCELL_ROW_48_431 VGND VPWR sky130_fd_sc_hd__tapvpwrvgnd_1
XFILLER_25_119 VGND VGND VPWR VPWR sky130_fd_sc_hd__decap_3
XFILLER_18_171 VGND VGND VPWR VPWR sky130_fd_sc_hd__decap_3
XFILLER_33_152 VGND VGND VPWR VPWR sky130_fd_sc_hd__decap_3
XFILLER_33_196 VGND VGND VPWR VPWR sky130_fd_sc_hd__decap_3
XFILLER_21_358 VGND VGND VPWR VPWR sky130_fd_sc_hd__decap_3
XFILLER_56_38 VGND VGND VPWR VPWR sky130_fd_sc_hd__decap_3
XFILLER_56_200 VGND VGND VPWR VPWR sky130_fd_sc_hd__decap_3
XFILLER_56_233 VGND VGND VPWR VPWR sky130_fd_sc_hd__decap_3
XFILLER_16_119 VGND VGND VPWR VPWR sky130_fd_sc_hd__decap_3
XFILLER_56_277 VGND VGND VPWR VPWR sky130_fd_sc_hd__decap_3
XFILLER_24_141 VGND VGND VPWR VPWR sky130_fd_sc_hd__decap_3
XFILLER_24_174 VGND VGND VPWR VPWR sky130_fd_sc_hd__decap_3
XFILLER_12_369 VGND VGND VPWR VPWR sky130_fd_sc_hd__decap_3
XFILLER_21_41 VGND VGND VPWR VPWR sky130_fd_sc_hd__decap_3
XFILLER_21_74 VGND VGND VPWR VPWR sky130_fd_sc_hd__decap_3
XFILLER_21_85 VGND VGND VPWR VPWR sky130_fd_sc_hd__decap_3
XFILLER_47_211 VGND VGND VPWR VPWR sky130_fd_sc_hd__decap_3
XFILLER_47_255 VGND VGND VPWR VPWR sky130_fd_sc_hd__decap_3
XFILLER_62_203 VGND VGND VPWR VPWR sky130_fd_sc_hd__decap_3
XFILLER_62_236 VGND VGND VPWR VPWR sky130_fd_sc_hd__decap_3
XTAP_TAPCELL_ROW_45_412 VGND VPWR sky130_fd_sc_hd__tapvpwrvgnd_1
XFILLER_47_299 VGND VGND VPWR VPWR sky130_fd_sc_hd__decap_3
XFILLER_46_71 VGND VGND VPWR VPWR sky130_fd_sc_hd__decap_3
XFILLER_15_152 VGND VGND VPWR VPWR sky130_fd_sc_hd__decap_3
XFILLER_30_100 VGND VGND VPWR VPWR sky130_fd_sc_hd__decap_3
XFILLER_30_144 VGND VGND VPWR VPWR sky130_fd_sc_hd__decap_3
XFILLER_30_133 VGND VGND VPWR VPWR sky130_fd_sc_hd__decap_3
XFILLER_7_21 VGND VGND VPWR VPWR sky130_fd_sc_hd__decap_3
XFILLER_30_177 VGND VGND VPWR VPWR sky130_fd_sc_hd__decap_3
XFILLER_11_391 VGND VGND VPWR VPWR sky130_fd_sc_hd__decap_3
XFILLER_7_340 VGND VGND VPWR VPWR sky130_fd_sc_hd__decap_3
XFILLER_7_54 VGND VGND VPWR VPWR sky130_fd_sc_hd__fill_2
XFILLER_7_373 VGND VGND VPWR VPWR sky130_fd_sc_hd__decap_3
XPHY_EDGE_ROW_17_1_Right_16 VGND VGND VPWR VPWR sky130_fd_sc_hd__decap_3
XFILLER_38_200 VGND VGND VPWR VPWR sky130_fd_sc_hd__decap_3
XFILLER_38_233 VGND VGND VPWR VPWR sky130_fd_sc_hd__decap_3
XFILLER_53_214 VGND VGND VPWR VPWR sky130_fd_sc_hd__decap_3
XFILLER_38_277 VGND VGND VPWR VPWR sky130_fd_sc_hd__decap_3
XFILLER_53_225 VGND VGND VPWR VPWR sky130_fd_sc_hd__decap_3
XFILLER_53_258 VGND VGND VPWR VPWR sky130_fd_sc_hd__decap_3
XFILLER_21_111 VGND VGND VPWR VPWR sky130_fd_sc_hd__fill_1
XFILLER_21_122 VGND VGND VPWR VPWR sky130_fd_sc_hd__decap_3
XFILLER_21_144 VGND VGND VPWR VPWR sky130_fd_sc_hd__decap_3
XFILLER_42_29 VGND VGND VPWR VPWR sky130_fd_sc_hd__decap_3
XFILLER_42_18 VGND VGND VPWR VPWR sky130_fd_sc_hd__decap_3
XFILLER_29_211 VGND VGND VPWR VPWR sky130_fd_sc_hd__decap_3
XFILLER_44_203 VGND VGND VPWR VPWR sky130_fd_sc_hd__decap_3
XFILLER_29_255 VGND VGND VPWR VPWR sky130_fd_sc_hd__decap_3
XFILLER_44_236 VGND VGND VPWR VPWR sky130_fd_sc_hd__decap_3
XFILLER_29_299 VGND VGND VPWR VPWR sky130_fd_sc_hd__decap_3
XFILLER_16_41 VGND VGND VPWR VPWR sky130_fd_sc_hd__decap_3
XFILLER_12_100 VGND VGND VPWR VPWR sky130_fd_sc_hd__decap_3
XFILLER_16_74 VGND VGND VPWR VPWR sky130_fd_sc_hd__decap_3
XFILLER_16_85 VGND VGND VPWR VPWR sky130_fd_sc_hd__decap_3
XFILLER_52_280 VGND VGND VPWR VPWR sky130_fd_sc_hd__decap_3
XFILLER_12_133 VGND VGND VPWR VPWR sky130_fd_sc_hd__decap_3
XFILLER_12_144 VGND VGND VPWR VPWR sky130_fd_sc_hd__decap_3
XFILLER_12_177 VGND VGND VPWR VPWR sky130_fd_sc_hd__decap_3
XFILLER_8_159 VGND VGND VPWR VPWR sky130_fd_sc_hd__decap_3
XFILLER_32_62 VGND VGND VPWR VPWR sky130_fd_sc_hd__decap_3
XFILLER_4_343 VGND VGND VPWR VPWR sky130_fd_sc_hd__decap_3
XFILLER_4_354 VGND VGND VPWR VPWR sky130_fd_sc_hd__decap_3
XFILLER_4_387 VGND VGND VPWR VPWR sky130_fd_sc_hd__decap_3
XFILLER_57_92 VGND VGND VPWR VPWR sky130_fd_sc_hd__decap_3
XFILLER_35_225 VGND VGND VPWR VPWR sky130_fd_sc_hd__decap_3
XFILLER_35_214 VGND VGND VPWR VPWR sky130_fd_sc_hd__decap_3
XFILLER_50_206 VGND VGND VPWR VPWR sky130_fd_sc_hd__decap_3
XFILLER_35_258 VGND VGND VPWR VPWR sky130_fd_sc_hd__decap_3
XPHY_EDGE_ROW_8_1_Left_114 VGND VGND VPWR VPWR sky130_fd_sc_hd__decap_3
XFILLER_50_239 VGND VGND VPWR VPWR sky130_fd_sc_hd__decap_3
XPHY_EDGE_ROW_14_2_Right_100 VGND VGND VPWR VPWR sky130_fd_sc_hd__decap_3
XFILLER_58_339 VGND VGND VPWR VPWR sky130_fd_sc_hd__decap_3
XFILLER_26_203 VGND VGND VPWR VPWR sky130_fd_sc_hd__decap_3
XFILLER_26_236 VGND VGND VPWR VPWR sky130_fd_sc_hd__decap_3
XTAP_TAPCELL_ROW_64_551 VGND VPWR sky130_fd_sc_hd__tapvpwrvgnd_1
XTAP_TAPCELL_ROW_64_540 VGND VPWR sky130_fd_sc_hd__tapvpwrvgnd_1
XFILLER_41_228 VGND VGND VPWR VPWR sky130_fd_sc_hd__decap_3
XFILLER_41_217 VGND VGND VPWR VPWR sky130_fd_sc_hd__decap_3
XFILLER_34_280 VGND VGND VPWR VPWR sky130_fd_sc_hd__decap_3
XFILLER_1_346 VGND VGND VPWR VPWR sky130_fd_sc_hd__decap_3
XFILLER_1_379 VGND VGND VPWR VPWR sky130_fd_sc_hd__fill_2
XFILLER_49_317 VGND VGND VPWR VPWR sky130_fd_sc_hd__decap_3
XFILLER_64_309 VGND VGND VPWR VPWR sky130_fd_sc_hd__decap_3
XFILLER_57_361 VGND VGND VPWR VPWR sky130_fd_sc_hd__decap_3
XFILLER_27_84 VGND VGND VPWR VPWR sky130_fd_sc_hd__decap_3
XTAP_TAPCELL_ROW_27_286 VGND VPWR sky130_fd_sc_hd__tapvpwrvgnd_1
XFILLER_32_239 VGND VGND VPWR VPWR sky130_fd_sc_hd__decap_3
XFILLER_32_206 VGND VGND VPWR VPWR sky130_fd_sc_hd__decap_3
XFILLER_43_72 VGND VGND VPWR VPWR sky130_fd_sc_hd__decap_3
XFILLER_40_283 VGND VGND VPWR VPWR sky130_fd_sc_hd__decap_3
XPHY_EDGE_ROW_13_2_Left_34 VGND VGND VPWR VPWR sky130_fd_sc_hd__decap_3
XFILLER_4_162 VGND VGND VPWR VPWR sky130_fd_sc_hd__decap_3
XFILLER_4_77 VGND VGND VPWR VPWR sky130_fd_sc_hd__decap_3
XFILLER_4_44 VGND VGND VPWR VPWR sky130_fd_sc_hd__decap_3
XFILLER_4_88 VGND VGND VPWR VPWR sky130_fd_sc_hd__decap_3
XPHY_EDGE_ROW_6_2_Right_92 VGND VGND VPWR VPWR sky130_fd_sc_hd__decap_3
XFILLER_63_320 VGND VGND VPWR VPWR sky130_fd_sc_hd__decap_3
XFILLER_48_383 VGND VGND VPWR VPWR sky130_fd_sc_hd__decap_3
XFILLER_63_364 VGND VGND VPWR VPWR sky130_fd_sc_hd__decap_3
XFILLER_23_217 VGND VGND VPWR VPWR sky130_fd_sc_hd__decap_3
XFILLER_23_228 VGND VGND VPWR VPWR sky130_fd_sc_hd__decap_3
XTAP_TAPCELL_ROW_61_521 VGND VPWR sky130_fd_sc_hd__tapvpwrvgnd_1
XFILLER_31_261 VGND VGND VPWR VPWR sky130_fd_sc_hd__decap_3
XPHY_EDGE_ROW_15_2_Right_101 VGND VGND VPWR VPWR sky130_fd_sc_hd__decap_3
XFILLER_58_147 VGND VGND VPWR VPWR sky130_fd_sc_hd__decap_3
XFILLER_58_125 VGND VGND VPWR VPWR sky130_fd_sc_hd__decap_3
XFILLER_46_309 VGND VGND VPWR VPWR sky130_fd_sc_hd__decap_3
XFILLER_39_361 VGND VGND VPWR VPWR sky130_fd_sc_hd__decap_3
XFILLER_64_38 VGND VGND VPWR VPWR sky130_fd_sc_hd__decap_3
XFILLER_54_342 VGND VGND VPWR VPWR sky130_fd_sc_hd__decap_3
XFILLER_54_386 VGND VGND VPWR VPWR sky130_fd_sc_hd__decap_3
XFILLER_22_250 VGND VGND VPWR VPWR sky130_fd_sc_hd__fill_2
XFILLER_22_283 VGND VGND VPWR VPWR sky130_fd_sc_hd__decap_3
X_180_ genblk1\[11\].fa_inst.b genblk1\[11\].fa_inst.a VGND VGND VPWR VPWR _093_ sky130_fd_sc_hd__or2_1
XFILLER_13_75 VGND VGND VPWR VPWR sky130_fd_sc_hd__decap_3
XFILLER_6_405 VGND VGND VPWR VPWR sky130_fd_sc_hd__fill_2
XFILLER_1_143 VGND VGND VPWR VPWR sky130_fd_sc_hd__decap_3
XFILLER_49_103 VGND VGND VPWR VPWR sky130_fd_sc_hd__decap_3
XFILLER_49_125 VGND VGND VPWR VPWR sky130_fd_sc_hd__decap_3
XFILLER_64_106 VGND VGND VPWR VPWR sky130_fd_sc_hd__decap_3
XFILLER_49_169 VGND VGND VPWR VPWR sky130_fd_sc_hd__decap_3
XFILLER_49_158 VGND VGND VPWR VPWR sky130_fd_sc_hd__decap_3
XFILLER_38_50 VGND VGND VPWR VPWR sky130_fd_sc_hd__decap_3
XFILLER_64_128 VGND VGND VPWR VPWR sky130_fd_sc_hd__decap_3
XFILLER_45_320 VGND VGND VPWR VPWR sky130_fd_sc_hd__decap_3
XFILLER_38_94 VGND VGND VPWR VPWR sky130_fd_sc_hd__decap_3
XFILLER_60_312 VGND VGND VPWR VPWR sky130_fd_sc_hd__decap_3
XFILLER_60_301 VGND VGND VPWR VPWR sky130_fd_sc_hd__decap_3
XFILLER_45_364 VGND VGND VPWR VPWR sky130_fd_sc_hd__decap_3
XFILLER_60_345 VGND VGND VPWR VPWR sky130_fd_sc_hd__decap_3
XFILLER_54_71 VGND VGND VPWR VPWR sky130_fd_sc_hd__decap_3
XFILLER_60_389 VGND VGND VPWR VPWR sky130_fd_sc_hd__decap_3
XFILLER_28_309 VGND VGND VPWR VPWR sky130_fd_sc_hd__decap_3
XFILLER_55_128 VGND VGND VPWR VPWR sky130_fd_sc_hd__decap_3
XFILLER_48_180 VGND VGND VPWR VPWR sky130_fd_sc_hd__decap_3
XTAP_TAPCELL_ROW_38_359 VGND VPWR sky130_fd_sc_hd__tapvpwrvgnd_1
XFILLER_36_342 VGND VGND VPWR VPWR sky130_fd_sc_hd__decap_3
XFILLER_63_161 VGND VGND VPWR VPWR sky130_fd_sc_hd__decap_3
XFILLER_63_172 VGND VGND VPWR VPWR sky130_fd_sc_hd__decap_3
XFILLER_36_386 VGND VGND VPWR VPWR sky130_fd_sc_hd__decap_3
XFILLER_51_323 VGND VGND VPWR VPWR sky130_fd_sc_hd__decap_3
XFILLER_51_367 VGND VGND VPWR VPWR sky130_fd_sc_hd__decap_3
XTAP_TAPCELL_ROW_21_237 VGND VPWR sky130_fd_sc_hd__tapvpwrvgnd_1
XFILLER_50_29 VGND VGND VPWR VPWR sky130_fd_sc_hd__decap_3
XFILLER_50_18 VGND VGND VPWR VPWR sky130_fd_sc_hd__decap_3
XFILLER_1_9 VGND VGND VPWR VPWR sky130_fd_sc_hd__decap_3
XPHY_EDGE_ROW_16_2_Right_102 VGND VGND VPWR VPWR sky130_fd_sc_hd__decap_3
XFILLER_59_27 VGND VGND VPWR VPWR sky130_fd_sc_hd__decap_3
XFILLER_46_106 VGND VGND VPWR VPWR sky130_fd_sc_hd__decap_3
XFILLER_27_320 VGND VGND VPWR VPWR sky130_fd_sc_hd__decap_3
XFILLER_46_139 VGND VGND VPWR VPWR sky130_fd_sc_hd__fill_1
XFILLER_27_364 VGND VGND VPWR VPWR sky130_fd_sc_hd__decap_3
XFILLER_54_150 VGND VGND VPWR VPWR sky130_fd_sc_hd__decap_3
XFILLER_42_312 VGND VGND VPWR VPWR sky130_fd_sc_hd__decap_3
XFILLER_42_301 VGND VGND VPWR VPWR sky130_fd_sc_hd__decap_3
XFILLER_54_183 VGND VGND VPWR VPWR sky130_fd_sc_hd__decap_3
XFILLER_42_345 VGND VGND VPWR VPWR sky130_fd_sc_hd__decap_3
XFILLER_24_41 VGND VGND VPWR VPWR sky130_fd_sc_hd__decap_3
X_301_ clknet_2_3__leaf_clk_regs net21 _046_ VGND VGND VPWR VPWR genblk1\[13\].fa_inst.b
+ sky130_fd_sc_hd__dfrtp_1
XFILLER_42_389 VGND VGND VPWR VPWR sky130_fd_sc_hd__decap_3
XFILLER_24_74 VGND VGND VPWR VPWR sky130_fd_sc_hd__decap_3
XFILLER_24_85 VGND VGND VPWR VPWR sky130_fd_sc_hd__decap_3
X_232_ net59 VGND VGND VPWR VPWR _027_ sky130_fd_sc_hd__inv_2
X_163_ _073_ _076_ _074_ VGND VGND VPWR VPWR _080_ sky130_fd_sc_hd__a21bo_1
XFILLER_40_62 VGND VGND VPWR VPWR sky130_fd_sc_hd__decap_3
XFILLER_34_9 VGND VGND VPWR VPWR sky130_fd_sc_hd__decap_3
XFILLER_49_82 VGND VGND VPWR VPWR sky130_fd_sc_hd__decap_3
XFILLER_49_60 VGND VGND VPWR VPWR sky130_fd_sc_hd__decap_3
XFILLER_1_12 VGND VGND VPWR VPWR sky130_fd_sc_hd__decap_3
XFILLER_1_45 VGND VGND VPWR VPWR sky130_fd_sc_hd__decap_3
XFILLER_37_128 VGND VGND VPWR VPWR sky130_fd_sc_hd__decap_3
XFILLER_18_331 VGND VGND VPWR VPWR sky130_fd_sc_hd__decap_3
XFILLER_1_78 VGND VGND VPWR VPWR sky130_fd_sc_hd__decap_3
XFILLER_18_375 VGND VGND VPWR VPWR sky130_fd_sc_hd__decap_3
XFILLER_45_172 VGND VGND VPWR VPWR sky130_fd_sc_hd__decap_3
XFILLER_45_161 VGND VGND VPWR VPWR sky130_fd_sc_hd__decap_3
XFILLER_33_323 VGND VGND VPWR VPWR sky130_fd_sc_hd__decap_3
XFILLER_60_153 VGND VGND VPWR VPWR sky130_fd_sc_hd__decap_3
XFILLER_33_367 VGND VGND VPWR VPWR sky130_fd_sc_hd__decap_3
XFILLER_60_197 VGND VGND VPWR VPWR sky130_fd_sc_hd__decap_3
XFILLER_60_186 VGND VGND VPWR VPWR sky130_fd_sc_hd__decap_3
XTAP_TAPCELL_ROW_43_395 VGND VPWR sky130_fd_sc_hd__tapvpwrvgnd_1
XFILLER_56_404 VGND VGND VPWR VPWR sky130_fd_sc_hd__decap_3
XFILLER_28_117 VGND VGND VPWR VPWR sky130_fd_sc_hd__decap_3
XFILLER_24_301 VGND VGND VPWR VPWR sky130_fd_sc_hd__decap_3
XFILLER_36_150 VGND VGND VPWR VPWR sky130_fd_sc_hd__decap_3
XFILLER_24_312 VGND VGND VPWR VPWR sky130_fd_sc_hd__decap_3
XFILLER_24_345 VGND VGND VPWR VPWR sky130_fd_sc_hd__decap_3
XFILLER_36_183 VGND VGND VPWR VPWR sky130_fd_sc_hd__decap_3
XFILLER_51_164 VGND VGND VPWR VPWR sky130_fd_sc_hd__decap_3
XFILLER_51_131 VGND VGND VPWR VPWR sky130_fd_sc_hd__decap_3
XFILLER_24_389 VGND VGND VPWR VPWR sky130_fd_sc_hd__decap_3
XFILLER_61_39 VGND VGND VPWR VPWR sky130_fd_sc_hd__decap_3
XFILLER_51_175 VGND VGND VPWR VPWR sky130_fd_sc_hd__decap_3
XFILLER_10_21 VGND VGND VPWR VPWR sky130_fd_sc_hd__decap_3
XFILLER_10_32 VGND VGND VPWR VPWR sky130_fd_sc_hd__decap_3
XPHY_EDGE_ROW_17_2_Right_103 VGND VGND VPWR VPWR sky130_fd_sc_hd__decap_3
XFILLER_59_231 VGND VGND VPWR VPWR sky130_fd_sc_hd__decap_3
XFILLER_59_220 VGND VGND VPWR VPWR sky130_fd_sc_hd__decap_3
XFILLER_59_264 VGND VGND VPWR VPWR sky130_fd_sc_hd__decap_3
XFILLER_19_128 VGND VGND VPWR VPWR sky130_fd_sc_hd__decap_3
XFILLER_19_52 VGND VGND VPWR VPWR sky130_fd_sc_hd__decap_3
XFILLER_19_63 VGND VGND VPWR VPWR sky130_fd_sc_hd__decap_3
XFILLER_27_161 VGND VGND VPWR VPWR sky130_fd_sc_hd__decap_3
XFILLER_34_109 VGND VGND VPWR VPWR sky130_fd_sc_hd__decap_3
XFILLER_15_334 VGND VGND VPWR VPWR sky130_fd_sc_hd__decap_3
XFILLER_27_172 VGND VGND VPWR VPWR sky130_fd_sc_hd__decap_3
XFILLER_42_120 VGND VGND VPWR VPWR sky130_fd_sc_hd__decap_3
XFILLER_15_367 VGND VGND VPWR VPWR sky130_fd_sc_hd__decap_3
XFILLER_42_153 VGND VGND VPWR VPWR sky130_fd_sc_hd__decap_3
XFILLER_35_84 VGND VGND VPWR VPWR sky130_fd_sc_hd__decap_3
XFILLER_30_304 VGND VGND VPWR VPWR sky130_fd_sc_hd__decap_3
XFILLER_42_197 VGND VGND VPWR VPWR sky130_fd_sc_hd__decap_3
XFILLER_42_186 VGND VGND VPWR VPWR sky130_fd_sc_hd__decap_3
XFILLER_30_315 VGND VGND VPWR VPWR sky130_fd_sc_hd__decap_3
XFILLER_30_348 VGND VGND VPWR VPWR sky130_fd_sc_hd__decap_3
XTAP_TAPCELL_ROW_40_376 VGND VPWR sky130_fd_sc_hd__tapvpwrvgnd_1
X_215_ net61 VGND VGND VPWR VPWR _010_ sky130_fd_sc_hd__inv_2
X_146_ genblk1\[4\].fa_inst.b genblk1\[4\].fa_inst.a VGND VGND VPWR VPWR _066_ sky130_fd_sc_hd__nand2_1
XFILLER_51_83 VGND VGND VPWR VPWR sky130_fd_sc_hd__decap_3
XPHY_EDGE_ROW_29_Left_135 VGND VGND VPWR VPWR sky130_fd_sc_hd__decap_3
XFILLER_32_6 VGND VGND VPWR VPWR sky130_fd_sc_hd__decap_3
XFILLER_38_404 VGND VGND VPWR VPWR sky130_fd_sc_hd__decap_3
XTAP_TAPCELL_ROW_48_432 VGND VPWR sky130_fd_sc_hd__tapvpwrvgnd_1
XFILLER_18_150 VGND VGND VPWR VPWR sky130_fd_sc_hd__decap_3
XFILLER_25_109 VGND VGND VPWR VPWR sky130_fd_sc_hd__decap_3
XPHY_EDGE_ROW_38_Left_144 VGND VGND VPWR VPWR sky130_fd_sc_hd__decap_3
XFILLER_33_131 VGND VGND VPWR VPWR sky130_fd_sc_hd__decap_3
XFILLER_21_315 VGND VGND VPWR VPWR sky130_fd_sc_hd__decap_3
XFILLER_21_337 VGND VGND VPWR VPWR sky130_fd_sc_hd__decap_3
XTAP_TAPCELL_ROW_31_310 VGND VPWR sky130_fd_sc_hd__tapvpwrvgnd_1
XFILLER_33_175 VGND VGND VPWR VPWR sky130_fd_sc_hd__decap_3
XFILLER_33_164 VGND VGND VPWR VPWR sky130_fd_sc_hd__decap_3
XPHY_EDGE_ROW_47_Left_153 VGND VGND VPWR VPWR sky130_fd_sc_hd__decap_3
XFILLER_56_212 VGND VGND VPWR VPWR sky130_fd_sc_hd__decap_3
XFILLER_56_256 VGND VGND VPWR VPWR sky130_fd_sc_hd__decap_3
XFILLER_56_245 VGND VGND VPWR VPWR sky130_fd_sc_hd__decap_3
XFILLER_56_289 VGND VGND VPWR VPWR sky130_fd_sc_hd__decap_3
XFILLER_24_120 VGND VGND VPWR VPWR sky130_fd_sc_hd__decap_3
XPHY_EDGE_ROW_56_Left_162 VGND VGND VPWR VPWR sky130_fd_sc_hd__decap_3
XFILLER_24_153 VGND VGND VPWR VPWR sky130_fd_sc_hd__decap_3
XFILLER_24_186 VGND VGND VPWR VPWR sky130_fd_sc_hd__decap_3
XFILLER_12_337 VGND VGND VPWR VPWR sky130_fd_sc_hd__decap_3
XFILLER_24_197 VGND VGND VPWR VPWR sky130_fd_sc_hd__decap_3
XFILLER_20_381 VGND VGND VPWR VPWR sky130_fd_sc_hd__decap_3
XPHY_EDGE_ROW_18_2_Right_104 VGND VGND VPWR VPWR sky130_fd_sc_hd__decap_3
XFILLER_47_234 VGND VGND VPWR VPWR sky130_fd_sc_hd__decap_3
XFILLER_47_223 VGND VGND VPWR VPWR sky130_fd_sc_hd__fill_1
XFILLER_62_215 VGND VGND VPWR VPWR sky130_fd_sc_hd__decap_3
XFILLER_47_267 VGND VGND VPWR VPWR sky130_fd_sc_hd__decap_3
XFILLER_46_50 VGND VGND VPWR VPWR sky130_fd_sc_hd__decap_3
XFILLER_62_248 VGND VGND VPWR VPWR sky130_fd_sc_hd__decap_3
XTAP_TAPCELL_ROW_45_413 VGND VPWR sky130_fd_sc_hd__tapvpwrvgnd_1
XFILLER_46_94 VGND VGND VPWR VPWR sky130_fd_sc_hd__decap_3
XFILLER_46_83 VGND VGND VPWR VPWR sky130_fd_sc_hd__fill_1
XFILLER_15_131 VGND VGND VPWR VPWR sky130_fd_sc_hd__decap_3
XFILLER_62_259 VGND VGND VPWR VPWR sky130_fd_sc_hd__decap_3
XFILLER_15_164 VGND VGND VPWR VPWR sky130_fd_sc_hd__decap_3
XFILLER_15_175 VGND VGND VPWR VPWR sky130_fd_sc_hd__decap_3
XFILLER_30_112 VGND VGND VPWR VPWR sky130_fd_sc_hd__decap_3
XFILLER_62_71 VGND VGND VPWR VPWR sky130_fd_sc_hd__decap_3
XFILLER_30_156 VGND VGND VPWR VPWR sky130_fd_sc_hd__decap_3
XFILLER_11_370 VGND VGND VPWR VPWR sky130_fd_sc_hd__decap_3
XFILLER_7_33 VGND VGND VPWR VPWR sky130_fd_sc_hd__decap_3
XFILLER_30_189 VGND VGND VPWR VPWR sky130_fd_sc_hd__decap_3
XFILLER_7_352 VGND VGND VPWR VPWR sky130_fd_sc_hd__decap_3
XFILLER_7_88 VGND VGND VPWR VPWR sky130_fd_sc_hd__decap_3
XFILLER_7_385 VGND VGND VPWR VPWR sky130_fd_sc_hd__decap_3
X_129_ net75 _052_ VGND VGND VPWR VPWR genblk1\[0\].fa_inst.s sky130_fd_sc_hd__xnor2_1
XFILLER_38_212 VGND VGND VPWR VPWR sky130_fd_sc_hd__decap_3
XFILLER_38_245 VGND VGND VPWR VPWR sky130_fd_sc_hd__decap_3
XFILLER_38_289 VGND VGND VPWR VPWR sky130_fd_sc_hd__decap_3
XFILLER_38_256 VGND VGND VPWR VPWR sky130_fd_sc_hd__decap_3
XFILLER_53_237 VGND VGND VPWR VPWR sky130_fd_sc_hd__decap_3
XFILLER_61_270 VGND VGND VPWR VPWR sky130_fd_sc_hd__decap_3
XFILLER_21_134 VGND VGND VPWR VPWR sky130_fd_sc_hd__decap_3
XTAP_TAPCELL_ROW_51_449 VGND VPWR sky130_fd_sc_hd__tapvpwrvgnd_1
XFILLER_61_281 VGND VGND VPWR VPWR sky130_fd_sc_hd__decap_3
XFILLER_21_156 VGND VGND VPWR VPWR sky130_fd_sc_hd__decap_3
XFILLER_21_178 VGND VGND VPWR VPWR sky130_fd_sc_hd__decap_3
XTAP_TAPCELL_ROW_59_505 VGND VPWR sky130_fd_sc_hd__tapvpwrvgnd_1
XFILLER_29_234 VGND VGND VPWR VPWR sky130_fd_sc_hd__decap_3
XFILLER_29_223 VGND VGND VPWR VPWR sky130_fd_sc_hd__fill_1
XFILLER_29_267 VGND VGND VPWR VPWR sky130_fd_sc_hd__decap_3
XFILLER_44_215 VGND VGND VPWR VPWR sky130_fd_sc_hd__decap_3
XFILLER_16_53 VGND VGND VPWR VPWR sky130_fd_sc_hd__decap_3
XFILLER_44_259 VGND VGND VPWR VPWR sky130_fd_sc_hd__decap_3
XFILLER_44_248 VGND VGND VPWR VPWR sky130_fd_sc_hd__decap_3
XFILLER_12_112 VGND VGND VPWR VPWR sky130_fd_sc_hd__decap_3
XFILLER_52_292 VGND VGND VPWR VPWR sky130_fd_sc_hd__decap_3
XFILLER_12_156 VGND VGND VPWR VPWR sky130_fd_sc_hd__decap_3
XFILLER_8_127 VGND VGND VPWR VPWR sky130_fd_sc_hd__decap_3
XFILLER_32_41 VGND VGND VPWR VPWR sky130_fd_sc_hd__decap_3
XFILLER_32_85 VGND VGND VPWR VPWR sky130_fd_sc_hd__decap_3
XFILLER_4_366 VGND VGND VPWR VPWR sky130_fd_sc_hd__decap_3
XFILLER_4_399 VGND VGND VPWR VPWR sky130_fd_sc_hd__decap_3
XPHY_EDGE_ROW_19_2_Right_105 VGND VGND VPWR VPWR sky130_fd_sc_hd__decap_3
XFILLER_57_60 VGND VGND VPWR VPWR sky130_fd_sc_hd__decap_3
XPHY_EDGE_ROW_1_1_Right_0 VGND VGND VPWR VPWR sky130_fd_sc_hd__decap_3
XFILLER_35_237 VGND VGND VPWR VPWR sky130_fd_sc_hd__decap_3
XFILLER_50_218 VGND VGND VPWR VPWR sky130_fd_sc_hd__decap_3
XFILLER_43_270 VGND VGND VPWR VPWR sky130_fd_sc_hd__decap_3
XFILLER_43_281 VGND VGND VPWR VPWR sky130_fd_sc_hd__decap_3
XFILLER_58_318 VGND VGND VPWR VPWR sky130_fd_sc_hd__decap_3
XFILLER_58_307 VGND VGND VPWR VPWR sky130_fd_sc_hd__fill_1
XFILLER_26_215 VGND VGND VPWR VPWR sky130_fd_sc_hd__decap_3
XFILLER_26_248 VGND VGND VPWR VPWR sky130_fd_sc_hd__decap_3
XFILLER_26_259 VGND VGND VPWR VPWR sky130_fd_sc_hd__decap_3
XTAP_TAPCELL_ROW_64_552 VGND VPWR sky130_fd_sc_hd__tapvpwrvgnd_1
XTAP_TAPCELL_ROW_64_541 VGND VPWR sky130_fd_sc_hd__tapvpwrvgnd_1
XFILLER_34_292 VGND VGND VPWR VPWR sky130_fd_sc_hd__decap_3
XFILLER_5_119 VGND VGND VPWR VPWR sky130_fd_sc_hd__decap_3
XFILLER_1_358 VGND VGND VPWR VPWR sky130_fd_sc_hd__decap_3
XFILLER_49_329 VGND VGND VPWR VPWR sky130_fd_sc_hd__decap_3
XFILLER_57_340 VGND VGND VPWR VPWR sky130_fd_sc_hd__decap_3
XFILLER_27_41 VGND VGND VPWR VPWR sky130_fd_sc_hd__decap_3
XFILLER_27_63 VGND VGND VPWR VPWR sky130_fd_sc_hd__decap_3
XFILLER_57_373 VGND VGND VPWR VPWR sky130_fd_sc_hd__decap_3
XFILLER_27_96 VGND VGND VPWR VPWR sky130_fd_sc_hd__decap_3
XFILLER_32_218 VGND VGND VPWR VPWR sky130_fd_sc_hd__decap_3
XFILLER_25_270 VGND VGND VPWR VPWR sky130_fd_sc_hd__decap_3
XFILLER_25_281 VGND VGND VPWR VPWR sky130_fd_sc_hd__decap_3
XTAP_TAPCELL_ROW_27_287 VGND VPWR sky130_fd_sc_hd__tapvpwrvgnd_1
XFILLER_43_51 VGND VGND VPWR VPWR sky130_fd_sc_hd__decap_3
XFILLER_40_262 VGND VGND VPWR VPWR sky130_fd_sc_hd__decap_3
XFILLER_40_251 VGND VGND VPWR VPWR sky130_fd_sc_hd__fill_1
XFILLER_43_84 VGND VGND VPWR VPWR sky130_fd_sc_hd__decap_3
XFILLER_40_295 VGND VGND VPWR VPWR sky130_fd_sc_hd__decap_3
XFILLER_4_141 VGND VGND VPWR VPWR sky130_fd_sc_hd__decap_3
XFILLER_4_130 VGND VGND VPWR VPWR sky130_fd_sc_hd__decap_3
XFILLER_4_174 VGND VGND VPWR VPWR sky130_fd_sc_hd__decap_3
XFILLER_4_56 VGND VGND VPWR VPWR sky130_fd_sc_hd__decap_3
XFILLER_0_391 VGND VGND VPWR VPWR sky130_fd_sc_hd__decap_3
XFILLER_48_351 VGND VGND VPWR VPWR sky130_fd_sc_hd__decap_3
XFILLER_48_395 VGND VGND VPWR VPWR sky130_fd_sc_hd__decap_3
XFILLER_63_332 VGND VGND VPWR VPWR sky130_fd_sc_hd__decap_3
XFILLER_63_343 VGND VGND VPWR VPWR sky130_fd_sc_hd__decap_3
XFILLER_63_376 VGND VGND VPWR VPWR sky130_fd_sc_hd__decap_3
XTAP_TAPCELL_ROW_61_522 VGND VPWR sky130_fd_sc_hd__tapvpwrvgnd_1
XFILLER_31_240 VGND VGND VPWR VPWR sky130_fd_sc_hd__decap_3
XFILLER_31_284 VGND VGND VPWR VPWR sky130_fd_sc_hd__decap_3
XFILLER_31_273 VGND VGND VPWR VPWR sky130_fd_sc_hd__decap_3
XFILLER_48_18 VGND VGND VPWR VPWR sky130_fd_sc_hd__decap_3
XFILLER_58_137 VGND VGND VPWR VPWR sky130_fd_sc_hd__decap_3
XFILLER_58_159 VGND VGND VPWR VPWR sky130_fd_sc_hd__decap_3
XFILLER_39_340 VGND VGND VPWR VPWR sky130_fd_sc_hd__decap_3
XFILLER_64_17 VGND VGND VPWR VPWR sky130_fd_sc_hd__decap_3
XFILLER_54_321 VGND VGND VPWR VPWR sky130_fd_sc_hd__decap_3
XFILLER_39_373 VGND VGND VPWR VPWR sky130_fd_sc_hd__decap_3
XFILLER_54_354 VGND VGND VPWR VPWR sky130_fd_sc_hd__decap_3
XFILLER_54_365 VGND VGND VPWR VPWR sky130_fd_sc_hd__decap_3
XFILLER_54_398 VGND VGND VPWR VPWR sky130_fd_sc_hd__decap_3
XFILLER_10_402 VGND VGND VPWR VPWR sky130_fd_sc_hd__decap_3
XFILLER_22_262 VGND VGND VPWR VPWR sky130_fd_sc_hd__decap_3
XFILLER_22_295 VGND VGND VPWR VPWR sky130_fd_sc_hd__decap_3
XFILLER_13_43 VGND VGND VPWR VPWR sky130_fd_sc_hd__decap_3
XFILLER_13_87 VGND VGND VPWR VPWR sky130_fd_sc_hd__decap_3
XFILLER_1_111 VGND VGND VPWR VPWR sky130_fd_sc_hd__fill_1
XFILLER_1_122 VGND VGND VPWR VPWR sky130_fd_sc_hd__decap_3
XFILLER_1_155 VGND VGND VPWR VPWR sky130_fd_sc_hd__decap_3
XFILLER_49_137 VGND VGND VPWR VPWR sky130_fd_sc_hd__decap_3
XFILLER_38_62 VGND VGND VPWR VPWR sky130_fd_sc_hd__decap_3
XFILLER_57_181 VGND VGND VPWR VPWR sky130_fd_sc_hd__decap_3
XFILLER_45_343 VGND VGND VPWR VPWR sky130_fd_sc_hd__decap_3
XFILLER_45_332 VGND VGND VPWR VPWR sky130_fd_sc_hd__decap_3
XFILLER_54_50 VGND VGND VPWR VPWR sky130_fd_sc_hd__decap_3
XFILLER_45_376 VGND VGND VPWR VPWR sky130_fd_sc_hd__decap_3
XFILLER_60_324 VGND VGND VPWR VPWR sky130_fd_sc_hd__decap_3
XFILLER_54_83 VGND VGND VPWR VPWR sky130_fd_sc_hd__fill_1
XFILLER_60_368 VGND VGND VPWR VPWR sky130_fd_sc_hd__decap_3
XFILLER_60_357 VGND VGND VPWR VPWR sky130_fd_sc_hd__decap_3
XFILLER_54_94 VGND VGND VPWR VPWR sky130_fd_sc_hd__decap_3
XFILLER_62_6 VGND VGND VPWR VPWR sky130_fd_sc_hd__decap_3
XFILLER_48_192 VGND VGND VPWR VPWR sky130_fd_sc_hd__decap_3
XFILLER_36_354 VGND VGND VPWR VPWR sky130_fd_sc_hd__decap_3
XFILLER_36_321 VGND VGND VPWR VPWR sky130_fd_sc_hd__decap_3
XFILLER_63_140 VGND VGND VPWR VPWR sky130_fd_sc_hd__decap_3
XFILLER_51_302 VGND VGND VPWR VPWR sky130_fd_sc_hd__decap_3
XFILLER_36_365 VGND VGND VPWR VPWR sky130_fd_sc_hd__decap_3
XFILLER_63_184 VGND VGND VPWR VPWR sky130_fd_sc_hd__decap_3
XFILLER_51_346 VGND VGND VPWR VPWR sky130_fd_sc_hd__decap_3
XFILLER_51_335 VGND VGND VPWR VPWR sky130_fd_sc_hd__fill_1
XFILLER_36_398 VGND VGND VPWR VPWR sky130_fd_sc_hd__decap_3
XFILLER_51_379 VGND VGND VPWR VPWR sky130_fd_sc_hd__decap_3
XTAP_TAPCELL_ROW_21_238 VGND VPWR sky130_fd_sc_hd__tapvpwrvgnd_1
XPHY_EDGE_ROW_7_2_Left_28 VGND VGND VPWR VPWR sky130_fd_sc_hd__decap_3
XFILLER_59_39 VGND VGND VPWR VPWR sky130_fd_sc_hd__decap_3
XFILLER_59_402 VGND VGND VPWR VPWR sky130_fd_sc_hd__decap_3
XFILLER_46_118 VGND VGND VPWR VPWR sky130_fd_sc_hd__decap_3
XFILLER_27_332 VGND VGND VPWR VPWR sky130_fd_sc_hd__decap_3
XFILLER_27_343 VGND VGND VPWR VPWR sky130_fd_sc_hd__decap_3
XFILLER_39_181 VGND VGND VPWR VPWR sky130_fd_sc_hd__decap_3
XFILLER_27_376 VGND VGND VPWR VPWR sky130_fd_sc_hd__decap_3
XFILLER_54_162 VGND VGND VPWR VPWR sky130_fd_sc_hd__decap_3
X_300_ clknet_2_2__leaf_clk_regs net20 _045_ VGND VGND VPWR VPWR genblk1\[12\].fa_inst.b
+ sky130_fd_sc_hd__dfrtp_1
XFILLER_54_195 VGND VGND VPWR VPWR sky130_fd_sc_hd__fill_1
XFILLER_42_324 VGND VGND VPWR VPWR sky130_fd_sc_hd__decap_3
XFILLER_42_368 VGND VGND VPWR VPWR sky130_fd_sc_hd__decap_3
XFILLER_42_357 VGND VGND VPWR VPWR sky130_fd_sc_hd__decap_3
XFILLER_24_53 VGND VGND VPWR VPWR sky130_fd_sc_hd__decap_3
X_231_ net59 VGND VGND VPWR VPWR _026_ sky130_fd_sc_hd__inv_2
X_162_ _077_ _078_ VGND VGND VPWR VPWR _079_ sky130_fd_sc_hd__nand2_1
XFILLER_40_41 VGND VGND VPWR VPWR sky130_fd_sc_hd__decap_3
XFILLER_40_85 VGND VGND VPWR VPWR sky130_fd_sc_hd__decap_3
XFILLER_49_50 VGND VGND VPWR VPWR sky130_fd_sc_hd__decap_3
XFILLER_27_9 VGND VGND VPWR VPWR sky130_fd_sc_hd__decap_3
XFILLER_49_94 VGND VGND VPWR VPWR sky130_fd_sc_hd__decap_3
XFILLER_1_24 VGND VGND VPWR VPWR sky130_fd_sc_hd__decap_3
XFILLER_37_107 VGND VGND VPWR VPWR sky130_fd_sc_hd__decap_3
XFILLER_18_343 VGND VGND VPWR VPWR sky130_fd_sc_hd__decap_3
XFILLER_1_57 VGND VGND VPWR VPWR sky130_fd_sc_hd__decap_3
XFILLER_18_354 VGND VGND VPWR VPWR sky130_fd_sc_hd__decap_3
XFILLER_45_140 VGND VGND VPWR VPWR sky130_fd_sc_hd__decap_3
XFILLER_33_302 VGND VGND VPWR VPWR sky130_fd_sc_hd__decap_3
XFILLER_18_387 VGND VGND VPWR VPWR sky130_fd_sc_hd__decap_3
XFILLER_60_121 VGND VGND VPWR VPWR sky130_fd_sc_hd__decap_3
XFILLER_45_184 VGND VGND VPWR VPWR sky130_fd_sc_hd__decap_3
XFILLER_33_346 VGND VGND VPWR VPWR sky130_fd_sc_hd__decap_3
XFILLER_33_335 VGND VGND VPWR VPWR sky130_fd_sc_hd__fill_1
XFILLER_60_165 VGND VGND VPWR VPWR sky130_fd_sc_hd__decap_3
XFILLER_33_379 VGND VGND VPWR VPWR sky130_fd_sc_hd__decap_3
XTAP_TAPCELL_ROW_43_396 VGND VPWR sky130_fd_sc_hd__tapvpwrvgnd_1
Xinput1 a[0] VGND VGND VPWR VPWR net1 sky130_fd_sc_hd__clkbuf_1
XFILLER_28_129 VGND VGND VPWR VPWR sky130_fd_sc_hd__decap_3
XFILLER_36_162 VGND VGND VPWR VPWR sky130_fd_sc_hd__decap_3
XFILLER_24_324 VGND VGND VPWR VPWR sky130_fd_sc_hd__decap_3
XFILLER_51_110 VGND VGND VPWR VPWR sky130_fd_sc_hd__fill_2
XFILLER_36_195 VGND VGND VPWR VPWR sky130_fd_sc_hd__fill_1
XFILLER_24_357 VGND VGND VPWR VPWR sky130_fd_sc_hd__decap_3
XFILLER_24_368 VGND VGND VPWR VPWR sky130_fd_sc_hd__decap_3
XTAP_TAPCELL_ROW_34_330 VGND VPWR sky130_fd_sc_hd__tapvpwrvgnd_1
XFILLER_51_143 VGND VGND VPWR VPWR sky130_fd_sc_hd__decap_3
XFILLER_61_18 VGND VGND VPWR VPWR sky130_fd_sc_hd__decap_3
XFILLER_51_187 VGND VGND VPWR VPWR sky130_fd_sc_hd__decap_3
XPHY_EDGE_ROW_13_1_Left_119 VGND VGND VPWR VPWR sky130_fd_sc_hd__decap_3
XFILLER_10_44 VGND VGND VPWR VPWR sky130_fd_sc_hd__fill_1
XFILLER_10_77 VGND VGND VPWR VPWR sky130_fd_sc_hd__decap_3
XFILLER_10_88 VGND VGND VPWR VPWR sky130_fd_sc_hd__decap_3
XFILLER_59_243 VGND VGND VPWR VPWR sky130_fd_sc_hd__decap_3
XFILLER_59_287 VGND VGND VPWR VPWR sky130_fd_sc_hd__decap_3
XFILLER_59_276 VGND VGND VPWR VPWR sky130_fd_sc_hd__decap_3
XFILLER_47_405 VGND VGND VPWR VPWR sky130_fd_sc_hd__fill_2
XFILLER_19_75 VGND VGND VPWR VPWR sky130_fd_sc_hd__decap_3
XFILLER_27_140 VGND VGND VPWR VPWR sky130_fd_sc_hd__decap_3
XFILLER_27_184 VGND VGND VPWR VPWR sky130_fd_sc_hd__decap_3
XFILLER_35_41 VGND VGND VPWR VPWR sky130_fd_sc_hd__decap_3
XFILLER_15_346 VGND VGND VPWR VPWR sky130_fd_sc_hd__decap_3
XFILLER_42_132 VGND VGND VPWR VPWR sky130_fd_sc_hd__decap_3
XFILLER_35_63 VGND VGND VPWR VPWR sky130_fd_sc_hd__decap_3
XFILLER_15_379 VGND VGND VPWR VPWR sky130_fd_sc_hd__fill_2
XFILLER_42_165 VGND VGND VPWR VPWR sky130_fd_sc_hd__decap_3
XFILLER_35_96 VGND VGND VPWR VPWR sky130_fd_sc_hd__decap_3
XFILLER_30_327 VGND VGND VPWR VPWR sky130_fd_sc_hd__decap_3
X_214_ net59 VGND VGND VPWR VPWR _009_ sky130_fd_sc_hd__inv_2
XTAP_TAPCELL_ROW_40_377 VGND VPWR sky130_fd_sc_hd__tapvpwrvgnd_1
X_145_ genblk1\[4\].fa_inst.b genblk1\[4\].fa_inst.a VGND VGND VPWR VPWR _065_ sky130_fd_sc_hd__or2_1
XFILLER_51_95 VGND VGND VPWR VPWR sky130_fd_sc_hd__decap_3
XFILLER_25_6 VGND VGND VPWR VPWR sky130_fd_sc_hd__decap_3
XTAP_TAPCELL_ROW_48_433 VGND VPWR sky130_fd_sc_hd__tapvpwrvgnd_1
XFILLER_18_162 VGND VGND VPWR VPWR sky130_fd_sc_hd__decap_3
XFILLER_33_110 VGND VGND VPWR VPWR sky130_fd_sc_hd__fill_2
XFILLER_33_143 VGND VGND VPWR VPWR sky130_fd_sc_hd__decap_3
XFILLER_21_305 VGND VGND VPWR VPWR sky130_fd_sc_hd__decap_3
XFILLER_21_327 VGND VGND VPWR VPWR sky130_fd_sc_hd__decap_3
XFILLER_33_187 VGND VGND VPWR VPWR sky130_fd_sc_hd__decap_3
XFILLER_14_390 VGND VGND VPWR VPWR sky130_fd_sc_hd__decap_3
XFILLER_21_349 VGND VGND VPWR VPWR sky130_fd_sc_hd__decap_3
XTAP_TAPCELL_ROW_31_311 VGND VPWR sky130_fd_sc_hd__tapvpwrvgnd_1
XFILLER_56_29 VGND VGND VPWR VPWR sky130_fd_sc_hd__decap_3
XFILLER_56_18 VGND VGND VPWR VPWR sky130_fd_sc_hd__decap_3
XFILLER_56_224 VGND VGND VPWR VPWR sky130_fd_sc_hd__decap_3
XPHY_EDGE_ROW_11_2_Right_97 VGND VGND VPWR VPWR sky130_fd_sc_hd__decap_3
XFILLER_56_268 VGND VGND VPWR VPWR sky130_fd_sc_hd__decap_3
XFILLER_24_132 VGND VGND VPWR VPWR sky130_fd_sc_hd__decap_3
XFILLER_64_290 VGND VGND VPWR VPWR sky130_fd_sc_hd__decap_3
XFILLER_24_165 VGND VGND VPWR VPWR sky130_fd_sc_hd__decap_3
XFILLER_12_349 VGND VGND VPWR VPWR sky130_fd_sc_hd__decap_3
XFILLER_20_360 VGND VGND VPWR VPWR sky130_fd_sc_hd__decap_3
XFILLER_20_393 VGND VGND VPWR VPWR sky130_fd_sc_hd__decap_3
XFILLER_21_21 VGND VGND VPWR VPWR sky130_fd_sc_hd__decap_3
XFILLER_21_32 VGND VGND VPWR VPWR sky130_fd_sc_hd__decap_3
XFILLER_21_54 VGND VGND VPWR VPWR sky130_fd_sc_hd__fill_2
XFILLER_21_65 VGND VGND VPWR VPWR sky130_fd_sc_hd__decap_3
XFILLER_47_202 VGND VGND VPWR VPWR sky130_fd_sc_hd__decap_3
XFILLER_47_246 VGND VGND VPWR VPWR sky130_fd_sc_hd__decap_3
XFILLER_47_279 VGND VGND VPWR VPWR sky130_fd_sc_hd__fill_1
XFILLER_62_227 VGND VGND VPWR VPWR sky130_fd_sc_hd__decap_3
XFILLER_46_62 VGND VGND VPWR VPWR sky130_fd_sc_hd__decap_3
XFILLER_15_143 VGND VGND VPWR VPWR sky130_fd_sc_hd__decap_3
XFILLER_55_290 VGND VGND VPWR VPWR sky130_fd_sc_hd__decap_3
XFILLER_62_50 VGND VGND VPWR VPWR sky130_fd_sc_hd__decap_3
XFILLER_30_124 VGND VGND VPWR VPWR sky130_fd_sc_hd__decap_3
XFILLER_62_83 VGND VGND VPWR VPWR sky130_fd_sc_hd__fill_1
XFILLER_62_94 VGND VGND VPWR VPWR sky130_fd_sc_hd__decap_3
XFILLER_7_12 VGND VGND VPWR VPWR sky130_fd_sc_hd__decap_3
XFILLER_30_168 VGND VGND VPWR VPWR sky130_fd_sc_hd__decap_3
XFILLER_11_382 VGND VGND VPWR VPWR sky130_fd_sc_hd__decap_3
XFILLER_7_331 VGND VGND VPWR VPWR sky130_fd_sc_hd__decap_3
XFILLER_7_45 VGND VGND VPWR VPWR sky130_fd_sc_hd__fill_1
XFILLER_7_364 VGND VGND VPWR VPWR sky130_fd_sc_hd__decap_3
X_128_ _050_ _051_ VGND VGND VPWR VPWR _052_ sky130_fd_sc_hd__nand2_1
XFILLER_7_397 VGND VGND VPWR VPWR sky130_fd_sc_hd__decap_3
XFILLER_23_3 VGND VGND VPWR VPWR sky130_fd_sc_hd__decap_3
XFILLER_38_224 VGND VGND VPWR VPWR sky130_fd_sc_hd__decap_3
XFILLER_53_205 VGND VGND VPWR VPWR sky130_fd_sc_hd__decap_3
XFILLER_38_268 VGND VGND VPWR VPWR sky130_fd_sc_hd__decap_3
XFILLER_53_249 VGND VGND VPWR VPWR sky130_fd_sc_hd__decap_3
XFILLER_21_113 VGND VGND VPWR VPWR sky130_fd_sc_hd__decap_3
XFILLER_61_293 VGND VGND VPWR VPWR sky130_fd_sc_hd__decap_3
XTAP_TAPCELL_ROW_59_506 VGND VPWR sky130_fd_sc_hd__tapvpwrvgnd_1
XFILLER_29_202 VGND VGND VPWR VPWR sky130_fd_sc_hd__decap_3
XFILLER_29_279 VGND VGND VPWR VPWR sky130_fd_sc_hd__fill_1
XFILLER_29_246 VGND VGND VPWR VPWR sky130_fd_sc_hd__decap_3
XFILLER_44_227 VGND VGND VPWR VPWR sky130_fd_sc_hd__decap_3
XFILLER_16_21 VGND VGND VPWR VPWR sky130_fd_sc_hd__decap_3
XFILLER_37_290 VGND VGND VPWR VPWR sky130_fd_sc_hd__decap_3
XFILLER_16_65 VGND VGND VPWR VPWR sky130_fd_sc_hd__decap_3
XFILLER_52_271 VGND VGND VPWR VPWR sky130_fd_sc_hd__decap_3
XFILLER_12_124 VGND VGND VPWR VPWR sky130_fd_sc_hd__decap_3
XFILLER_12_168 VGND VGND VPWR VPWR sky130_fd_sc_hd__decap_3
XFILLER_8_139 VGND VGND VPWR VPWR sky130_fd_sc_hd__fill_1
XFILLER_32_53 VGND VGND VPWR VPWR sky130_fd_sc_hd__decap_3
XFILLER_32_75 VGND VGND VPWR VPWR sky130_fd_sc_hd__decap_3
XFILLER_4_334 VGND VGND VPWR VPWR sky130_fd_sc_hd__decap_3
XFILLER_4_378 VGND VGND VPWR VPWR sky130_fd_sc_hd__decap_3
XFILLER_35_205 VGND VGND VPWR VPWR sky130_fd_sc_hd__decap_3
XFILLER_35_249 VGND VGND VPWR VPWR sky130_fd_sc_hd__decap_3
XFILLER_43_293 VGND VGND VPWR VPWR sky130_fd_sc_hd__decap_3
XFILLER_7_161 VGND VGND VPWR VPWR sky130_fd_sc_hd__decap_3
XFILLER_7_172 VGND VGND VPWR VPWR sky130_fd_sc_hd__decap_3
XFILLER_26_227 VGND VGND VPWR VPWR sky130_fd_sc_hd__decap_3
XTAP_TAPCELL_ROW_64_553 VGND VPWR sky130_fd_sc_hd__tapvpwrvgnd_1
XTAP_TAPCELL_ROW_64_542 VGND VPWR sky130_fd_sc_hd__tapvpwrvgnd_1
XFILLER_41_208 VGND VGND VPWR VPWR sky130_fd_sc_hd__decap_3
XFILLER_34_271 VGND VGND VPWR VPWR sky130_fd_sc_hd__decap_3
XFILLER_1_337 VGND VGND VPWR VPWR sky130_fd_sc_hd__decap_3
XFILLER_49_308 VGND VGND VPWR VPWR sky130_fd_sc_hd__decap_3
XFILLER_57_352 VGND VGND VPWR VPWR sky130_fd_sc_hd__decap_3
XFILLER_27_53 VGND VGND VPWR VPWR sky130_fd_sc_hd__decap_3
XFILLER_57_396 VGND VGND VPWR VPWR sky130_fd_sc_hd__decap_3
XFILLER_57_385 VGND VGND VPWR VPWR sky130_fd_sc_hd__decap_3
XFILLER_27_75 VGND VGND VPWR VPWR sky130_fd_sc_hd__decap_3
XPHY_EDGE_ROW_16_1_Right_15 VGND VGND VPWR VPWR sky130_fd_sc_hd__decap_3
XFILLER_13_400 VGND VGND VPWR VPWR sky130_fd_sc_hd__decap_3
XFILLER_25_293 VGND VGND VPWR VPWR sky130_fd_sc_hd__decap_3
XFILLER_43_63 VGND VGND VPWR VPWR sky130_fd_sc_hd__decap_3
XFILLER_40_230 VGND VGND VPWR VPWR sky130_fd_sc_hd__decap_3
XFILLER_40_274 VGND VGND VPWR VPWR sky130_fd_sc_hd__decap_3
XFILLER_57_9 VGND VGND VPWR VPWR sky130_fd_sc_hd__decap_3
XFILLER_4_153 VGND VGND VPWR VPWR sky130_fd_sc_hd__decap_3
XFILLER_4_68 VGND VGND VPWR VPWR sky130_fd_sc_hd__decap_3
XFILLER_4_35 VGND VGND VPWR VPWR sky130_fd_sc_hd__decap_3
XFILLER_48_330 VGND VGND VPWR VPWR sky130_fd_sc_hd__decap_3
XFILLER_63_311 VGND VGND VPWR VPWR sky130_fd_sc_hd__decap_3
XFILLER_48_374 VGND VGND VPWR VPWR sky130_fd_sc_hd__decap_3
XFILLER_48_363 VGND VGND VPWR VPWR sky130_fd_sc_hd__fill_1
XFILLER_63_355 VGND VGND VPWR VPWR sky130_fd_sc_hd__decap_3
XFILLER_23_208 VGND VGND VPWR VPWR sky130_fd_sc_hd__decap_3
XFILLER_63_388 VGND VGND VPWR VPWR sky130_fd_sc_hd__decap_3
XFILLER_63_399 VGND VGND VPWR VPWR sky130_fd_sc_hd__decap_3
XTAP_TAPCELL_ROW_61_523 VGND VPWR sky130_fd_sc_hd__tapvpwrvgnd_1
XFILLER_31_252 VGND VGND VPWR VPWR sky130_fd_sc_hd__decap_3
XFILLER_31_296 VGND VGND VPWR VPWR sky130_fd_sc_hd__decap_3
XFILLER_39_352 VGND VGND VPWR VPWR sky130_fd_sc_hd__decap_3
XFILLER_39_385 VGND VGND VPWR VPWR sky130_fd_sc_hd__decap_3
XFILLER_64_29 VGND VGND VPWR VPWR sky130_fd_sc_hd__decap_3
XFILLER_54_333 VGND VGND VPWR VPWR sky130_fd_sc_hd__decap_3
XFILLER_39_396 VGND VGND VPWR VPWR sky130_fd_sc_hd__decap_3
XFILLER_54_377 VGND VGND VPWR VPWR sky130_fd_sc_hd__decap_3
XFILLER_22_241 VGND VGND VPWR VPWR sky130_fd_sc_hd__decap_3
Xfanout56 net58 VGND VGND VPWR VPWR net56 sky130_fd_sc_hd__buf_4
XFILLER_22_274 VGND VGND VPWR VPWR sky130_fd_sc_hd__decap_3
XFILLER_13_55 VGND VGND VPWR VPWR sky130_fd_sc_hd__fill_1
XFILLER_1_134 VGND VGND VPWR VPWR sky130_fd_sc_hd__decap_3
XPHY_EDGE_ROW_7_1_Left_113 VGND VGND VPWR VPWR sky130_fd_sc_hd__decap_3
XFILLER_1_167 VGND VGND VPWR VPWR sky130_fd_sc_hd__fill_1
XFILLER_1_178 VGND VGND VPWR VPWR sky130_fd_sc_hd__fill_2
XFILLER_49_116 VGND VGND VPWR VPWR sky130_fd_sc_hd__decap_3
XFILLER_49_149 VGND VGND VPWR VPWR sky130_fd_sc_hd__decap_3
XFILLER_38_41 VGND VGND VPWR VPWR sky130_fd_sc_hd__decap_3
XFILLER_64_119 VGND VGND VPWR VPWR sky130_fd_sc_hd__decap_3
XFILLER_45_311 VGND VGND VPWR VPWR sky130_fd_sc_hd__decap_3
XFILLER_38_85 VGND VGND VPWR VPWR sky130_fd_sc_hd__decap_3
XFILLER_57_193 VGND VGND VPWR VPWR sky130_fd_sc_hd__decap_3
XFILLER_45_388 VGND VGND VPWR VPWR sky130_fd_sc_hd__decap_3
XFILLER_45_355 VGND VGND VPWR VPWR sky130_fd_sc_hd__decap_3
XFILLER_60_336 VGND VGND VPWR VPWR sky130_fd_sc_hd__decap_3
XFILLER_54_62 VGND VGND VPWR VPWR sky130_fd_sc_hd__decap_3
XFILLER_45_399 VGND VGND VPWR VPWR sky130_fd_sc_hd__decap_3
XFILLER_55_6 VGND VGND VPWR VPWR sky130_fd_sc_hd__decap_3
XFILLER_55_119 VGND VGND VPWR VPWR sky130_fd_sc_hd__decap_3
XFILLER_55_108 VGND VGND VPWR VPWR sky130_fd_sc_hd__fill_1
XFILLER_48_171 VGND VGND VPWR VPWR sky130_fd_sc_hd__decap_3
XFILLER_36_333 VGND VGND VPWR VPWR sky130_fd_sc_hd__decap_3
XFILLER_63_152 VGND VGND VPWR VPWR sky130_fd_sc_hd__decap_3
XFILLER_36_377 VGND VGND VPWR VPWR sky130_fd_sc_hd__decap_3
XFILLER_63_196 VGND VGND VPWR VPWR sky130_fd_sc_hd__decap_3
XFILLER_51_314 VGND VGND VPWR VPWR sky130_fd_sc_hd__decap_3
XFILLER_51_358 VGND VGND VPWR VPWR sky130_fd_sc_hd__decap_3
XTAP_TAPCELL_ROW_21_239 VGND VPWR sky130_fd_sc_hd__tapvpwrvgnd_1
XFILLER_59_18 VGND VGND VPWR VPWR sky130_fd_sc_hd__decap_3
XFILLER_27_311 VGND VGND VPWR VPWR sky130_fd_sc_hd__decap_3
XFILLER_54_130 VGND VGND VPWR VPWR sky130_fd_sc_hd__decap_3
XFILLER_39_193 VGND VGND VPWR VPWR sky130_fd_sc_hd__decap_3
XFILLER_27_355 VGND VGND VPWR VPWR sky130_fd_sc_hd__decap_3
XFILLER_54_141 VGND VGND VPWR VPWR sky130_fd_sc_hd__decap_3
XFILLER_27_388 VGND VGND VPWR VPWR sky130_fd_sc_hd__decap_3
XFILLER_27_399 VGND VGND VPWR VPWR sky130_fd_sc_hd__decap_3
XFILLER_54_174 VGND VGND VPWR VPWR sky130_fd_sc_hd__decap_3
XFILLER_42_336 VGND VGND VPWR VPWR sky130_fd_sc_hd__decap_3
XFILLER_24_21 VGND VGND VPWR VPWR sky130_fd_sc_hd__decap_3
XFILLER_24_32 VGND VGND VPWR VPWR sky130_fd_sc_hd__decap_3
XFILLER_24_65 VGND VGND VPWR VPWR sky130_fd_sc_hd__decap_3
X_230_ net58 VGND VGND VPWR VPWR _025_ sky130_fd_sc_hd__inv_2
X_161_ genblk1\[7\].fa_inst.b genblk1\[7\].fa_inst.a VGND VGND VPWR VPWR _078_ sky130_fd_sc_hd__nand2_1
XFILLER_50_380 VGND VGND VPWR VPWR sky130_fd_sc_hd__decap_3
XPHY_EDGE_ROW_5_2_Right_91 VGND VGND VPWR VPWR sky130_fd_sc_hd__decap_3
XFILLER_40_53 VGND VGND VPWR VPWR sky130_fd_sc_hd__decap_3
XFILLER_49_73 VGND VGND VPWR VPWR sky130_fd_sc_hd__decap_3
XFILLER_1_36 VGND VGND VPWR VPWR sky130_fd_sc_hd__decap_3
XFILLER_37_119 VGND VGND VPWR VPWR sky130_fd_sc_hd__decap_3
XFILLER_1_69 VGND VGND VPWR VPWR sky130_fd_sc_hd__decap_3
XFILLER_18_366 VGND VGND VPWR VPWR sky130_fd_sc_hd__decap_3
XFILLER_45_152 VGND VGND VPWR VPWR sky130_fd_sc_hd__decap_3
XFILLER_18_399 VGND VGND VPWR VPWR sky130_fd_sc_hd__decap_3
XFILLER_60_100 VGND VGND VPWR VPWR sky130_fd_sc_hd__decap_3
XFILLER_45_196 VGND VGND VPWR VPWR sky130_fd_sc_hd__decap_3
XFILLER_33_314 VGND VGND VPWR VPWR sky130_fd_sc_hd__decap_3
XFILLER_60_144 VGND VGND VPWR VPWR sky130_fd_sc_hd__decap_3
XFILLER_60_133 VGND VGND VPWR VPWR sky130_fd_sc_hd__decap_3
XFILLER_33_358 VGND VGND VPWR VPWR sky130_fd_sc_hd__decap_3
XFILLER_60_177 VGND VGND VPWR VPWR sky130_fd_sc_hd__decap_3
XTAP_TAPCELL_ROW_43_397 VGND VPWR sky130_fd_sc_hd__tapvpwrvgnd_1
XFILLER_41_391 VGND VGND VPWR VPWR sky130_fd_sc_hd__fill_1
XFILLER_53_3 VGND VGND VPWR VPWR sky130_fd_sc_hd__decap_3
Xinput2 a[10] VGND VGND VPWR VPWR net2 sky130_fd_sc_hd__buf_1
XFILLER_36_141 VGND VGND VPWR VPWR sky130_fd_sc_hd__decap_3
XFILLER_36_130 VGND VGND VPWR VPWR sky130_fd_sc_hd__decap_3
XFILLER_24_336 VGND VGND VPWR VPWR sky130_fd_sc_hd__decap_3
XFILLER_36_174 VGND VGND VPWR VPWR sky130_fd_sc_hd__decap_3
XTAP_TAPCELL_ROW_34_331 VGND VPWR sky130_fd_sc_hd__tapvpwrvgnd_1
XFILLER_51_155 VGND VGND VPWR VPWR sky130_fd_sc_hd__decap_3
XFILLER_51_122 VGND VGND VPWR VPWR sky130_fd_sc_hd__decap_3
XPHY_EDGE_ROW_27_Right_48 VGND VGND VPWR VPWR sky130_fd_sc_hd__decap_3
XFILLER_51_199 VGND VGND VPWR VPWR sky130_fd_sc_hd__decap_3
XFILLER_32_380 VGND VGND VPWR VPWR sky130_fd_sc_hd__decap_3
XFILLER_10_12 VGND VGND VPWR VPWR sky130_fd_sc_hd__decap_3
XFILLER_10_56 VGND VGND VPWR VPWR sky130_fd_sc_hd__decap_3
XPHY_EDGE_ROW_36_Right_57 VGND VGND VPWR VPWR sky130_fd_sc_hd__decap_3
XFILLER_59_211 VGND VGND VPWR VPWR sky130_fd_sc_hd__decap_3
XFILLER_59_255 VGND VGND VPWR VPWR sky130_fd_sc_hd__decap_3
XFILLER_19_119 VGND VGND VPWR VPWR sky130_fd_sc_hd__decap_3
XFILLER_19_43 VGND VGND VPWR VPWR sky130_fd_sc_hd__decap_3
XFILLER_19_87 VGND VGND VPWR VPWR sky130_fd_sc_hd__decap_3
XFILLER_59_299 VGND VGND VPWR VPWR sky130_fd_sc_hd__decap_3
XFILLER_27_152 VGND VGND VPWR VPWR sky130_fd_sc_hd__decap_3
XFILLER_42_111 VGND VGND VPWR VPWR sky130_fd_sc_hd__decap_3
XFILLER_15_358 VGND VGND VPWR VPWR sky130_fd_sc_hd__decap_3
XFILLER_27_196 VGND VGND VPWR VPWR sky130_fd_sc_hd__decap_3
XPHY_EDGE_ROW_45_Right_66 VGND VGND VPWR VPWR sky130_fd_sc_hd__decap_3
XFILLER_42_144 VGND VGND VPWR VPWR sky130_fd_sc_hd__decap_3
XFILLER_35_75 VGND VGND VPWR VPWR sky130_fd_sc_hd__decap_3
XFILLER_35_53 VGND VGND VPWR VPWR sky130_fd_sc_hd__decap_3
XFILLER_42_177 VGND VGND VPWR VPWR sky130_fd_sc_hd__decap_3
XFILLER_23_391 VGND VGND VPWR VPWR sky130_fd_sc_hd__fill_1
X_213_ net59 VGND VGND VPWR VPWR _008_ sky130_fd_sc_hd__inv_2
XFILLER_30_339 VGND VGND VPWR VPWR sky130_fd_sc_hd__decap_3
XFILLER_51_63 VGND VGND VPWR VPWR sky130_fd_sc_hd__decap_3
XFILLER_51_52 VGND VGND VPWR VPWR sky130_fd_sc_hd__decap_3
XTAP_TAPCELL_ROW_40_378 VGND VPWR sky130_fd_sc_hd__tapvpwrvgnd_1
X_144_ _063_ _064_ VGND VGND VPWR VPWR genblk1\[3\].fa_inst.s sky130_fd_sc_hd__xnor2_1
XPHY_EDGE_ROW_54_Right_75 VGND VGND VPWR VPWR sky130_fd_sc_hd__decap_3
XFILLER_18_6 VGND VGND VPWR VPWR sky130_fd_sc_hd__decap_3
XTAP_TAPCELL_ROW_48_434 VGND VPWR sky130_fd_sc_hd__tapvpwrvgnd_1
XFILLER_18_130 VGND VGND VPWR VPWR sky130_fd_sc_hd__decap_3
XFILLER_18_141 VGND VGND VPWR VPWR sky130_fd_sc_hd__decap_3
XFILLER_18_174 VGND VGND VPWR VPWR sky130_fd_sc_hd__decap_3
XPHY_EDGE_ROW_63_Right_84 VGND VGND VPWR VPWR sky130_fd_sc_hd__decap_3
XFILLER_33_122 VGND VGND VPWR VPWR sky130_fd_sc_hd__decap_3
XFILLER_33_155 VGND VGND VPWR VPWR sky130_fd_sc_hd__decap_3
XTAP_TAPCELL_ROW_31_312 VGND VPWR sky130_fd_sc_hd__tapvpwrvgnd_1
XFILLER_33_199 VGND VGND VPWR VPWR sky130_fd_sc_hd__decap_3
XFILLER_56_203 VGND VGND VPWR VPWR sky130_fd_sc_hd__decap_3
XFILLER_56_236 VGND VGND VPWR VPWR sky130_fd_sc_hd__decap_3
XFILLER_24_111 VGND VGND VPWR VPWR sky130_fd_sc_hd__decap_3
XFILLER_24_144 VGND VGND VPWR VPWR sky130_fd_sc_hd__decap_3
XFILLER_24_177 VGND VGND VPWR VPWR sky130_fd_sc_hd__decap_3
XFILLER_20_372 VGND VGND VPWR VPWR sky130_fd_sc_hd__decap_3
XFILLER_21_44 VGND VGND VPWR VPWR sky130_fd_sc_hd__decap_3
XFILLER_21_77 VGND VGND VPWR VPWR sky130_fd_sc_hd__decap_3
XFILLER_21_88 VGND VGND VPWR VPWR sky130_fd_sc_hd__decap_3
XFILLER_47_225 VGND VGND VPWR VPWR sky130_fd_sc_hd__decap_3
XFILLER_47_214 VGND VGND VPWR VPWR sky130_fd_sc_hd__decap_3
XFILLER_62_206 VGND VGND VPWR VPWR sky130_fd_sc_hd__decap_3
XFILLER_47_258 VGND VGND VPWR VPWR sky130_fd_sc_hd__decap_3
XFILLER_46_41 VGND VGND VPWR VPWR sky130_fd_sc_hd__decap_3
XFILLER_62_239 VGND VGND VPWR VPWR sky130_fd_sc_hd__decap_3
XFILLER_46_85 VGND VGND VPWR VPWR sky130_fd_sc_hd__decap_3
XFILLER_46_74 VGND VGND VPWR VPWR sky130_fd_sc_hd__decap_3
XFILLER_15_111 VGND VGND VPWR VPWR sky130_fd_sc_hd__fill_1
XFILLER_15_122 VGND VGND VPWR VPWR sky130_fd_sc_hd__decap_3
XFILLER_15_155 VGND VGND VPWR VPWR sky130_fd_sc_hd__decap_3
XFILLER_30_103 VGND VGND VPWR VPWR sky130_fd_sc_hd__decap_3
XFILLER_62_62 VGND VGND VPWR VPWR sky130_fd_sc_hd__decap_3
XFILLER_30_136 VGND VGND VPWR VPWR sky130_fd_sc_hd__decap_3
XFILLER_30_147 VGND VGND VPWR VPWR sky130_fd_sc_hd__decap_3
XFILLER_11_361 VGND VGND VPWR VPWR sky130_fd_sc_hd__decap_3
XFILLER_7_24 VGND VGND VPWR VPWR sky130_fd_sc_hd__decap_3
XFILLER_11_394 VGND VGND VPWR VPWR sky130_fd_sc_hd__decap_3
XFILLER_7_343 VGND VGND VPWR VPWR sky130_fd_sc_hd__decap_3
XFILLER_7_57 VGND VGND VPWR VPWR sky130_fd_sc_hd__decap_3
X_127_ genblk1\[0\].fa_inst.b genblk1\[0\].fa_inst.a VGND VGND VPWR VPWR _051_ sky130_fd_sc_hd__nand2_1
XFILLER_7_376 VGND VGND VPWR VPWR sky130_fd_sc_hd__decap_3
XFILLER_38_203 VGND VGND VPWR VPWR sky130_fd_sc_hd__decap_3
XFILLER_38_236 VGND VGND VPWR VPWR sky130_fd_sc_hd__decap_3
XFILLER_53_228 VGND VGND VPWR VPWR sky130_fd_sc_hd__decap_3
XFILLER_53_217 VGND VGND VPWR VPWR sky130_fd_sc_hd__decap_3
XFILLER_46_280 VGND VGND VPWR VPWR sky130_fd_sc_hd__decap_3
XFILLER_61_261 VGND VGND VPWR VPWR sky130_fd_sc_hd__decap_3
XFILLER_21_125 VGND VGND VPWR VPWR sky130_fd_sc_hd__decap_3
XFILLER_21_147 VGND VGND VPWR VPWR sky130_fd_sc_hd__decap_3
XFILLER_21_169 VGND VGND VPWR VPWR sky130_fd_sc_hd__decap_3
XTAP_TAPCELL_ROW_59_507 VGND VPWR sky130_fd_sc_hd__tapvpwrvgnd_1
XFILLER_29_225 VGND VGND VPWR VPWR sky130_fd_sc_hd__decap_3
XFILLER_29_214 VGND VGND VPWR VPWR sky130_fd_sc_hd__decap_3
XFILLER_29_258 VGND VGND VPWR VPWR sky130_fd_sc_hd__decap_3
XFILLER_44_206 VGND VGND VPWR VPWR sky130_fd_sc_hd__decap_3
XFILLER_16_44 VGND VGND VPWR VPWR sky130_fd_sc_hd__decap_3
XFILLER_44_239 VGND VGND VPWR VPWR sky130_fd_sc_hd__decap_3
XFILLER_16_77 VGND VGND VPWR VPWR sky130_fd_sc_hd__decap_3
XFILLER_40_401 VGND VGND VPWR VPWR sky130_fd_sc_hd__decap_3
XFILLER_12_136 VGND VGND VPWR VPWR sky130_fd_sc_hd__decap_3
XFILLER_16_88 VGND VGND VPWR VPWR sky130_fd_sc_hd__fill_2
XFILLER_52_283 VGND VGND VPWR VPWR sky130_fd_sc_hd__decap_3
XFILLER_12_147 VGND VGND VPWR VPWR sky130_fd_sc_hd__decap_3
XFILLER_32_21 VGND VGND VPWR VPWR sky130_fd_sc_hd__decap_3
XFILLER_32_65 VGND VGND VPWR VPWR sky130_fd_sc_hd__decap_3
XFILLER_32_32 VGND VGND VPWR VPWR sky130_fd_sc_hd__decap_3
XFILLER_4_357 VGND VGND VPWR VPWR sky130_fd_sc_hd__decap_3
XFILLER_4_346 VGND VGND VPWR VPWR sky130_fd_sc_hd__decap_3
XFILLER_57_40 VGND VGND VPWR VPWR sky130_fd_sc_hd__decap_3
XFILLER_57_95 VGND VGND VPWR VPWR sky130_fd_sc_hd__decap_3
XFILLER_35_228 VGND VGND VPWR VPWR sky130_fd_sc_hd__decap_3
XFILLER_35_217 VGND VGND VPWR VPWR sky130_fd_sc_hd__decap_3
XFILLER_28_280 VGND VGND VPWR VPWR sky130_fd_sc_hd__decap_3
XFILLER_50_209 VGND VGND VPWR VPWR sky130_fd_sc_hd__decap_3
XFILLER_43_261 VGND VGND VPWR VPWR sky130_fd_sc_hd__decap_3
XFILLER_7_140 VGND VGND VPWR VPWR sky130_fd_sc_hd__decap_3
XFILLER_58_309 VGND VGND VPWR VPWR sky130_fd_sc_hd__decap_3
XFILLER_26_206 VGND VGND VPWR VPWR sky130_fd_sc_hd__decap_3
XFILLER_26_239 VGND VGND VPWR VPWR sky130_fd_sc_hd__decap_3
XTAP_TAPCELL_ROW_64_543 VGND VPWR sky130_fd_sc_hd__tapvpwrvgnd_1
XFILLER_22_401 VGND VGND VPWR VPWR sky130_fd_sc_hd__decap_3
XFILLER_34_283 VGND VGND VPWR VPWR sky130_fd_sc_hd__decap_3
XFILLER_1_349 VGND VGND VPWR VPWR sky130_fd_sc_hd__decap_3
XFILLER_57_320 VGND VGND VPWR VPWR sky130_fd_sc_hd__decap_3
XFILLER_57_364 VGND VGND VPWR VPWR sky130_fd_sc_hd__decap_3
XFILLER_27_87 VGND VGND VPWR VPWR sky130_fd_sc_hd__decap_3
XFILLER_32_209 VGND VGND VPWR VPWR sky130_fd_sc_hd__decap_3
XFILLER_25_261 VGND VGND VPWR VPWR sky130_fd_sc_hd__decap_3
XFILLER_43_42 VGND VGND VPWR VPWR sky130_fd_sc_hd__decap_3
XFILLER_40_253 VGND VGND VPWR VPWR sky130_fd_sc_hd__decap_3
XFILLER_40_242 VGND VGND VPWR VPWR sky130_fd_sc_hd__decap_3
XFILLER_43_75 VGND VGND VPWR VPWR sky130_fd_sc_hd__decap_3
XFILLER_40_286 VGND VGND VPWR VPWR sky130_fd_sc_hd__decap_3
XFILLER_4_121 VGND VGND VPWR VPWR sky130_fd_sc_hd__decap_3
XFILLER_4_165 VGND VGND VPWR VPWR sky130_fd_sc_hd__decap_3
XFILLER_4_47 VGND VGND VPWR VPWR sky130_fd_sc_hd__decap_3
XFILLER_0_360 VGND VGND VPWR VPWR sky130_fd_sc_hd__decap_3
XFILLER_0_382 VGND VGND VPWR VPWR sky130_fd_sc_hd__decap_3
XFILLER_48_342 VGND VGND VPWR VPWR sky130_fd_sc_hd__decap_3
XFILLER_48_386 VGND VGND VPWR VPWR sky130_fd_sc_hd__decap_3
XFILLER_63_323 VGND VGND VPWR VPWR sky130_fd_sc_hd__decap_3
XFILLER_63_367 VGND VGND VPWR VPWR sky130_fd_sc_hd__decap_3
XTAP_TAPCELL_ROW_61_524 VGND VPWR sky130_fd_sc_hd__tapvpwrvgnd_1
XFILLER_31_231 VGND VGND VPWR VPWR sky130_fd_sc_hd__decap_3
XFILLER_31_220 VGND VGND VPWR VPWR sky130_fd_sc_hd__decap_3
XFILLER_31_264 VGND VGND VPWR VPWR sky130_fd_sc_hd__decap_3
XFILLER_58_128 VGND VGND VPWR VPWR sky130_fd_sc_hd__decap_3
XFILLER_39_320 VGND VGND VPWR VPWR sky130_fd_sc_hd__decap_3
XFILLER_54_312 VGND VGND VPWR VPWR sky130_fd_sc_hd__decap_3
XFILLER_54_301 VGND VGND VPWR VPWR sky130_fd_sc_hd__decap_3
XFILLER_39_364 VGND VGND VPWR VPWR sky130_fd_sc_hd__decap_3
XFILLER_54_345 VGND VGND VPWR VPWR sky130_fd_sc_hd__decap_3
XFILLER_54_389 VGND VGND VPWR VPWR sky130_fd_sc_hd__decap_3
XFILLER_13_12 VGND VGND VPWR VPWR sky130_fd_sc_hd__fill_2
XFILLER_22_253 VGND VGND VPWR VPWR sky130_fd_sc_hd__decap_3
XFILLER_22_286 VGND VGND VPWR VPWR sky130_fd_sc_hd__decap_3
Xfanout57 net58 VGND VGND VPWR VPWR net57 sky130_fd_sc_hd__buf_2
XFILLER_13_34 VGND VGND VPWR VPWR sky130_fd_sc_hd__decap_3
XFILLER_13_78 VGND VGND VPWR VPWR sky130_fd_sc_hd__decap_3
XFILLER_1_102 VGND VGND VPWR VPWR sky130_fd_sc_hd__decap_3
XFILLER_1_113 VGND VGND VPWR VPWR sky130_fd_sc_hd__decap_3
XFILLER_1_146 VGND VGND VPWR VPWR sky130_fd_sc_hd__decap_3
XFILLER_49_128 VGND VGND VPWR VPWR sky130_fd_sc_hd__decap_3
XFILLER_49_106 VGND VGND VPWR VPWR sky130_fd_sc_hd__decap_3
XFILLER_38_53 VGND VGND VPWR VPWR sky130_fd_sc_hd__decap_3
XFILLER_64_109 VGND VGND VPWR VPWR sky130_fd_sc_hd__decap_3
XFILLER_57_161 VGND VGND VPWR VPWR sky130_fd_sc_hd__decap_3
XFILLER_38_97 VGND VGND VPWR VPWR sky130_fd_sc_hd__decap_3
XFILLER_57_172 VGND VGND VPWR VPWR sky130_fd_sc_hd__decap_3
XFILLER_45_323 VGND VGND VPWR VPWR sky130_fd_sc_hd__decap_3
XFILLER_60_304 VGND VGND VPWR VPWR sky130_fd_sc_hd__decap_3
XFILLER_54_41 VGND VGND VPWR VPWR sky130_fd_sc_hd__decap_3
XFILLER_45_367 VGND VGND VPWR VPWR sky130_fd_sc_hd__decap_3
XFILLER_60_315 VGND VGND VPWR VPWR sky130_fd_sc_hd__decap_3
XFILLER_54_74 VGND VGND VPWR VPWR sky130_fd_sc_hd__decap_3
XFILLER_60_348 VGND VGND VPWR VPWR sky130_fd_sc_hd__decap_3
XFILLER_54_85 VGND VGND VPWR VPWR sky130_fd_sc_hd__decap_3
XFILLER_48_6 VGND VGND VPWR VPWR sky130_fd_sc_hd__decap_3
XFILLER_48_150 VGND VGND VPWR VPWR sky130_fd_sc_hd__decap_3
XFILLER_36_301 VGND VGND VPWR VPWR sky130_fd_sc_hd__decap_3
XFILLER_48_183 VGND VGND VPWR VPWR sky130_fd_sc_hd__decap_3
XFILLER_36_345 VGND VGND VPWR VPWR sky130_fd_sc_hd__decap_3
XFILLER_36_312 VGND VGND VPWR VPWR sky130_fd_sc_hd__decap_3
XFILLER_63_131 VGND VGND VPWR VPWR sky130_fd_sc_hd__decap_3
XFILLER_63_164 VGND VGND VPWR VPWR sky130_fd_sc_hd__decap_3
XFILLER_63_175 VGND VGND VPWR VPWR sky130_fd_sc_hd__decap_3
XFILLER_51_337 VGND VGND VPWR VPWR sky130_fd_sc_hd__decap_3
XFILLER_51_326 VGND VGND VPWR VPWR sky130_fd_sc_hd__decap_3
XFILLER_36_389 VGND VGND VPWR VPWR sky130_fd_sc_hd__decap_3
XFILLER_46_109 VGND VGND VPWR VPWR sky130_fd_sc_hd__decap_3
XFILLER_39_161 VGND VGND VPWR VPWR sky130_fd_sc_hd__decap_3
XFILLER_27_323 VGND VGND VPWR VPWR sky130_fd_sc_hd__decap_3
XFILLER_39_172 VGND VGND VPWR VPWR sky130_fd_sc_hd__decap_3
XFILLER_27_367 VGND VGND VPWR VPWR sky130_fd_sc_hd__decap_3
XFILLER_54_153 VGND VGND VPWR VPWR sky130_fd_sc_hd__decap_3
XTAP_TAPCELL_ROW_37_351 VGND VPWR sky130_fd_sc_hd__tapvpwrvgnd_1
XFILLER_54_197 VGND VGND VPWR VPWR sky130_fd_sc_hd__decap_3
XFILLER_54_186 VGND VGND VPWR VPWR sky130_fd_sc_hd__decap_3
XFILLER_42_315 VGND VGND VPWR VPWR sky130_fd_sc_hd__decap_3
XFILLER_42_304 VGND VGND VPWR VPWR sky130_fd_sc_hd__decap_3
XFILLER_42_348 VGND VGND VPWR VPWR sky130_fd_sc_hd__decap_3
XFILLER_24_44 VGND VGND VPWR VPWR sky130_fd_sc_hd__decap_3
XFILLER_24_77 VGND VGND VPWR VPWR sky130_fd_sc_hd__decap_3
X_160_ genblk1\[7\].fa_inst.b genblk1\[7\].fa_inst.a VGND VGND VPWR VPWR _077_ sky130_fd_sc_hd__or2_1
XFILLER_50_392 VGND VGND VPWR VPWR sky130_fd_sc_hd__decap_3
XFILLER_40_32 VGND VGND VPWR VPWR sky130_fd_sc_hd__decap_3
XFILLER_40_21 VGND VGND VPWR VPWR sky130_fd_sc_hd__decap_3
XFILLER_40_76 VGND VGND VPWR VPWR sky130_fd_sc_hd__decap_3
XFILLER_40_65 VGND VGND VPWR VPWR sky130_fd_sc_hd__decap_3
XFILLER_49_63 VGND VGND VPWR VPWR sky130_fd_sc_hd__fill_2
XFILLER_49_41 VGND VGND VPWR VPWR sky130_fd_sc_hd__decap_3
XFILLER_49_85 VGND VGND VPWR VPWR sky130_fd_sc_hd__decap_3
XFILLER_1_15 VGND VGND VPWR VPWR sky130_fd_sc_hd__decap_3
XFILLER_18_334 VGND VGND VPWR VPWR sky130_fd_sc_hd__decap_3
XFILLER_1_48 VGND VGND VPWR VPWR sky130_fd_sc_hd__decap_3
XFILLER_45_131 VGND VGND VPWR VPWR sky130_fd_sc_hd__decap_3
XFILLER_18_378 VGND VGND VPWR VPWR sky130_fd_sc_hd__decap_3
XFILLER_60_112 VGND VGND VPWR VPWR sky130_fd_sc_hd__decap_3
XFILLER_45_175 VGND VGND VPWR VPWR sky130_fd_sc_hd__decap_3
XFILLER_45_164 VGND VGND VPWR VPWR sky130_fd_sc_hd__decap_3
XFILLER_33_337 VGND VGND VPWR VPWR sky130_fd_sc_hd__decap_3
XFILLER_33_326 VGND VGND VPWR VPWR sky130_fd_sc_hd__decap_3
XFILLER_60_189 VGND VGND VPWR VPWR sky130_fd_sc_hd__decap_3
XFILLER_60_156 VGND VGND VPWR VPWR sky130_fd_sc_hd__decap_3
XTAP_TAPCELL_ROW_43_398 VGND VPWR sky130_fd_sc_hd__tapvpwrvgnd_1
XFILLER_41_370 VGND VGND VPWR VPWR sky130_fd_sc_hd__decap_3
X_289_ clknet_2_1__leaf_clk_regs net24 _034_ VGND VGND VPWR VPWR genblk1\[1\].fa_inst.b
+ sky130_fd_sc_hd__dfrtp_1
Xinput3 a[11] VGND VGND VPWR VPWR net3 sky130_fd_sc_hd__buf_1
XFILLER_36_153 VGND VGND VPWR VPWR sky130_fd_sc_hd__decap_3
XFILLER_24_304 VGND VGND VPWR VPWR sky130_fd_sc_hd__decap_3
XFILLER_24_315 VGND VGND VPWR VPWR sky130_fd_sc_hd__decap_3
XFILLER_51_101 VGND VGND VPWR VPWR sky130_fd_sc_hd__decap_3
XFILLER_36_186 VGND VGND VPWR VPWR sky130_fd_sc_hd__decap_3
XFILLER_24_348 VGND VGND VPWR VPWR sky130_fd_sc_hd__decap_3
XTAP_TAPCELL_ROW_34_332 VGND VPWR sky130_fd_sc_hd__tapvpwrvgnd_1
XFILLER_51_134 VGND VGND VPWR VPWR sky130_fd_sc_hd__decap_3
XFILLER_36_197 VGND VGND VPWR VPWR sky130_fd_sc_hd__decap_3
XFILLER_51_178 VGND VGND VPWR VPWR sky130_fd_sc_hd__decap_3
XFILLER_51_167 VGND VGND VPWR VPWR sky130_fd_sc_hd__fill_1
XFILLER_32_392 VGND VGND VPWR VPWR sky130_fd_sc_hd__decap_3
XFILLER_10_24 VGND VGND VPWR VPWR sky130_fd_sc_hd__decap_3
XFILLER_10_35 VGND VGND VPWR VPWR sky130_fd_sc_hd__decap_3
XFILLER_59_234 VGND VGND VPWR VPWR sky130_fd_sc_hd__decap_3
XFILLER_59_223 VGND VGND VPWR VPWR sky130_fd_sc_hd__fill_1
XFILLER_19_55 VGND VGND VPWR VPWR sky130_fd_sc_hd__fill_1
XFILLER_59_267 VGND VGND VPWR VPWR sky130_fd_sc_hd__decap_3
XFILLER_19_66 VGND VGND VPWR VPWR sky130_fd_sc_hd__decap_3
XFILLER_27_131 VGND VGND VPWR VPWR sky130_fd_sc_hd__decap_3
XFILLER_27_164 VGND VGND VPWR VPWR sky130_fd_sc_hd__decap_3
XFILLER_27_175 VGND VGND VPWR VPWR sky130_fd_sc_hd__decap_3
XFILLER_15_337 VGND VGND VPWR VPWR sky130_fd_sc_hd__decap_3
XFILLER_42_123 VGND VGND VPWR VPWR sky130_fd_sc_hd__decap_3
XFILLER_42_156 VGND VGND VPWR VPWR sky130_fd_sc_hd__decap_3
XFILLER_35_87 VGND VGND VPWR VPWR sky130_fd_sc_hd__decap_3
XFILLER_30_318 VGND VGND VPWR VPWR sky130_fd_sc_hd__decap_3
XFILLER_30_307 VGND VGND VPWR VPWR sky130_fd_sc_hd__fill_1
XFILLER_23_370 VGND VGND VPWR VPWR sky130_fd_sc_hd__decap_3
X_212_ net58 VGND VGND VPWR VPWR _007_ sky130_fd_sc_hd__inv_2
XFILLER_42_189 VGND VGND VPWR VPWR sky130_fd_sc_hd__decap_3
X_143_ _057_ _058_ _059_ VGND VGND VPWR VPWR _064_ sky130_fd_sc_hd__a21bo_1
XFILLER_51_86 VGND VGND VPWR VPWR sky130_fd_sc_hd__decap_3
XFILLER_32_9 VGND VGND VPWR VPWR sky130_fd_sc_hd__decap_3
XFILLER_18_153 VGND VGND VPWR VPWR sky130_fd_sc_hd__decap_3
XFILLER_33_101 VGND VGND VPWR VPWR sky130_fd_sc_hd__decap_3
XTAP_TAPCELL_ROW_56_490 VGND VPWR sky130_fd_sc_hd__tapvpwrvgnd_1
XFILLER_33_134 VGND VGND VPWR VPWR sky130_fd_sc_hd__decap_3
XFILLER_21_318 VGND VGND VPWR VPWR sky130_fd_sc_hd__decap_3
XFILLER_33_178 VGND VGND VPWR VPWR sky130_fd_sc_hd__decap_3
XFILLER_33_167 VGND VGND VPWR VPWR sky130_fd_sc_hd__fill_1
XFILLER_14_381 VGND VGND VPWR VPWR sky130_fd_sc_hd__decap_3
XTAP_TAPCELL_ROW_31_313 VGND VPWR sky130_fd_sc_hd__tapvpwrvgnd_1
XFILLER_56_215 VGND VGND VPWR VPWR sky130_fd_sc_hd__decap_3
XFILLER_2_80 VGND VGND VPWR VPWR sky130_fd_sc_hd__decap_3
XFILLER_56_259 VGND VGND VPWR VPWR sky130_fd_sc_hd__decap_3
XFILLER_56_248 VGND VGND VPWR VPWR sky130_fd_sc_hd__decap_3
XFILLER_2_91 VGND VGND VPWR VPWR sky130_fd_sc_hd__decap_3
XFILLER_24_123 VGND VGND VPWR VPWR sky130_fd_sc_hd__decap_3
XFILLER_64_281 VGND VGND VPWR VPWR sky130_fd_sc_hd__decap_3
XFILLER_24_156 VGND VGND VPWR VPWR sky130_fd_sc_hd__decap_3
XFILLER_24_189 VGND VGND VPWR VPWR sky130_fd_sc_hd__decap_3
XFILLER_20_340 VGND VGND VPWR VPWR sky130_fd_sc_hd__decap_3
XPHY_EDGE_ROW_25_Left_131 VGND VGND VPWR VPWR sky130_fd_sc_hd__decap_3
XFILLER_20_384 VGND VGND VPWR VPWR sky130_fd_sc_hd__decap_3
XFILLER_21_12 VGND VGND VPWR VPWR sky130_fd_sc_hd__decap_3
XPHY_EDGE_ROW_34_Left_140 VGND VGND VPWR VPWR sky130_fd_sc_hd__decap_3
XFILLER_47_237 VGND VGND VPWR VPWR sky130_fd_sc_hd__decap_3
XFILLER_62_218 VGND VGND VPWR VPWR sky130_fd_sc_hd__decap_3
XFILLER_55_270 VGND VGND VPWR VPWR sky130_fd_sc_hd__decap_3
XFILLER_46_53 VGND VGND VPWR VPWR sky130_fd_sc_hd__decap_3
XFILLER_15_134 VGND VGND VPWR VPWR sky130_fd_sc_hd__decap_3
XFILLER_55_281 VGND VGND VPWR VPWR sky130_fd_sc_hd__decap_3
XFILLER_46_97 VGND VGND VPWR VPWR sky130_fd_sc_hd__decap_3
XFILLER_15_167 VGND VGND VPWR VPWR sky130_fd_sc_hd__fill_1
XFILLER_15_178 VGND VGND VPWR VPWR sky130_fd_sc_hd__fill_2
XFILLER_62_41 VGND VGND VPWR VPWR sky130_fd_sc_hd__decap_3
XFILLER_30_115 VGND VGND VPWR VPWR sky130_fd_sc_hd__decap_3
XFILLER_11_340 VGND VGND VPWR VPWR sky130_fd_sc_hd__decap_3
XFILLER_62_74 VGND VGND VPWR VPWR sky130_fd_sc_hd__decap_3
XFILLER_62_85 VGND VGND VPWR VPWR sky130_fd_sc_hd__decap_3
XFILLER_30_159 VGND VGND VPWR VPWR sky130_fd_sc_hd__decap_3
XFILLER_11_373 VGND VGND VPWR VPWR sky130_fd_sc_hd__decap_3
XFILLER_7_36 VGND VGND VPWR VPWR sky130_fd_sc_hd__decap_3
XFILLER_7_355 VGND VGND VPWR VPWR sky130_fd_sc_hd__decap_3
X_126_ genblk1\[0\].fa_inst.b genblk1\[0\].fa_inst.a VGND VGND VPWR VPWR _050_ sky130_fd_sc_hd__or2_1
XFILLER_7_388 VGND VGND VPWR VPWR sky130_fd_sc_hd__decap_3
XFILLER_30_6 VGND VGND VPWR VPWR sky130_fd_sc_hd__decap_3
XPHY_EDGE_ROW_12_1_Left_118 VGND VGND VPWR VPWR sky130_fd_sc_hd__decap_3
XFILLER_38_215 VGND VGND VPWR VPWR sky130_fd_sc_hd__decap_3
XFILLER_38_259 VGND VGND VPWR VPWR sky130_fd_sc_hd__decap_3
XFILLER_38_248 VGND VGND VPWR VPWR sky130_fd_sc_hd__decap_3
XFILLER_46_292 VGND VGND VPWR VPWR sky130_fd_sc_hd__decap_3
XFILLER_61_240 VGND VGND VPWR VPWR sky130_fd_sc_hd__decap_3
XFILLER_61_284 VGND VGND VPWR VPWR sky130_fd_sc_hd__decap_3
XFILLER_61_273 VGND VGND VPWR VPWR sky130_fd_sc_hd__decap_3
XFILLER_21_137 VGND VGND VPWR VPWR sky130_fd_sc_hd__decap_3
XFILLER_21_159 VGND VGND VPWR VPWR sky130_fd_sc_hd__decap_3
XTAP_TAPCELL_ROW_59_508 VGND VPWR sky130_fd_sc_hd__tapvpwrvgnd_1
XFILLER_29_237 VGND VGND VPWR VPWR sky130_fd_sc_hd__decap_3
XFILLER_44_218 VGND VGND VPWR VPWR sky130_fd_sc_hd__decap_3
XFILLER_16_12 VGND VGND VPWR VPWR sky130_fd_sc_hd__decap_3
XFILLER_37_281 VGND VGND VPWR VPWR sky130_fd_sc_hd__decap_3
XFILLER_37_270 VGND VGND VPWR VPWR sky130_fd_sc_hd__decap_3
XFILLER_16_56 VGND VGND VPWR VPWR sky130_fd_sc_hd__decap_3
XFILLER_52_262 VGND VGND VPWR VPWR sky130_fd_sc_hd__decap_3
XFILLER_52_251 VGND VGND VPWR VPWR sky130_fd_sc_hd__fill_1
XFILLER_12_115 VGND VGND VPWR VPWR sky130_fd_sc_hd__decap_3
XFILLER_52_295 VGND VGND VPWR VPWR sky130_fd_sc_hd__decap_3
XFILLER_12_159 VGND VGND VPWR VPWR sky130_fd_sc_hd__decap_3
XFILLER_32_44 VGND VGND VPWR VPWR sky130_fd_sc_hd__decap_3
XFILLER_32_88 VGND VGND VPWR VPWR sky130_fd_sc_hd__decap_3
XFILLER_4_369 VGND VGND VPWR VPWR sky130_fd_sc_hd__decap_3
XFILLER_57_52 VGND VGND VPWR VPWR sky130_fd_sc_hd__decap_3
XFILLER_57_63 VGND VGND VPWR VPWR sky130_fd_sc_hd__decap_3
XFILLER_28_292 VGND VGND VPWR VPWR sky130_fd_sc_hd__decap_3
XFILLER_43_240 VGND VGND VPWR VPWR sky130_fd_sc_hd__decap_3
XFILLER_31_402 VGND VGND VPWR VPWR sky130_fd_sc_hd__decap_3
XFILLER_43_284 VGND VGND VPWR VPWR sky130_fd_sc_hd__decap_3
XFILLER_43_273 VGND VGND VPWR VPWR sky130_fd_sc_hd__decap_3
XFILLER_7_152 VGND VGND VPWR VPWR sky130_fd_sc_hd__decap_3
XPHY_EDGE_ROW_10_2_Right_96 VGND VGND VPWR VPWR sky130_fd_sc_hd__decap_3
XFILLER_3_391 VGND VGND VPWR VPWR sky130_fd_sc_hd__decap_3
XFILLER_26_218 VGND VGND VPWR VPWR sky130_fd_sc_hd__decap_3
XTAP_TAPCELL_ROW_64_544 VGND VPWR sky130_fd_sc_hd__tapvpwrvgnd_1
XFILLER_34_251 VGND VGND VPWR VPWR sky130_fd_sc_hd__fill_1
XFILLER_34_262 VGND VGND VPWR VPWR sky130_fd_sc_hd__decap_3
XFILLER_34_295 VGND VGND VPWR VPWR sky130_fd_sc_hd__decap_3
XFILLER_1_328 VGND VGND VPWR VPWR sky130_fd_sc_hd__decap_3
XFILLER_57_343 VGND VGND VPWR VPWR sky130_fd_sc_hd__decap_3
XFILLER_57_332 VGND VGND VPWR VPWR sky130_fd_sc_hd__decap_3
XFILLER_27_44 VGND VGND VPWR VPWR sky130_fd_sc_hd__decap_3
XFILLER_57_376 VGND VGND VPWR VPWR sky130_fd_sc_hd__decap_3
XFILLER_27_66 VGND VGND VPWR VPWR sky130_fd_sc_hd__decap_3
XFILLER_25_240 VGND VGND VPWR VPWR sky130_fd_sc_hd__decap_3
XFILLER_27_99 VGND VGND VPWR VPWR sky130_fd_sc_hd__decap_3
XFILLER_25_273 VGND VGND VPWR VPWR sky130_fd_sc_hd__decap_3
XFILLER_25_284 VGND VGND VPWR VPWR sky130_fd_sc_hd__decap_3
XFILLER_43_54 VGND VGND VPWR VPWR sky130_fd_sc_hd__fill_2
XFILLER_40_221 VGND VGND VPWR VPWR sky130_fd_sc_hd__decap_3
XFILLER_43_87 VGND VGND VPWR VPWR sky130_fd_sc_hd__decap_3
XFILLER_40_265 VGND VGND VPWR VPWR sky130_fd_sc_hd__decap_3
XFILLER_40_298 VGND VGND VPWR VPWR sky130_fd_sc_hd__decap_3
XFILLER_4_133 VGND VGND VPWR VPWR sky130_fd_sc_hd__decap_3
XPHY_EDGE_ROW_2_2_Left_23 VGND VGND VPWR VPWR sky130_fd_sc_hd__decap_3
XFILLER_4_144 VGND VGND VPWR VPWR sky130_fd_sc_hd__decap_3
XFILLER_4_59 VGND VGND VPWR VPWR sky130_fd_sc_hd__fill_1
XFILLER_4_177 VGND VGND VPWR VPWR sky130_fd_sc_hd__decap_3
XFILLER_0_372 VGND VGND VPWR VPWR sky130_fd_sc_hd__decap_3
XFILLER_0_394 VGND VGND VPWR VPWR sky130_fd_sc_hd__decap_3
XFILLER_48_321 VGND VGND VPWR VPWR sky130_fd_sc_hd__decap_3
XFILLER_63_302 VGND VGND VPWR VPWR sky130_fd_sc_hd__decap_3
XFILLER_48_365 VGND VGND VPWR VPWR sky130_fd_sc_hd__decap_3
XFILLER_48_354 VGND VGND VPWR VPWR sky130_fd_sc_hd__decap_3
XFILLER_63_335 VGND VGND VPWR VPWR sky130_fd_sc_hd__fill_1
XFILLER_63_346 VGND VGND VPWR VPWR sky130_fd_sc_hd__decap_3
XFILLER_48_398 VGND VGND VPWR VPWR sky130_fd_sc_hd__decap_3
XFILLER_63_379 VGND VGND VPWR VPWR sky130_fd_sc_hd__decap_3
XTAP_TAPCELL_ROW_61_525 VGND VPWR sky130_fd_sc_hd__tapvpwrvgnd_1
XFILLER_31_243 VGND VGND VPWR VPWR sky130_fd_sc_hd__decap_3
XFILLER_31_276 VGND VGND VPWR VPWR sky130_fd_sc_hd__decap_3
XFILLER_31_287 VGND VGND VPWR VPWR sky130_fd_sc_hd__decap_3
XFILLER_39_343 VGND VGND VPWR VPWR sky130_fd_sc_hd__decap_3
XFILLER_39_332 VGND VGND VPWR VPWR sky130_fd_sc_hd__decap_3
XFILLER_39_376 VGND VGND VPWR VPWR sky130_fd_sc_hd__decap_3
XFILLER_54_324 VGND VGND VPWR VPWR sky130_fd_sc_hd__decap_3
XFILLER_54_368 VGND VGND VPWR VPWR sky130_fd_sc_hd__decap_3
XFILLER_54_357 VGND VGND VPWR VPWR sky130_fd_sc_hd__decap_3
XFILLER_10_405 VGND VGND VPWR VPWR sky130_fd_sc_hd__fill_2
XFILLER_22_265 VGND VGND VPWR VPWR sky130_fd_sc_hd__decap_3
Xfanout58 net62 VGND VGND VPWR VPWR net58 sky130_fd_sc_hd__buf_4
XFILLER_13_46 VGND VGND VPWR VPWR sky130_fd_sc_hd__decap_3
XFILLER_13_57 VGND VGND VPWR VPWR sky130_fd_sc_hd__decap_3
XFILLER_22_298 VGND VGND VPWR VPWR sky130_fd_sc_hd__decap_3
XFILLER_1_125 VGND VGND VPWR VPWR sky130_fd_sc_hd__decap_3
XFILLER_8_6 VGND VGND VPWR VPWR sky130_fd_sc_hd__decap_3
XFILLER_1_158 VGND VGND VPWR VPWR sky130_fd_sc_hd__decap_3
XFILLER_1_169 VGND VGND VPWR VPWR sky130_fd_sc_hd__decap_3
XFILLER_38_21 VGND VGND VPWR VPWR sky130_fd_sc_hd__decap_3
XFILLER_38_32 VGND VGND VPWR VPWR sky130_fd_sc_hd__decap_3
XFILLER_57_140 VGND VGND VPWR VPWR sky130_fd_sc_hd__decap_3
XFILLER_45_302 VGND VGND VPWR VPWR sky130_fd_sc_hd__decap_3
XFILLER_38_76 VGND VGND VPWR VPWR sky130_fd_sc_hd__decap_3
XFILLER_38_65 VGND VGND VPWR VPWR sky130_fd_sc_hd__decap_3
XFILLER_57_184 VGND VGND VPWR VPWR sky130_fd_sc_hd__decap_3
XFILLER_45_335 VGND VGND VPWR VPWR sky130_fd_sc_hd__fill_1
XFILLER_45_379 VGND VGND VPWR VPWR sky130_fd_sc_hd__decap_3
XFILLER_45_346 VGND VGND VPWR VPWR sky130_fd_sc_hd__decap_3
XFILLER_60_327 VGND VGND VPWR VPWR sky130_fd_sc_hd__decap_3
XFILLER_54_53 VGND VGND VPWR VPWR sky130_fd_sc_hd__decap_3
XFILLER_54_97 VGND VGND VPWR VPWR sky130_fd_sc_hd__fill_1
XFILLER_62_9 VGND VGND VPWR VPWR sky130_fd_sc_hd__decap_3
XFILLER_48_162 VGND VGND VPWR VPWR sky130_fd_sc_hd__decap_3
XFILLER_48_195 VGND VGND VPWR VPWR sky130_fd_sc_hd__fill_1
XFILLER_36_324 VGND VGND VPWR VPWR sky130_fd_sc_hd__decap_3
XFILLER_63_143 VGND VGND VPWR VPWR sky130_fd_sc_hd__decap_3
XFILLER_36_368 VGND VGND VPWR VPWR sky130_fd_sc_hd__decap_3
XFILLER_36_357 VGND VGND VPWR VPWR sky130_fd_sc_hd__decap_3
XFILLER_63_187 VGND VGND VPWR VPWR sky130_fd_sc_hd__decap_3
XFILLER_51_305 VGND VGND VPWR VPWR sky130_fd_sc_hd__decap_3
XFILLER_51_349 VGND VGND VPWR VPWR sky130_fd_sc_hd__decap_3
XPHY_EDGE_ROW_15_1_Right_14 VGND VGND VPWR VPWR sky130_fd_sc_hd__decap_3
XFILLER_5_91 VGND VGND VPWR VPWR sky130_fd_sc_hd__decap_3
XFILLER_59_405 VGND VGND VPWR VPWR sky130_fd_sc_hd__fill_2
XFILLER_27_302 VGND VGND VPWR VPWR sky130_fd_sc_hd__decap_3
XFILLER_39_140 VGND VGND VPWR VPWR sky130_fd_sc_hd__decap_3
XFILLER_27_335 VGND VGND VPWR VPWR sky130_fd_sc_hd__fill_1
XFILLER_54_121 VGND VGND VPWR VPWR sky130_fd_sc_hd__decap_3
XFILLER_39_184 VGND VGND VPWR VPWR sky130_fd_sc_hd__decap_3
XFILLER_27_346 VGND VGND VPWR VPWR sky130_fd_sc_hd__decap_3
XFILLER_27_379 VGND VGND VPWR VPWR sky130_fd_sc_hd__decap_3
XTAP_TAPCELL_ROW_37_352 VGND VPWR sky130_fd_sc_hd__tapvpwrvgnd_1
XFILLER_54_165 VGND VGND VPWR VPWR sky130_fd_sc_hd__decap_3
XFILLER_42_327 VGND VGND VPWR VPWR sky130_fd_sc_hd__decap_3
XFILLER_24_12 VGND VGND VPWR VPWR sky130_fd_sc_hd__decap_3
XFILLER_24_56 VGND VGND VPWR VPWR sky130_fd_sc_hd__decap_3
XFILLER_50_360 VGND VGND VPWR VPWR sky130_fd_sc_hd__decap_3
XFILLER_50_371 VGND VGND VPWR VPWR sky130_fd_sc_hd__decap_3
XFILLER_40_44 VGND VGND VPWR VPWR sky130_fd_sc_hd__decap_3
XFILLER_40_88 VGND VGND VPWR VPWR sky130_fd_sc_hd__decap_3
XFILLER_49_53 VGND VGND VPWR VPWR sky130_fd_sc_hd__decap_3
XFILLER_49_97 VGND VGND VPWR VPWR sky130_fd_sc_hd__decap_3
XFILLER_1_27 VGND VGND VPWR VPWR sky130_fd_sc_hd__decap_3
XFILLER_18_346 VGND VGND VPWR VPWR sky130_fd_sc_hd__decap_3
XFILLER_18_357 VGND VGND VPWR VPWR sky130_fd_sc_hd__decap_3
XFILLER_45_143 VGND VGND VPWR VPWR sky130_fd_sc_hd__decap_3
XFILLER_45_187 VGND VGND VPWR VPWR sky130_fd_sc_hd__decap_3
XFILLER_33_305 VGND VGND VPWR VPWR sky130_fd_sc_hd__decap_3
XFILLER_60_124 VGND VGND VPWR VPWR sky130_fd_sc_hd__decap_3
XFILLER_33_349 VGND VGND VPWR VPWR sky130_fd_sc_hd__decap_3
XFILLER_60_168 VGND VGND VPWR VPWR sky130_fd_sc_hd__decap_3
XTAP_TAPCELL_ROW_43_399 VGND VPWR sky130_fd_sc_hd__tapvpwrvgnd_1
XFILLER_41_393 VGND VGND VPWR VPWR sky130_fd_sc_hd__decap_3
XFILLER_41_382 VGND VGND VPWR VPWR sky130_fd_sc_hd__decap_3
X_288_ clknet_2_0__leaf_clk_regs net17 _033_ VGND VGND VPWR VPWR genblk1\[0\].fa_inst.b
+ sky130_fd_sc_hd__dfrtp_1
XFILLER_60_6 VGND VGND VPWR VPWR sky130_fd_sc_hd__fill_2
XFILLER_39_3 VGND VGND VPWR VPWR sky130_fd_sc_hd__decap_3
Xinput4 a[12] VGND VGND VPWR VPWR net4 sky130_fd_sc_hd__buf_1
XTAP_TAPCELL_ROW_17_1_220 VGND VPWR sky130_fd_sc_hd__tapvpwrvgnd_1
XFILLER_36_121 VGND VGND VPWR VPWR sky130_fd_sc_hd__decap_3
XFILLER_24_327 VGND VGND VPWR VPWR sky130_fd_sc_hd__decap_3
XFILLER_36_165 VGND VGND VPWR VPWR sky130_fd_sc_hd__decap_3
XPHY_EDGE_ROW_6_1_Left_112 VGND VGND VPWR VPWR sky130_fd_sc_hd__decap_3
XTAP_TAPCELL_ROW_34_333 VGND VPWR sky130_fd_sc_hd__tapvpwrvgnd_1
XFILLER_51_146 VGND VGND VPWR VPWR sky130_fd_sc_hd__decap_3
XFILLER_51_113 VGND VGND VPWR VPWR sky130_fd_sc_hd__decap_3
XFILLER_32_360 VGND VGND VPWR VPWR sky130_fd_sc_hd__decap_3
XFILLER_32_371 VGND VGND VPWR VPWR sky130_fd_sc_hd__decap_3
XFILLER_59_202 VGND VGND VPWR VPWR sky130_fd_sc_hd__decap_3
XFILLER_19_12 VGND VGND VPWR VPWR sky130_fd_sc_hd__decap_3
XFILLER_59_246 VGND VGND VPWR VPWR sky130_fd_sc_hd__decap_3
XFILLER_59_279 VGND VGND VPWR VPWR sky130_fd_sc_hd__fill_1
XFILLER_19_78 VGND VGND VPWR VPWR sky130_fd_sc_hd__decap_3
XFILLER_27_143 VGND VGND VPWR VPWR sky130_fd_sc_hd__decap_3
XFILLER_42_102 VGND VGND VPWR VPWR sky130_fd_sc_hd__decap_3
XFILLER_15_349 VGND VGND VPWR VPWR sky130_fd_sc_hd__decap_3
XFILLER_27_187 VGND VGND VPWR VPWR sky130_fd_sc_hd__decap_3
XFILLER_42_135 VGND VGND VPWR VPWR sky130_fd_sc_hd__decap_3
XFILLER_35_66 VGND VGND VPWR VPWR sky130_fd_sc_hd__decap_3
XFILLER_35_44 VGND VGND VPWR VPWR sky130_fd_sc_hd__decap_3
XFILLER_42_168 VGND VGND VPWR VPWR sky130_fd_sc_hd__decap_3
XFILLER_35_99 VGND VGND VPWR VPWR sky130_fd_sc_hd__decap_3
XFILLER_23_382 VGND VGND VPWR VPWR sky130_fd_sc_hd__decap_3
XFILLER_23_393 VGND VGND VPWR VPWR sky130_fd_sc_hd__decap_3
X_211_ net58 VGND VGND VPWR VPWR _006_ sky130_fd_sc_hd__inv_2
Xclkbuf_2_3__f_clk_regs clknet_0_clk_regs VGND VGND VPWR VPWR clknet_2_3__leaf_clk_regs
+ sky130_fd_sc_hd__clkbuf_16
X_142_ _061_ _062_ VGND VGND VPWR VPWR _063_ sky130_fd_sc_hd__nand2_1
XFILLER_51_43 VGND VGND VPWR VPWR sky130_fd_sc_hd__decap_3
XFILLER_51_98 VGND VGND VPWR VPWR sky130_fd_sc_hd__decap_3
XFILLER_25_9 VGND VGND VPWR VPWR sky130_fd_sc_hd__decap_3
XFILLER_18_121 VGND VGND VPWR VPWR sky130_fd_sc_hd__decap_3
XFILLER_18_165 VGND VGND VPWR VPWR sky130_fd_sc_hd__decap_3
XFILLER_33_113 VGND VGND VPWR VPWR sky130_fd_sc_hd__decap_3
XFILLER_33_146 VGND VGND VPWR VPWR sky130_fd_sc_hd__decap_3
XFILLER_14_360 VGND VGND VPWR VPWR sky130_fd_sc_hd__decap_3
XTAP_TAPCELL_ROW_31_314 VGND VPWR sky130_fd_sc_hd__tapvpwrvgnd_1
XFILLER_14_393 VGND VGND VPWR VPWR sky130_fd_sc_hd__decap_3
XFILLER_41_190 VGND VGND VPWR VPWR sky130_fd_sc_hd__decap_3
XPHY_EDGE_ROW_4_2_Right_90 VGND VGND VPWR VPWR sky130_fd_sc_hd__decap_3
XFILLER_56_227 VGND VGND VPWR VPWR sky130_fd_sc_hd__decap_3
XFILLER_49_290 VGND VGND VPWR VPWR sky130_fd_sc_hd__decap_3
XFILLER_24_135 VGND VGND VPWR VPWR sky130_fd_sc_hd__decap_3
XFILLER_64_271 VGND VGND VPWR VPWR sky130_fd_sc_hd__decap_3
XFILLER_64_293 VGND VGND VPWR VPWR sky130_fd_sc_hd__decap_3
XFILLER_24_168 VGND VGND VPWR VPWR sky130_fd_sc_hd__decap_3
XFILLER_32_190 VGND VGND VPWR VPWR sky130_fd_sc_hd__decap_3
XFILLER_20_352 VGND VGND VPWR VPWR sky130_fd_sc_hd__fill_1
XFILLER_20_363 VGND VGND VPWR VPWR sky130_fd_sc_hd__decap_3
XFILLER_20_396 VGND VGND VPWR VPWR sky130_fd_sc_hd__decap_3
XFILLER_21_24 VGND VGND VPWR VPWR sky130_fd_sc_hd__decap_3
XFILLER_21_35 VGND VGND VPWR VPWR sky130_fd_sc_hd__decap_3
XFILLER_21_68 VGND VGND VPWR VPWR sky130_fd_sc_hd__decap_3
XFILLER_47_205 VGND VGND VPWR VPWR sky130_fd_sc_hd__decap_3
XFILLER_47_249 VGND VGND VPWR VPWR sky130_fd_sc_hd__decap_3
XFILLER_46_32 VGND VGND VPWR VPWR sky130_fd_sc_hd__decap_3
XFILLER_46_21 VGND VGND VPWR VPWR sky130_fd_sc_hd__decap_3
XFILLER_46_65 VGND VGND VPWR VPWR sky130_fd_sc_hd__decap_3
XFILLER_15_102 VGND VGND VPWR VPWR sky130_fd_sc_hd__decap_3
XFILLER_15_113 VGND VGND VPWR VPWR sky130_fd_sc_hd__decap_3
XFILLER_55_293 VGND VGND VPWR VPWR sky130_fd_sc_hd__decap_3
XFILLER_15_146 VGND VGND VPWR VPWR sky130_fd_sc_hd__decap_3
XFILLER_62_53 VGND VGND VPWR VPWR sky130_fd_sc_hd__decap_3
XFILLER_30_127 VGND VGND VPWR VPWR sky130_fd_sc_hd__decap_3
XFILLER_23_190 VGND VGND VPWR VPWR sky130_fd_sc_hd__decap_3
XFILLER_62_97 VGND VGND VPWR VPWR sky130_fd_sc_hd__decap_3
XFILLER_11_352 VGND VGND VPWR VPWR sky130_fd_sc_hd__decap_3
XFILLER_7_15 VGND VGND VPWR VPWR sky130_fd_sc_hd__decap_3
XFILLER_11_385 VGND VGND VPWR VPWR sky130_fd_sc_hd__decap_3
XFILLER_7_334 VGND VGND VPWR VPWR sky130_fd_sc_hd__decap_3
X_125_ net57 VGND VGND VPWR VPWR _000_ sky130_fd_sc_hd__inv_2
XFILLER_7_367 VGND VGND VPWR VPWR sky130_fd_sc_hd__decap_3
XFILLER_23_6 VGND VGND VPWR VPWR sky130_fd_sc_hd__decap_3
XFILLER_38_227 VGND VGND VPWR VPWR sky130_fd_sc_hd__decap_3
XFILLER_53_208 VGND VGND VPWR VPWR sky130_fd_sc_hd__decap_3
XFILLER_46_271 VGND VGND VPWR VPWR sky130_fd_sc_hd__decap_3
XFILLER_61_252 VGND VGND VPWR VPWR sky130_fd_sc_hd__decap_3
XFILLER_21_116 VGND VGND VPWR VPWR sky130_fd_sc_hd__decap_3
XFILLER_61_296 VGND VGND VPWR VPWR sky130_fd_sc_hd__decap_3
XTAP_TAPCELL_ROW_59_509 VGND VPWR sky130_fd_sc_hd__tapvpwrvgnd_1
XFILLER_29_205 VGND VGND VPWR VPWR sky130_fd_sc_hd__decap_3
XFILLER_29_249 VGND VGND VPWR VPWR sky130_fd_sc_hd__decap_3
XFILLER_16_24 VGND VGND VPWR VPWR sky130_fd_sc_hd__fill_1
XFILLER_16_35 VGND VGND VPWR VPWR sky130_fd_sc_hd__decap_3
XFILLER_37_293 VGND VGND VPWR VPWR sky130_fd_sc_hd__decap_3
XFILLER_16_68 VGND VGND VPWR VPWR sky130_fd_sc_hd__decap_3
XFILLER_52_230 VGND VGND VPWR VPWR sky130_fd_sc_hd__decap_3
XFILLER_12_127 VGND VGND VPWR VPWR sky130_fd_sc_hd__decap_3
XFILLER_52_274 VGND VGND VPWR VPWR sky130_fd_sc_hd__decap_3
XTAP_TAPCELL_ROW_50_442 VGND VPWR sky130_fd_sc_hd__tapvpwrvgnd_1
XFILLER_32_12 VGND VGND VPWR VPWR sky130_fd_sc_hd__decap_3
XFILLER_32_56 VGND VGND VPWR VPWR sky130_fd_sc_hd__decap_3
XFILLER_20_171 VGND VGND VPWR VPWR sky130_fd_sc_hd__decap_3
XFILLER_32_78 VGND VGND VPWR VPWR sky130_fd_sc_hd__decap_3
XFILLER_4_337 VGND VGND VPWR VPWR sky130_fd_sc_hd__decap_3
XFILLER_57_86 VGND VGND VPWR VPWR sky130_fd_sc_hd__decap_3
XFILLER_35_208 VGND VGND VPWR VPWR sky130_fd_sc_hd__decap_3
XFILLER_28_271 VGND VGND VPWR VPWR sky130_fd_sc_hd__decap_3
XFILLER_43_252 VGND VGND VPWR VPWR sky130_fd_sc_hd__decap_3
XFILLER_43_296 VGND VGND VPWR VPWR sky130_fd_sc_hd__decap_3
XFILLER_7_131 VGND VGND VPWR VPWR sky130_fd_sc_hd__decap_3
XFILLER_7_164 VGND VGND VPWR VPWR sky130_fd_sc_hd__decap_3
XFILLER_7_175 VGND VGND VPWR VPWR sky130_fd_sc_hd__decap_3
XFILLER_3_370 VGND VGND VPWR VPWR sky130_fd_sc_hd__decap_3
XFILLER_21_3 VGND VGND VPWR VPWR sky130_fd_sc_hd__decap_3
XPHY_EDGE_ROW_53_Left_159 VGND VGND VPWR VPWR sky130_fd_sc_hd__decap_3
XTAP_TAPCELL_ROW_64_545 VGND VPWR sky130_fd_sc_hd__tapvpwrvgnd_1
XFILLER_34_230 VGND VGND VPWR VPWR sky130_fd_sc_hd__decap_3
XFILLER_34_274 VGND VGND VPWR VPWR sky130_fd_sc_hd__decap_3
XFILLER_8_80 VGND VGND VPWR VPWR sky130_fd_sc_hd__decap_3
XFILLER_8_91 VGND VGND VPWR VPWR sky130_fd_sc_hd__decap_3
XPHY_EDGE_ROW_62_Left_168 VGND VGND VPWR VPWR sky130_fd_sc_hd__decap_3
XFILLER_27_12 VGND VGND VPWR VPWR sky130_fd_sc_hd__decap_3
XFILLER_57_355 VGND VGND VPWR VPWR sky130_fd_sc_hd__decap_3
XFILLER_27_78 VGND VGND VPWR VPWR sky130_fd_sc_hd__decap_3
XFILLER_57_399 VGND VGND VPWR VPWR sky130_fd_sc_hd__fill_2
XFILLER_57_388 VGND VGND VPWR VPWR sky130_fd_sc_hd__decap_3
XFILLER_25_252 VGND VGND VPWR VPWR sky130_fd_sc_hd__decap_3
XFILLER_40_200 VGND VGND VPWR VPWR sky130_fd_sc_hd__decap_3
XFILLER_25_296 VGND VGND VPWR VPWR sky130_fd_sc_hd__decap_3
XFILLER_40_233 VGND VGND VPWR VPWR sky130_fd_sc_hd__decap_3
XFILLER_43_66 VGND VGND VPWR VPWR sky130_fd_sc_hd__decap_3
XFILLER_40_277 VGND VGND VPWR VPWR sky130_fd_sc_hd__decap_3
XFILLER_4_156 VGND VGND VPWR VPWR sky130_fd_sc_hd__decap_3
XPHY_EDGE_ROW_17_2_Left_38 VGND VGND VPWR VPWR sky130_fd_sc_hd__decap_3
XFILLER_4_38 VGND VGND VPWR VPWR sky130_fd_sc_hd__decap_3
XFILLER_0_340 VGND VGND VPWR VPWR sky130_fd_sc_hd__decap_3
XFILLER_48_333 VGND VGND VPWR VPWR sky130_fd_sc_hd__decap_3
XFILLER_48_377 VGND VGND VPWR VPWR sky130_fd_sc_hd__decap_3
XFILLER_63_314 VGND VGND VPWR VPWR sky130_fd_sc_hd__decap_3
XFILLER_63_358 VGND VGND VPWR VPWR sky130_fd_sc_hd__decap_3
XTAP_TAPCELL_ROW_26_280 VGND VPWR sky130_fd_sc_hd__tapvpwrvgnd_1
XFILLER_31_211 VGND VGND VPWR VPWR sky130_fd_sc_hd__decap_3
XFILLER_31_255 VGND VGND VPWR VPWR sky130_fd_sc_hd__decap_3
XFILLER_31_299 VGND VGND VPWR VPWR sky130_fd_sc_hd__decap_3
XFILLER_58_119 VGND VGND VPWR VPWR sky130_fd_sc_hd__decap_3
XFILLER_39_311 VGND VGND VPWR VPWR sky130_fd_sc_hd__decap_3
XFILLER_39_355 VGND VGND VPWR VPWR sky130_fd_sc_hd__decap_3
XFILLER_54_336 VGND VGND VPWR VPWR sky130_fd_sc_hd__decap_3
XFILLER_39_399 VGND VGND VPWR VPWR sky130_fd_sc_hd__decap_3
XFILLER_39_388 VGND VGND VPWR VPWR sky130_fd_sc_hd__decap_3
XFILLER_22_200 VGND VGND VPWR VPWR sky130_fd_sc_hd__decap_3
XFILLER_62_380 VGND VGND VPWR VPWR sky130_fd_sc_hd__decap_3
XFILLER_22_244 VGND VGND VPWR VPWR sky130_fd_sc_hd__decap_3
XFILLER_22_277 VGND VGND VPWR VPWR sky130_fd_sc_hd__decap_3
Xfanout59 net61 VGND VGND VPWR VPWR net59 sky130_fd_sc_hd__buf_4
XFILLER_1_137 VGND VGND VPWR VPWR sky130_fd_sc_hd__decap_3
XFILLER_49_119 VGND VGND VPWR VPWR sky130_fd_sc_hd__decap_3
XFILLER_38_44 VGND VGND VPWR VPWR sky130_fd_sc_hd__decap_3
XFILLER_57_152 VGND VGND VPWR VPWR sky130_fd_sc_hd__decap_3
XFILLER_38_88 VGND VGND VPWR VPWR sky130_fd_sc_hd__decap_3
XFILLER_57_196 VGND VGND VPWR VPWR sky130_fd_sc_hd__decap_3
XFILLER_45_314 VGND VGND VPWR VPWR sky130_fd_sc_hd__decap_3
XFILLER_54_32 VGND VGND VPWR VPWR sky130_fd_sc_hd__decap_3
XFILLER_54_21 VGND VGND VPWR VPWR sky130_fd_sc_hd__decap_3
XFILLER_45_358 VGND VGND VPWR VPWR sky130_fd_sc_hd__decap_3
XFILLER_54_65 VGND VGND VPWR VPWR sky130_fd_sc_hd__decap_3
XFILLER_60_339 VGND VGND VPWR VPWR sky130_fd_sc_hd__decap_3
XFILLER_53_391 VGND VGND VPWR VPWR sky130_fd_sc_hd__fill_1
XFILLER_55_9 VGND VGND VPWR VPWR sky130_fd_sc_hd__decap_3
XFILLER_48_141 VGND VGND VPWR VPWR sky130_fd_sc_hd__decap_3
XFILLER_63_111 VGND VGND VPWR VPWR sky130_fd_sc_hd__fill_1
XFILLER_48_174 VGND VGND VPWR VPWR sky130_fd_sc_hd__decap_3
XFILLER_36_336 VGND VGND VPWR VPWR sky130_fd_sc_hd__decap_3
XFILLER_63_122 VGND VGND VPWR VPWR sky130_fd_sc_hd__decap_3
XFILLER_63_155 VGND VGND VPWR VPWR sky130_fd_sc_hd__decap_3
XFILLER_51_317 VGND VGND VPWR VPWR sky130_fd_sc_hd__decap_3
XFILLER_63_199 VGND VGND VPWR VPWR sky130_fd_sc_hd__decap_3
XFILLER_44_380 VGND VGND VPWR VPWR sky130_fd_sc_hd__decap_3
XFILLER_39_152 VGND VGND VPWR VPWR sky130_fd_sc_hd__decap_3
XFILLER_27_314 VGND VGND VPWR VPWR sky130_fd_sc_hd__decap_3
XFILLER_27_358 VGND VGND VPWR VPWR sky130_fd_sc_hd__decap_3
XFILLER_54_144 VGND VGND VPWR VPWR sky130_fd_sc_hd__decap_3
XFILLER_54_133 VGND VGND VPWR VPWR sky130_fd_sc_hd__decap_3
XFILLER_39_196 VGND VGND VPWR VPWR sky130_fd_sc_hd__decap_3
XTAP_TAPCELL_ROW_37_353 VGND VPWR sky130_fd_sc_hd__tapvpwrvgnd_1
XFILLER_54_177 VGND VGND VPWR VPWR sky130_fd_sc_hd__decap_3
XFILLER_24_24 VGND VGND VPWR VPWR sky130_fd_sc_hd__decap_3
XFILLER_42_339 VGND VGND VPWR VPWR sky130_fd_sc_hd__decap_3
XFILLER_35_391 VGND VGND VPWR VPWR sky130_fd_sc_hd__fill_1
XFILLER_24_35 VGND VGND VPWR VPWR sky130_fd_sc_hd__decap_3
XFILLER_24_68 VGND VGND VPWR VPWR sky130_fd_sc_hd__decap_3
Xclkbuf_2_2__f_clk_regs clknet_0_clk_regs VGND VGND VPWR VPWR clknet_2_2__leaf_clk_regs
+ sky130_fd_sc_hd__clkbuf_16
XFILLER_50_383 VGND VGND VPWR VPWR sky130_fd_sc_hd__decap_3
XFILLER_40_12 VGND VGND VPWR VPWR sky130_fd_sc_hd__decap_3
XFILLER_40_56 VGND VGND VPWR VPWR sky130_fd_sc_hd__decap_3
XFILLER_2_402 VGND VGND VPWR VPWR sky130_fd_sc_hd__decap_3
XFILLER_49_76 VGND VGND VPWR VPWR sky130_fd_sc_hd__decap_3
XFILLER_1_39 VGND VGND VPWR VPWR sky130_fd_sc_hd__decap_3
XFILLER_45_100 VGND VGND VPWR VPWR sky130_fd_sc_hd__decap_3
XFILLER_45_122 VGND VGND VPWR VPWR sky130_fd_sc_hd__decap_3
XFILLER_18_369 VGND VGND VPWR VPWR sky130_fd_sc_hd__decap_3
XFILLER_60_103 VGND VGND VPWR VPWR sky130_fd_sc_hd__decap_3
XFILLER_45_155 VGND VGND VPWR VPWR sky130_fd_sc_hd__decap_3
XFILLER_33_317 VGND VGND VPWR VPWR sky130_fd_sc_hd__decap_3
XFILLER_26_380 VGND VGND VPWR VPWR sky130_fd_sc_hd__decap_3
XFILLER_60_136 VGND VGND VPWR VPWR sky130_fd_sc_hd__decap_3
XFILLER_45_199 VGND VGND VPWR VPWR sky130_fd_sc_hd__decap_3
XFILLER_60_147 VGND VGND VPWR VPWR sky130_fd_sc_hd__decap_3
XFILLER_41_361 VGND VGND VPWR VPWR sky130_fd_sc_hd__decap_3
X_287_ clknet_2_3__leaf_clk_regs net7 _032_ VGND VGND VPWR VPWR genblk1\[15\].fa_inst.a
+ sky130_fd_sc_hd__dfrtp_1
XFILLER_53_6 VGND VGND VPWR VPWR sky130_fd_sc_hd__decap_3
Xinput5 a[13] VGND VGND VPWR VPWR net5 sky130_fd_sc_hd__buf_1
XTAP_TAPCELL_ROW_17_1_221 VGND VPWR sky130_fd_sc_hd__tapvpwrvgnd_1
XFILLER_36_144 VGND VGND VPWR VPWR sky130_fd_sc_hd__decap_3
XFILLER_36_133 VGND VGND VPWR VPWR sky130_fd_sc_hd__decap_3
XFILLER_36_177 VGND VGND VPWR VPWR sky130_fd_sc_hd__decap_3
XFILLER_17_391 VGND VGND VPWR VPWR sky130_fd_sc_hd__decap_3
XFILLER_24_339 VGND VGND VPWR VPWR sky130_fd_sc_hd__decap_3
XFILLER_51_125 VGND VGND VPWR VPWR sky130_fd_sc_hd__decap_3
XTAP_TAPCELL_ROW_34_334 VGND VPWR sky130_fd_sc_hd__tapvpwrvgnd_1
XFILLER_51_169 VGND VGND VPWR VPWR sky130_fd_sc_hd__decap_3
XFILLER_51_158 VGND VGND VPWR VPWR sky130_fd_sc_hd__decap_3
XFILLER_32_383 VGND VGND VPWR VPWR sky130_fd_sc_hd__decap_3
XFILLER_10_15 VGND VGND VPWR VPWR sky130_fd_sc_hd__decap_3
XFILLER_10_59 VGND VGND VPWR VPWR sky130_fd_sc_hd__fill_2
XFILLER_59_225 VGND VGND VPWR VPWR sky130_fd_sc_hd__decap_3
XFILLER_59_214 VGND VGND VPWR VPWR sky130_fd_sc_hd__decap_3
XFILLER_19_46 VGND VGND VPWR VPWR sky130_fd_sc_hd__decap_3
XFILLER_59_258 VGND VGND VPWR VPWR sky130_fd_sc_hd__decap_3
XFILLER_19_57 VGND VGND VPWR VPWR sky130_fd_sc_hd__decap_3
XFILLER_27_111 VGND VGND VPWR VPWR sky130_fd_sc_hd__fill_1
XFILLER_27_122 VGND VGND VPWR VPWR sky130_fd_sc_hd__decap_3
XFILLER_27_155 VGND VGND VPWR VPWR sky130_fd_sc_hd__decap_3
XFILLER_35_12 VGND VGND VPWR VPWR sky130_fd_sc_hd__decap_3
XFILLER_27_199 VGND VGND VPWR VPWR sky130_fd_sc_hd__decap_3
XFILLER_42_114 VGND VGND VPWR VPWR sky130_fd_sc_hd__decap_3
XFILLER_42_147 VGND VGND VPWR VPWR sky130_fd_sc_hd__decap_3
XFILLER_35_78 VGND VGND VPWR VPWR sky130_fd_sc_hd__decap_3
XFILLER_30_309 VGND VGND VPWR VPWR sky130_fd_sc_hd__decap_3
XFILLER_23_361 VGND VGND VPWR VPWR sky130_fd_sc_hd__decap_3
X_210_ net58 VGND VGND VPWR VPWR _005_ sky130_fd_sc_hd__inv_2
X_141_ genblk1\[3\].fa_inst.b genblk1\[3\].fa_inst.a VGND VGND VPWR VPWR _062_ sky130_fd_sc_hd__nand2_1
XFILLER_50_180 VGND VGND VPWR VPWR sky130_fd_sc_hd__decap_3
XFILLER_51_77 VGND VGND VPWR VPWR sky130_fd_sc_hd__decap_3
XFILLER_51_66 VGND VGND VPWR VPWR sky130_fd_sc_hd__decap_3
XFILLER_51_55 VGND VGND VPWR VPWR sky130_fd_sc_hd__fill_1
XPHY_EDGE_ROW_23_Right_44 VGND VGND VPWR VPWR sky130_fd_sc_hd__decap_3
XFILLER_18_100 VGND VGND VPWR VPWR sky130_fd_sc_hd__decap_3
XFILLER_18_9 VGND VGND VPWR VPWR sky130_fd_sc_hd__decap_3
XFILLER_18_133 VGND VGND VPWR VPWR sky130_fd_sc_hd__decap_3
XFILLER_58_280 VGND VGND VPWR VPWR sky130_fd_sc_hd__decap_3
XFILLER_18_144 VGND VGND VPWR VPWR sky130_fd_sc_hd__decap_3
XFILLER_18_177 VGND VGND VPWR VPWR sky130_fd_sc_hd__decap_3
XFILLER_33_125 VGND VGND VPWR VPWR sky130_fd_sc_hd__decap_3
XFILLER_21_309 VGND VGND VPWR VPWR sky130_fd_sc_hd__decap_3
XFILLER_33_169 VGND VGND VPWR VPWR sky130_fd_sc_hd__decap_3
XFILLER_33_158 VGND VGND VPWR VPWR sky130_fd_sc_hd__decap_3
XFILLER_14_372 VGND VGND VPWR VPWR sky130_fd_sc_hd__decap_3
XPHY_EDGE_ROW_32_Right_53 VGND VGND VPWR VPWR sky130_fd_sc_hd__decap_3
XTAP_TAPCELL_ROW_31_315 VGND VPWR sky130_fd_sc_hd__tapvpwrvgnd_1
XFILLER_51_3 VGND VGND VPWR VPWR sky130_fd_sc_hd__decap_3
XPHY_EDGE_ROW_41_Right_62 VGND VGND VPWR VPWR sky130_fd_sc_hd__decap_3
XFILLER_56_206 VGND VGND VPWR VPWR sky130_fd_sc_hd__decap_3
XFILLER_2_71 VGND VGND VPWR VPWR sky130_fd_sc_hd__decap_3
XFILLER_56_239 VGND VGND VPWR VPWR sky130_fd_sc_hd__decap_3
XFILLER_52_401 VGND VGND VPWR VPWR sky130_fd_sc_hd__decap_3
XFILLER_24_114 VGND VGND VPWR VPWR sky130_fd_sc_hd__decap_3
XFILLER_24_147 VGND VGND VPWR VPWR sky130_fd_sc_hd__decap_3
XPHY_EDGE_ROW_50_Right_71 VGND VGND VPWR VPWR sky130_fd_sc_hd__decap_3
XFILLER_20_331 VGND VGND VPWR VPWR sky130_fd_sc_hd__decap_3
XFILLER_20_375 VGND VGND VPWR VPWR sky130_fd_sc_hd__decap_3
XFILLER_21_47 VGND VGND VPWR VPWR sky130_fd_sc_hd__fill_2
XFILLER_47_228 VGND VGND VPWR VPWR sky130_fd_sc_hd__decap_3
XFILLER_47_217 VGND VGND VPWR VPWR sky130_fd_sc_hd__decap_3
XFILLER_62_209 VGND VGND VPWR VPWR sky130_fd_sc_hd__decap_3
XTAP_TAPCELL_ROW_45_407 VGND VPWR sky130_fd_sc_hd__tapvpwrvgnd_1
XFILLER_55_261 VGND VGND VPWR VPWR sky130_fd_sc_hd__decap_3
XFILLER_46_77 VGND VGND VPWR VPWR sky130_fd_sc_hd__decap_3
XFILLER_46_44 VGND VGND VPWR VPWR sky130_fd_sc_hd__decap_3
XFILLER_15_125 VGND VGND VPWR VPWR sky130_fd_sc_hd__decap_3
XFILLER_46_88 VGND VGND VPWR VPWR sky130_fd_sc_hd__decap_3
XFILLER_15_158 VGND VGND VPWR VPWR sky130_fd_sc_hd__decap_3
XFILLER_15_169 VGND VGND VPWR VPWR sky130_fd_sc_hd__decap_3
XFILLER_62_21 VGND VGND VPWR VPWR sky130_fd_sc_hd__decap_3
XFILLER_62_32 VGND VGND VPWR VPWR sky130_fd_sc_hd__decap_3
XFILLER_30_106 VGND VGND VPWR VPWR sky130_fd_sc_hd__decap_3
XFILLER_11_331 VGND VGND VPWR VPWR sky130_fd_sc_hd__decap_3
XFILLER_62_65 VGND VGND VPWR VPWR sky130_fd_sc_hd__decap_3
XFILLER_30_139 VGND VGND VPWR VPWR sky130_fd_sc_hd__fill_1
XFILLER_11_364 VGND VGND VPWR VPWR sky130_fd_sc_hd__decap_3
XFILLER_7_27 VGND VGND VPWR VPWR sky130_fd_sc_hd__decap_3
XFILLER_11_397 VGND VGND VPWR VPWR sky130_fd_sc_hd__decap_3
XFILLER_7_346 VGND VGND VPWR VPWR sky130_fd_sc_hd__decap_3
XFILLER_7_379 VGND VGND VPWR VPWR sky130_fd_sc_hd__fill_2
XFILLER_11_80 VGND VGND VPWR VPWR sky130_fd_sc_hd__decap_3
XFILLER_38_206 VGND VGND VPWR VPWR sky130_fd_sc_hd__decap_3
XFILLER_16_6 VGND VGND VPWR VPWR sky130_fd_sc_hd__decap_3
XFILLER_38_239 VGND VGND VPWR VPWR sky130_fd_sc_hd__decap_3
XFILLER_34_401 VGND VGND VPWR VPWR sky130_fd_sc_hd__decap_3
XFILLER_61_220 VGND VGND VPWR VPWR sky130_fd_sc_hd__decap_3
XFILLER_46_283 VGND VGND VPWR VPWR sky130_fd_sc_hd__decap_3
XFILLER_61_231 VGND VGND VPWR VPWR sky130_fd_sc_hd__decap_3
XFILLER_61_264 VGND VGND VPWR VPWR sky130_fd_sc_hd__decap_3
XFILLER_21_128 VGND VGND VPWR VPWR sky130_fd_sc_hd__decap_3
Xinput30 b[7] VGND VGND VPWR VPWR net30 sky130_fd_sc_hd__clkbuf_1
XFILLER_6_390 VGND VGND VPWR VPWR sky130_fd_sc_hd__decap_3
XFILLER_29_217 VGND VGND VPWR VPWR sky130_fd_sc_hd__decap_3
XFILLER_29_228 VGND VGND VPWR VPWR sky130_fd_sc_hd__decap_3
XFILLER_44_209 VGND VGND VPWR VPWR sky130_fd_sc_hd__decap_3
XFILLER_37_261 VGND VGND VPWR VPWR sky130_fd_sc_hd__decap_3
XFILLER_16_47 VGND VGND VPWR VPWR sky130_fd_sc_hd__decap_3
XFILLER_52_253 VGND VGND VPWR VPWR sky130_fd_sc_hd__decap_3
XFILLER_52_242 VGND VGND VPWR VPWR sky130_fd_sc_hd__decap_3
XFILLER_12_106 VGND VGND VPWR VPWR sky130_fd_sc_hd__decap_3
XFILLER_52_286 VGND VGND VPWR VPWR sky130_fd_sc_hd__decap_3
XFILLER_40_404 VGND VGND VPWR VPWR sky130_fd_sc_hd__decap_3
XFILLER_12_139 VGND VGND VPWR VPWR sky130_fd_sc_hd__fill_1
XFILLER_20_150 VGND VGND VPWR VPWR sky130_fd_sc_hd__decap_3
XTAP_TAPCELL_ROW_50_443 VGND VPWR sky130_fd_sc_hd__tapvpwrvgnd_1
XFILLER_32_35 VGND VGND VPWR VPWR sky130_fd_sc_hd__decap_3
XFILLER_32_24 VGND VGND VPWR VPWR sky130_fd_sc_hd__decap_3
XFILLER_4_349 VGND VGND VPWR VPWR sky130_fd_sc_hd__decap_3
XFILLER_57_43 VGND VGND VPWR VPWR sky130_fd_sc_hd__decap_3
XFILLER_57_98 VGND VGND VPWR VPWR sky130_fd_sc_hd__decap_3
XFILLER_28_283 VGND VGND VPWR VPWR sky130_fd_sc_hd__decap_3
XFILLER_43_231 VGND VGND VPWR VPWR sky130_fd_sc_hd__decap_3
XFILLER_43_220 VGND VGND VPWR VPWR sky130_fd_sc_hd__decap_3
XPHY_EDGE_ROW_5_1_Right_4 VGND VGND VPWR VPWR sky130_fd_sc_hd__decap_3
XFILLER_43_264 VGND VGND VPWR VPWR sky130_fd_sc_hd__decap_3
XFILLER_11_161 VGND VGND VPWR VPWR sky130_fd_sc_hd__decap_3
XFILLER_11_172 VGND VGND VPWR VPWR sky130_fd_sc_hd__decap_3
XFILLER_7_143 VGND VGND VPWR VPWR sky130_fd_sc_hd__decap_3
XFILLER_3_382 VGND VGND VPWR VPWR sky130_fd_sc_hd__decap_3
XFILLER_26_209 VGND VGND VPWR VPWR sky130_fd_sc_hd__decap_3
XTAP_TAPCELL_ROW_64_546 VGND VPWR sky130_fd_sc_hd__tapvpwrvgnd_1
XFILLER_34_242 VGND VGND VPWR VPWR sky130_fd_sc_hd__decap_3
XFILLER_22_404 VGND VGND VPWR VPWR sky130_fd_sc_hd__decap_3
XFILLER_34_253 VGND VGND VPWR VPWR sky130_fd_sc_hd__decap_3
XFILLER_34_286 VGND VGND VPWR VPWR sky130_fd_sc_hd__decap_3
XFILLER_57_323 VGND VGND VPWR VPWR sky130_fd_sc_hd__decap_3
XFILLER_57_367 VGND VGND VPWR VPWR sky130_fd_sc_hd__decap_3
XFILLER_27_57 VGND VGND VPWR VPWR sky130_fd_sc_hd__decap_3
XFILLER_25_220 VGND VGND VPWR VPWR sky130_fd_sc_hd__decap_3
XFILLER_25_231 VGND VGND VPWR VPWR sky130_fd_sc_hd__decap_3
XFILLER_25_264 VGND VGND VPWR VPWR sky130_fd_sc_hd__decap_3
XFILLER_43_12 VGND VGND VPWR VPWR sky130_fd_sc_hd__decap_3
XFILLER_43_45 VGND VGND VPWR VPWR sky130_fd_sc_hd__decap_3
XFILLER_40_212 VGND VGND VPWR VPWR sky130_fd_sc_hd__decap_3
XPHY_EDGE_ROW_11_1_Left_117 VGND VGND VPWR VPWR sky130_fd_sc_hd__decap_3
XFILLER_43_78 VGND VGND VPWR VPWR sky130_fd_sc_hd__decap_3
XFILLER_40_256 VGND VGND VPWR VPWR sky130_fd_sc_hd__decap_3
XFILLER_40_245 VGND VGND VPWR VPWR sky130_fd_sc_hd__decap_3
XFILLER_40_289 VGND VGND VPWR VPWR sky130_fd_sc_hd__decap_3
XFILLER_4_124 VGND VGND VPWR VPWR sky130_fd_sc_hd__decap_3
XFILLER_4_168 VGND VGND VPWR VPWR sky130_fd_sc_hd__decap_3
XFILLER_0_352 VGND VGND VPWR VPWR sky130_fd_sc_hd__fill_1
XFILLER_0_363 VGND VGND VPWR VPWR sky130_fd_sc_hd__decap_3
XFILLER_48_301 VGND VGND VPWR VPWR sky130_fd_sc_hd__decap_3
XFILLER_0_385 VGND VGND VPWR VPWR sky130_fd_sc_hd__decap_3
XFILLER_48_312 VGND VGND VPWR VPWR sky130_fd_sc_hd__decap_3
XFILLER_48_345 VGND VGND VPWR VPWR sky130_fd_sc_hd__decap_3
XFILLER_63_326 VGND VGND VPWR VPWR sky130_fd_sc_hd__decap_3
XFILLER_63_337 VGND VGND VPWR VPWR sky130_fd_sc_hd__decap_3
XFILLER_48_389 VGND VGND VPWR VPWR sky130_fd_sc_hd__decap_3
XFILLER_31_234 VGND VGND VPWR VPWR sky130_fd_sc_hd__decap_3
XFILLER_31_223 VGND VGND VPWR VPWR sky130_fd_sc_hd__fill_1
XFILLER_31_267 VGND VGND VPWR VPWR sky130_fd_sc_hd__decap_3
XFILLER_39_323 VGND VGND VPWR VPWR sky130_fd_sc_hd__decap_3
XFILLER_39_367 VGND VGND VPWR VPWR sky130_fd_sc_hd__decap_3
XFILLER_54_315 VGND VGND VPWR VPWR sky130_fd_sc_hd__decap_3
XFILLER_54_304 VGND VGND VPWR VPWR sky130_fd_sc_hd__decap_3
XFILLER_54_348 VGND VGND VPWR VPWR sky130_fd_sc_hd__decap_3
XFILLER_22_212 VGND VGND VPWR VPWR sky130_fd_sc_hd__decap_3
XFILLER_62_392 VGND VGND VPWR VPWR sky130_fd_sc_hd__decap_3
XFILLER_22_256 VGND VGND VPWR VPWR sky130_fd_sc_hd__decap_3
Xclkbuf_2_1__f_clk_regs clknet_0_clk_regs VGND VGND VPWR VPWR clknet_2_1__leaf_clk_regs
+ sky130_fd_sc_hd__clkbuf_16
XFILLER_13_37 VGND VGND VPWR VPWR sky130_fd_sc_hd__decap_3
XFILLER_22_289 VGND VGND VPWR VPWR sky130_fd_sc_hd__decap_3
XTAP_TAPCELL_ROW_18_1_223 VGND VPWR sky130_fd_sc_hd__tapvpwrvgnd_1
XFILLER_1_105 VGND VGND VPWR VPWR sky130_fd_sc_hd__decap_3
XFILLER_1_116 VGND VGND VPWR VPWR sky130_fd_sc_hd__decap_3
XFILLER_1_149 VGND VGND VPWR VPWR sky130_fd_sc_hd__decap_3
XFILLER_49_109 VGND VGND VPWR VPWR sky130_fd_sc_hd__decap_3
XFILLER_38_12 VGND VGND VPWR VPWR sky130_fd_sc_hd__decap_3
XFILLER_57_131 VGND VGND VPWR VPWR sky130_fd_sc_hd__decap_3
XFILLER_38_56 VGND VGND VPWR VPWR sky130_fd_sc_hd__decap_3
XFILLER_57_175 VGND VGND VPWR VPWR sky130_fd_sc_hd__decap_3
XFILLER_57_164 VGND VGND VPWR VPWR sky130_fd_sc_hd__decap_3
XFILLER_45_326 VGND VGND VPWR VPWR sky130_fd_sc_hd__decap_3
XFILLER_45_337 VGND VGND VPWR VPWR sky130_fd_sc_hd__decap_3
XFILLER_60_318 VGND VGND VPWR VPWR sky130_fd_sc_hd__decap_3
XFILLER_60_307 VGND VGND VPWR VPWR sky130_fd_sc_hd__fill_1
XFILLER_54_44 VGND VGND VPWR VPWR sky130_fd_sc_hd__decap_3
XFILLER_54_88 VGND VGND VPWR VPWR sky130_fd_sc_hd__decap_3
XFILLER_54_77 VGND VGND VPWR VPWR sky130_fd_sc_hd__decap_3
XFILLER_53_370 VGND VGND VPWR VPWR sky130_fd_sc_hd__decap_3
XFILLER_5_400 VGND VGND VPWR VPWR sky130_fd_sc_hd__decap_3
XFILLER_48_9 VGND VGND VPWR VPWR sky130_fd_sc_hd__decap_3
XFILLER_48_153 VGND VGND VPWR VPWR sky130_fd_sc_hd__decap_3
XFILLER_48_120 VGND VGND VPWR VPWR sky130_fd_sc_hd__decap_3
XFILLER_48_186 VGND VGND VPWR VPWR sky130_fd_sc_hd__decap_3
XFILLER_36_315 VGND VGND VPWR VPWR sky130_fd_sc_hd__decap_3
XFILLER_36_304 VGND VGND VPWR VPWR sky130_fd_sc_hd__decap_3
XFILLER_63_134 VGND VGND VPWR VPWR sky130_fd_sc_hd__decap_3
XFILLER_48_197 VGND VGND VPWR VPWR sky130_fd_sc_hd__decap_3
XFILLER_36_348 VGND VGND VPWR VPWR sky130_fd_sc_hd__decap_3
XFILLER_63_167 VGND VGND VPWR VPWR sky130_fd_sc_hd__fill_1
XFILLER_63_178 VGND VGND VPWR VPWR sky130_fd_sc_hd__decap_3
XFILLER_51_329 VGND VGND VPWR VPWR sky130_fd_sc_hd__decap_3
XFILLER_44_392 VGND VGND VPWR VPWR sky130_fd_sc_hd__decap_3
XFILLER_5_82 VGND VGND VPWR VPWR sky130_fd_sc_hd__decap_3
XFILLER_5_60 VGND VGND VPWR VPWR sky130_fd_sc_hd__decap_3
XFILLER_39_131 VGND VGND VPWR VPWR sky130_fd_sc_hd__decap_3
XFILLER_27_326 VGND VGND VPWR VPWR sky130_fd_sc_hd__decap_3
XFILLER_39_175 VGND VGND VPWR VPWR sky130_fd_sc_hd__decap_3
XFILLER_39_164 VGND VGND VPWR VPWR sky130_fd_sc_hd__decap_3
XFILLER_27_337 VGND VGND VPWR VPWR sky130_fd_sc_hd__decap_3
XTAP_TAPCELL_ROW_37_354 VGND VPWR sky130_fd_sc_hd__tapvpwrvgnd_1
XFILLER_54_156 VGND VGND VPWR VPWR sky130_fd_sc_hd__decap_3
XFILLER_42_318 VGND VGND VPWR VPWR sky130_fd_sc_hd__decap_3
XFILLER_42_307 VGND VGND VPWR VPWR sky130_fd_sc_hd__fill_1
XFILLER_54_189 VGND VGND VPWR VPWR sky130_fd_sc_hd__decap_3
XFILLER_35_370 VGND VGND VPWR VPWR sky130_fd_sc_hd__decap_3
XFILLER_24_47 VGND VGND VPWR VPWR sky130_fd_sc_hd__decap_3
XFILLER_50_351 VGND VGND VPWR VPWR sky130_fd_sc_hd__decap_3
XFILLER_50_395 VGND VGND VPWR VPWR sky130_fd_sc_hd__decap_3
XFILLER_40_35 VGND VGND VPWR VPWR sky130_fd_sc_hd__decap_3
XFILLER_40_24 VGND VGND VPWR VPWR sky130_fd_sc_hd__decap_3
XFILLER_40_68 VGND VGND VPWR VPWR sky130_fd_sc_hd__fill_1
XFILLER_40_79 VGND VGND VPWR VPWR sky130_fd_sc_hd__decap_3
XFILLER_49_44 VGND VGND VPWR VPWR sky130_fd_sc_hd__decap_3
XFILLER_49_88 VGND VGND VPWR VPWR sky130_fd_sc_hd__decap_3
XFILLER_1_18 VGND VGND VPWR VPWR sky130_fd_sc_hd__decap_3
XFILLER_18_337 VGND VGND VPWR VPWR sky130_fd_sc_hd__decap_3
XFILLER_45_134 VGND VGND VPWR VPWR sky130_fd_sc_hd__decap_3
XFILLER_45_178 VGND VGND VPWR VPWR sky130_fd_sc_hd__decap_3
XFILLER_45_167 VGND VGND VPWR VPWR sky130_fd_sc_hd__fill_1
XFILLER_26_392 VGND VGND VPWR VPWR sky130_fd_sc_hd__decap_3
XFILLER_60_115 VGND VGND VPWR VPWR sky130_fd_sc_hd__decap_3
XFILLER_33_329 VGND VGND VPWR VPWR sky130_fd_sc_hd__decap_3
XFILLER_60_159 VGND VGND VPWR VPWR sky130_fd_sc_hd__decap_3
XFILLER_41_340 VGND VGND VPWR VPWR sky130_fd_sc_hd__decap_3
XFILLER_41_373 VGND VGND VPWR VPWR sky130_fd_sc_hd__decap_3
XFILLER_14_80 VGND VGND VPWR VPWR sky130_fd_sc_hd__decap_3
X_286_ clknet_2_3__leaf_clk_regs net6 _031_ VGND VGND VPWR VPWR genblk1\[14\].fa_inst.a
+ sky130_fd_sc_hd__dfrtp_1
XFILLER_14_91 VGND VGND VPWR VPWR sky130_fd_sc_hd__decap_3
XFILLER_46_6 VGND VGND VPWR VPWR sky130_fd_sc_hd__decap_3
Xinput6 a[14] VGND VGND VPWR VPWR net6 sky130_fd_sc_hd__buf_1
XTAP_TAPCELL_ROW_17_1_222 VGND VPWR sky130_fd_sc_hd__tapvpwrvgnd_1
XFILLER_24_307 VGND VGND VPWR VPWR sky130_fd_sc_hd__fill_1
XFILLER_24_318 VGND VGND VPWR VPWR sky130_fd_sc_hd__decap_3
XFILLER_36_156 VGND VGND VPWR VPWR sky130_fd_sc_hd__decap_3
XFILLER_17_370 VGND VGND VPWR VPWR sky130_fd_sc_hd__decap_3
XFILLER_51_137 VGND VGND VPWR VPWR sky130_fd_sc_hd__decap_3
XFILLER_51_104 VGND VGND VPWR VPWR sky130_fd_sc_hd__decap_3
XFILLER_36_189 VGND VGND VPWR VPWR sky130_fd_sc_hd__decap_3
XTAP_TAPCELL_ROW_34_335 VGND VPWR sky130_fd_sc_hd__tapvpwrvgnd_1
XFILLER_32_351 VGND VGND VPWR VPWR sky130_fd_sc_hd__decap_3
XTAP_TAPCELL_ROW_42_390 VGND VPWR sky130_fd_sc_hd__tapvpwrvgnd_1
XFILLER_32_395 VGND VGND VPWR VPWR sky130_fd_sc_hd__decap_3
XFILLER_10_27 VGND VGND VPWR VPWR sky130_fd_sc_hd__fill_1
XFILLER_10_38 VGND VGND VPWR VPWR sky130_fd_sc_hd__decap_3
XFILLER_59_237 VGND VGND VPWR VPWR sky130_fd_sc_hd__decap_3
XFILLER_19_69 VGND VGND VPWR VPWR sky130_fd_sc_hd__decap_3
XPHY_EDGE_ROW_20_1_Left_126 VGND VGND VPWR VPWR sky130_fd_sc_hd__decap_3
XFILLER_27_134 VGND VGND VPWR VPWR sky130_fd_sc_hd__decap_3
XFILLER_27_167 VGND VGND VPWR VPWR sky130_fd_sc_hd__fill_1
XFILLER_27_178 VGND VGND VPWR VPWR sky130_fd_sc_hd__decap_3
XFILLER_42_126 VGND VGND VPWR VPWR sky130_fd_sc_hd__decap_3
XFILLER_35_57 VGND VGND VPWR VPWR sky130_fd_sc_hd__decap_3
XFILLER_23_340 VGND VGND VPWR VPWR sky130_fd_sc_hd__decap_3
XFILLER_42_159 VGND VGND VPWR VPWR sky130_fd_sc_hd__decap_3
XFILLER_23_373 VGND VGND VPWR VPWR sky130_fd_sc_hd__decap_3
XFILLER_51_12 VGND VGND VPWR VPWR sky130_fd_sc_hd__decap_3
X_140_ genblk1\[3\].fa_inst.b genblk1\[3\].fa_inst.a VGND VGND VPWR VPWR _061_ sky130_fd_sc_hd__or2_1
XFILLER_50_192 VGND VGND VPWR VPWR sky130_fd_sc_hd__decap_3
XFILLER_51_89 VGND VGND VPWR VPWR sky130_fd_sc_hd__decap_3
XFILLER_18_112 VGND VGND VPWR VPWR sky130_fd_sc_hd__decap_3
XFILLER_58_292 VGND VGND VPWR VPWR sky130_fd_sc_hd__decap_3
XFILLER_18_156 VGND VGND VPWR VPWR sky130_fd_sc_hd__decap_3
XPHY_EDGE_ROW_14_1_Right_13 VGND VGND VPWR VPWR sky130_fd_sc_hd__decap_3
XFILLER_61_402 VGND VGND VPWR VPWR sky130_fd_sc_hd__fill_1
XFILLER_33_104 VGND VGND VPWR VPWR sky130_fd_sc_hd__decap_3
XFILLER_14_340 VGND VGND VPWR VPWR sky130_fd_sc_hd__decap_3
XFILLER_33_137 VGND VGND VPWR VPWR sky130_fd_sc_hd__decap_3
XFILLER_14_384 VGND VGND VPWR VPWR sky130_fd_sc_hd__decap_3
XFILLER_41_181 VGND VGND VPWR VPWR sky130_fd_sc_hd__decap_3
X_269_ clknet_2_3__leaf_clk_regs genblk1\[14\].fa_inst.s _014_ VGND VGND VPWR VPWR
+ net44 sky130_fd_sc_hd__dfrtp_1
XFILLER_56_218 VGND VGND VPWR VPWR sky130_fd_sc_hd__decap_3
XFILLER_2_50 VGND VGND VPWR VPWR sky130_fd_sc_hd__decap_3
XFILLER_49_281 VGND VGND VPWR VPWR sky130_fd_sc_hd__decap_3
XFILLER_49_270 VGND VGND VPWR VPWR sky130_fd_sc_hd__decap_3
XFILLER_2_94 VGND VGND VPWR VPWR sky130_fd_sc_hd__decap_3
XFILLER_2_83 VGND VGND VPWR VPWR sky130_fd_sc_hd__fill_1
XFILLER_64_240 VGND VGND VPWR VPWR sky130_fd_sc_hd__decap_3
XFILLER_24_126 VGND VGND VPWR VPWR sky130_fd_sc_hd__decap_3
XFILLER_64_262 VGND VGND VPWR VPWR sky130_fd_sc_hd__decap_3
XFILLER_64_284 VGND VGND VPWR VPWR sky130_fd_sc_hd__decap_3
XFILLER_24_159 VGND VGND VPWR VPWR sky130_fd_sc_hd__decap_3
XFILLER_32_181 VGND VGND VPWR VPWR sky130_fd_sc_hd__decap_3
XFILLER_20_343 VGND VGND VPWR VPWR sky130_fd_sc_hd__decap_3
XFILLER_20_354 VGND VGND VPWR VPWR sky130_fd_sc_hd__decap_3
XFILLER_20_387 VGND VGND VPWR VPWR sky130_fd_sc_hd__decap_3
XFILLER_21_15 VGND VGND VPWR VPWR sky130_fd_sc_hd__decap_3
XFILLER_46_12 VGND VGND VPWR VPWR sky130_fd_sc_hd__decap_3
XTAP_TAPCELL_ROW_45_408 VGND VPWR sky130_fd_sc_hd__tapvpwrvgnd_1
XFILLER_55_240 VGND VGND VPWR VPWR sky130_fd_sc_hd__decap_3
XFILLER_46_56 VGND VGND VPWR VPWR sky130_fd_sc_hd__decap_3
XFILLER_55_284 VGND VGND VPWR VPWR sky130_fd_sc_hd__decap_3
XFILLER_55_273 VGND VGND VPWR VPWR sky130_fd_sc_hd__decap_3
XFILLER_43_402 VGND VGND VPWR VPWR sky130_fd_sc_hd__decap_3
XFILLER_15_137 VGND VGND VPWR VPWR sky130_fd_sc_hd__decap_3
XFILLER_62_44 VGND VGND VPWR VPWR sky130_fd_sc_hd__decap_3
XTAP_TAPCELL_ROW_53_463 VGND VPWR sky130_fd_sc_hd__tapvpwrvgnd_1
XFILLER_30_118 VGND VGND VPWR VPWR sky130_fd_sc_hd__decap_3
XFILLER_23_181 VGND VGND VPWR VPWR sky130_fd_sc_hd__decap_3
XFILLER_62_77 VGND VGND VPWR VPWR sky130_fd_sc_hd__decap_3
XFILLER_62_88 VGND VGND VPWR VPWR sky130_fd_sc_hd__decap_3
XFILLER_11_343 VGND VGND VPWR VPWR sky130_fd_sc_hd__decap_3
XFILLER_11_376 VGND VGND VPWR VPWR sky130_fd_sc_hd__decap_3
XFILLER_7_39 VGND VGND VPWR VPWR sky130_fd_sc_hd__decap_3
XFILLER_7_358 VGND VGND VPWR VPWR sky130_fd_sc_hd__decap_3
XFILLER_11_92 VGND VGND VPWR VPWR sky130_fd_sc_hd__decap_3
XPHY_EDGE_ROW_5_1_Left_111 VGND VGND VPWR VPWR sky130_fd_sc_hd__decap_3
XFILLER_30_9 VGND VGND VPWR VPWR sky130_fd_sc_hd__decap_3
XFILLER_38_218 VGND VGND VPWR VPWR sky130_fd_sc_hd__decap_3
XFILLER_46_251 VGND VGND VPWR VPWR sky130_fd_sc_hd__fill_1
XFILLER_46_262 VGND VGND VPWR VPWR sky130_fd_sc_hd__decap_3
XFILLER_61_243 VGND VGND VPWR VPWR sky130_fd_sc_hd__decap_3
XFILLER_46_295 VGND VGND VPWR VPWR sky130_fd_sc_hd__decap_3
XFILLER_61_287 VGND VGND VPWR VPWR sky130_fd_sc_hd__decap_3
XFILLER_61_276 VGND VGND VPWR VPWR sky130_fd_sc_hd__decap_3
Xinput20 b[12] VGND VGND VPWR VPWR net20 sky130_fd_sc_hd__clkbuf_1
Xinput31 b[8] VGND VGND VPWR VPWR net31 sky130_fd_sc_hd__clkbuf_1
XFILLER_37_240 VGND VGND VPWR VPWR sky130_fd_sc_hd__decap_3
XFILLER_16_15 VGND VGND VPWR VPWR sky130_fd_sc_hd__decap_3
XFILLER_25_402 VGND VGND VPWR VPWR sky130_fd_sc_hd__fill_1
XFILLER_37_284 VGND VGND VPWR VPWR sky130_fd_sc_hd__decap_3
XFILLER_37_273 VGND VGND VPWR VPWR sky130_fd_sc_hd__decap_3
XFILLER_16_59 VGND VGND VPWR VPWR sky130_fd_sc_hd__decap_3
XFILLER_52_221 VGND VGND VPWR VPWR sky130_fd_sc_hd__decap_3
XFILLER_12_118 VGND VGND VPWR VPWR sky130_fd_sc_hd__decap_3
XFILLER_52_265 VGND VGND VPWR VPWR sky130_fd_sc_hd__decap_3
XFILLER_52_298 VGND VGND VPWR VPWR sky130_fd_sc_hd__decap_3
XTAP_TAPCELL_ROW_50_444 VGND VPWR sky130_fd_sc_hd__tapvpwrvgnd_1
XFILLER_32_47 VGND VGND VPWR VPWR sky130_fd_sc_hd__decap_3
XFILLER_20_162 VGND VGND VPWR VPWR sky130_fd_sc_hd__decap_3
XFILLER_4_328 VGND VGND VPWR VPWR sky130_fd_sc_hd__decap_3
XTAP_TAPCELL_ROW_58_500 VGND VPWR sky130_fd_sc_hd__tapvpwrvgnd_1
XFILLER_57_66 VGND VGND VPWR VPWR sky130_fd_sc_hd__fill_2
XFILLER_57_55 VGND VGND VPWR VPWR sky130_fd_sc_hd__fill_1
XFILLER_16_402 VGND VGND VPWR VPWR sky130_fd_sc_hd__decap_3
XFILLER_28_262 VGND VGND VPWR VPWR sky130_fd_sc_hd__decap_3
XFILLER_28_251 VGND VGND VPWR VPWR sky130_fd_sc_hd__fill_1
XFILLER_43_243 VGND VGND VPWR VPWR sky130_fd_sc_hd__decap_3
XFILLER_28_295 VGND VGND VPWR VPWR sky130_fd_sc_hd__decap_3
XFILLER_43_276 VGND VGND VPWR VPWR sky130_fd_sc_hd__decap_3
XFILLER_31_405 VGND VGND VPWR VPWR sky130_fd_sc_hd__fill_2
XFILLER_43_287 VGND VGND VPWR VPWR sky130_fd_sc_hd__decap_3
XFILLER_11_140 VGND VGND VPWR VPWR sky130_fd_sc_hd__decap_3
XFILLER_7_100 VGND VGND VPWR VPWR sky130_fd_sc_hd__decap_3
XFILLER_7_122 VGND VGND VPWR VPWR sky130_fd_sc_hd__decap_3
XFILLER_7_155 VGND VGND VPWR VPWR sky130_fd_sc_hd__decap_3
XFILLER_22_91 VGND VGND VPWR VPWR sky130_fd_sc_hd__decap_3
XFILLER_3_361 VGND VGND VPWR VPWR sky130_fd_sc_hd__decap_3
XFILLER_3_394 VGND VGND VPWR VPWR sky130_fd_sc_hd__decap_3
XTAP_TAPCELL_ROW_64_547 VGND VPWR sky130_fd_sc_hd__tapvpwrvgnd_1
XFILLER_34_221 VGND VGND VPWR VPWR sky130_fd_sc_hd__decap_3
Xclkbuf_2_0__f_clk_regs clknet_0_clk_regs VGND VGND VPWR VPWR clknet_2_0__leaf_clk_regs
+ sky130_fd_sc_hd__clkbuf_16
XFILLER_34_265 VGND VGND VPWR VPWR sky130_fd_sc_hd__decap_3
XFILLER_34_298 VGND VGND VPWR VPWR sky130_fd_sc_hd__decap_3
XFILLER_8_71 VGND VGND VPWR VPWR sky130_fd_sc_hd__decap_3
XFILLER_57_335 VGND VGND VPWR VPWR sky130_fd_sc_hd__fill_1
XFILLER_57_346 VGND VGND VPWR VPWR sky130_fd_sc_hd__decap_3
XFILLER_27_47 VGND VGND VPWR VPWR sky130_fd_sc_hd__decap_3
XFILLER_27_69 VGND VGND VPWR VPWR sky130_fd_sc_hd__decap_3
XFILLER_57_379 VGND VGND VPWR VPWR sky130_fd_sc_hd__decap_3
XFILLER_25_243 VGND VGND VPWR VPWR sky130_fd_sc_hd__decap_3
XFILLER_25_276 VGND VGND VPWR VPWR sky130_fd_sc_hd__decap_3
XFILLER_25_287 VGND VGND VPWR VPWR sky130_fd_sc_hd__decap_3
XFILLER_40_224 VGND VGND VPWR VPWR sky130_fd_sc_hd__decap_3
XFILLER_43_57 VGND VGND VPWR VPWR sky130_fd_sc_hd__decap_3
XFILLER_40_268 VGND VGND VPWR VPWR sky130_fd_sc_hd__decap_3
XFILLER_4_147 VGND VGND VPWR VPWR sky130_fd_sc_hd__decap_3
XFILLER_4_136 VGND VGND VPWR VPWR sky130_fd_sc_hd__decap_3
XFILLER_0_331 VGND VGND VPWR VPWR sky130_fd_sc_hd__decap_3
XFILLER_0_375 VGND VGND VPWR VPWR sky130_fd_sc_hd__decap_3
XFILLER_0_397 VGND VGND VPWR VPWR sky130_fd_sc_hd__decap_3
XFILLER_48_324 VGND VGND VPWR VPWR sky130_fd_sc_hd__decap_3
XFILLER_48_368 VGND VGND VPWR VPWR sky130_fd_sc_hd__decap_3
XFILLER_48_357 VGND VGND VPWR VPWR sky130_fd_sc_hd__decap_3
XFILLER_63_305 VGND VGND VPWR VPWR sky130_fd_sc_hd__decap_3
XFILLER_63_349 VGND VGND VPWR VPWR sky130_fd_sc_hd__decap_3
XFILLER_17_91 VGND VGND VPWR VPWR sky130_fd_sc_hd__decap_3
XFILLER_31_202 VGND VGND VPWR VPWR sky130_fd_sc_hd__decap_3
XFILLER_31_246 VGND VGND VPWR VPWR sky130_fd_sc_hd__decap_3
XFILLER_31_279 VGND VGND VPWR VPWR sky130_fd_sc_hd__fill_1
XFILLER_39_335 VGND VGND VPWR VPWR sky130_fd_sc_hd__fill_1
XFILLER_39_302 VGND VGND VPWR VPWR sky130_fd_sc_hd__decap_3
XFILLER_39_346 VGND VGND VPWR VPWR sky130_fd_sc_hd__decap_3
XFILLER_54_327 VGND VGND VPWR VPWR sky130_fd_sc_hd__decap_3
XFILLER_39_379 VGND VGND VPWR VPWR sky130_fd_sc_hd__decap_3
XFILLER_62_360 VGND VGND VPWR VPWR sky130_fd_sc_hd__decap_3
XFILLER_62_371 VGND VGND VPWR VPWR sky130_fd_sc_hd__decap_3
XFILLER_22_268 VGND VGND VPWR VPWR sky130_fd_sc_hd__decap_3
XFILLER_13_49 VGND VGND VPWR VPWR sky130_fd_sc_hd__decap_3
XTAP_TAPCELL_ROW_18_1_224 VGND VPWR sky130_fd_sc_hd__tapvpwrvgnd_1
XFILLER_1_128 VGND VGND VPWR VPWR sky130_fd_sc_hd__decap_3
XFILLER_8_9 VGND VGND VPWR VPWR sky130_fd_sc_hd__decap_3
XFILLER_57_110 VGND VGND VPWR VPWR sky130_fd_sc_hd__fill_2
XFILLER_38_35 VGND VGND VPWR VPWR sky130_fd_sc_hd__decap_3
XFILLER_38_24 VGND VGND VPWR VPWR sky130_fd_sc_hd__decap_3
XFILLER_57_143 VGND VGND VPWR VPWR sky130_fd_sc_hd__decap_3
XFILLER_38_79 VGND VGND VPWR VPWR sky130_fd_sc_hd__decap_3
XFILLER_38_68 VGND VGND VPWR VPWR sky130_fd_sc_hd__fill_2
XFILLER_57_187 VGND VGND VPWR VPWR sky130_fd_sc_hd__decap_3
XFILLER_45_305 VGND VGND VPWR VPWR sky130_fd_sc_hd__decap_3
XFILLER_54_12 VGND VGND VPWR VPWR sky130_fd_sc_hd__decap_3
XFILLER_45_349 VGND VGND VPWR VPWR sky130_fd_sc_hd__decap_3
XFILLER_54_56 VGND VGND VPWR VPWR sky130_fd_sc_hd__decap_3
XFILLER_53_393 VGND VGND VPWR VPWR sky130_fd_sc_hd__decap_3
XFILLER_53_382 VGND VGND VPWR VPWR sky130_fd_sc_hd__decap_3
XFILLER_0_150 VGND VGND VPWR VPWR sky130_fd_sc_hd__decap_3
XFILLER_0_172 VGND VGND VPWR VPWR sky130_fd_sc_hd__fill_1
XFILLER_48_132 VGND VGND VPWR VPWR sky130_fd_sc_hd__decap_3
XFILLER_63_102 VGND VGND VPWR VPWR sky130_fd_sc_hd__decap_3
XFILLER_48_165 VGND VGND VPWR VPWR sky130_fd_sc_hd__decap_3
XFILLER_36_327 VGND VGND VPWR VPWR sky130_fd_sc_hd__decap_3
XFILLER_63_113 VGND VGND VPWR VPWR sky130_fd_sc_hd__decap_3
XFILLER_63_146 VGND VGND VPWR VPWR sky130_fd_sc_hd__decap_3
XFILLER_51_308 VGND VGND VPWR VPWR sky130_fd_sc_hd__decap_3
XFILLER_44_371 VGND VGND VPWR VPWR sky130_fd_sc_hd__decap_3
XFILLER_44_360 VGND VGND VPWR VPWR sky130_fd_sc_hd__decap_3
XFILLER_5_94 VGND VGND VPWR VPWR sky130_fd_sc_hd__decap_3
XFILLER_39_143 VGND VGND VPWR VPWR sky130_fd_sc_hd__decap_3
XFILLER_27_305 VGND VGND VPWR VPWR sky130_fd_sc_hd__decap_3
XFILLER_27_349 VGND VGND VPWR VPWR sky130_fd_sc_hd__decap_3
XFILLER_54_124 VGND VGND VPWR VPWR sky130_fd_sc_hd__decap_3
XFILLER_39_187 VGND VGND VPWR VPWR sky130_fd_sc_hd__decap_3
XTAP_TAPCELL_ROW_37_355 VGND VPWR sky130_fd_sc_hd__tapvpwrvgnd_1
XFILLER_54_168 VGND VGND VPWR VPWR sky130_fd_sc_hd__decap_3
XFILLER_24_15 VGND VGND VPWR VPWR sky130_fd_sc_hd__decap_3
XFILLER_35_382 VGND VGND VPWR VPWR sky130_fd_sc_hd__decap_3
XPHY_EDGE_ROW_59_Left_165 VGND VGND VPWR VPWR sky130_fd_sc_hd__decap_3
XFILLER_50_330 VGND VGND VPWR VPWR sky130_fd_sc_hd__decap_3
XFILLER_35_393 VGND VGND VPWR VPWR sky130_fd_sc_hd__decap_3
XFILLER_24_59 VGND VGND VPWR VPWR sky130_fd_sc_hd__decap_3
XFILLER_50_374 VGND VGND VPWR VPWR sky130_fd_sc_hd__decap_3
XFILLER_50_363 VGND VGND VPWR VPWR sky130_fd_sc_hd__fill_1
XFILLER_40_47 VGND VGND VPWR VPWR sky130_fd_sc_hd__decap_3
XFILLER_6_6 VGND VGND VPWR VPWR sky130_fd_sc_hd__decap_3
XFILLER_49_12 VGND VGND VPWR VPWR sky130_fd_sc_hd__decap_3
XFILLER_18_349 VGND VGND VPWR VPWR sky130_fd_sc_hd__decap_3
XFILLER_45_113 VGND VGND VPWR VPWR sky130_fd_sc_hd__decap_3
XFILLER_45_146 VGND VGND VPWR VPWR sky130_fd_sc_hd__decap_3
XFILLER_33_308 VGND VGND VPWR VPWR sky130_fd_sc_hd__decap_3
XFILLER_26_360 VGND VGND VPWR VPWR sky130_fd_sc_hd__decap_3
XFILLER_26_371 VGND VGND VPWR VPWR sky130_fd_sc_hd__decap_3
XFILLER_60_127 VGND VGND VPWR VPWR sky130_fd_sc_hd__decap_3
XFILLER_53_190 VGND VGND VPWR VPWR sky130_fd_sc_hd__decap_3
XFILLER_41_385 VGND VGND VPWR VPWR sky130_fd_sc_hd__decap_3
XFILLER_41_352 VGND VGND VPWR VPWR sky130_fd_sc_hd__decap_3
X_285_ clknet_2_3__leaf_clk_regs net5 _030_ VGND VGND VPWR VPWR genblk1\[13\].fa_inst.a
+ sky130_fd_sc_hd__dfrtp_1
XFILLER_41_396 VGND VGND VPWR VPWR sky130_fd_sc_hd__decap_3
XFILLER_30_91 VGND VGND VPWR VPWR sky130_fd_sc_hd__decap_3
XFILLER_39_6 VGND VGND VPWR VPWR sky130_fd_sc_hd__decap_3
Xinput7 a[15] VGND VGND VPWR VPWR net7 sky130_fd_sc_hd__buf_1
XFILLER_36_124 VGND VGND VPWR VPWR sky130_fd_sc_hd__decap_3
XFILLER_36_168 VGND VGND VPWR VPWR sky130_fd_sc_hd__decap_3
XFILLER_17_382 VGND VGND VPWR VPWR sky130_fd_sc_hd__decap_3
XFILLER_51_116 VGND VGND VPWR VPWR sky130_fd_sc_hd__decap_3
XTAP_TAPCELL_ROW_34_336 VGND VPWR sky130_fd_sc_hd__tapvpwrvgnd_1
XFILLER_51_149 VGND VGND VPWR VPWR sky130_fd_sc_hd__decap_3
XFILLER_32_330 VGND VGND VPWR VPWR sky130_fd_sc_hd__decap_3
XFILLER_32_374 VGND VGND VPWR VPWR sky130_fd_sc_hd__decap_3
XFILLER_32_363 VGND VGND VPWR VPWR sky130_fd_sc_hd__fill_1
XTAP_TAPCELL_ROW_42_391 VGND VPWR sky130_fd_sc_hd__tapvpwrvgnd_1
XFILLER_59_205 VGND VGND VPWR VPWR sky130_fd_sc_hd__decap_3
XFILLER_19_15 VGND VGND VPWR VPWR sky130_fd_sc_hd__fill_2
XFILLER_19_37 VGND VGND VPWR VPWR sky130_fd_sc_hd__decap_3
XFILLER_59_249 VGND VGND VPWR VPWR sky130_fd_sc_hd__decap_3
XFILLER_27_102 VGND VGND VPWR VPWR sky130_fd_sc_hd__decap_3
XFILLER_27_113 VGND VGND VPWR VPWR sky130_fd_sc_hd__decap_3
XFILLER_27_146 VGND VGND VPWR VPWR sky130_fd_sc_hd__decap_3
XFILLER_42_105 VGND VGND VPWR VPWR sky130_fd_sc_hd__decap_3
XFILLER_35_47 VGND VGND VPWR VPWR sky130_fd_sc_hd__decap_3
XFILLER_42_138 VGND VGND VPWR VPWR sky130_fd_sc_hd__fill_2
XFILLER_35_69 VGND VGND VPWR VPWR sky130_fd_sc_hd__decap_3
XFILLER_35_190 VGND VGND VPWR VPWR sky130_fd_sc_hd__decap_3
XFILLER_23_352 VGND VGND VPWR VPWR sky130_fd_sc_hd__decap_3
XFILLER_23_385 VGND VGND VPWR VPWR sky130_fd_sc_hd__decap_3
XFILLER_23_396 VGND VGND VPWR VPWR sky130_fd_sc_hd__decap_3
XFILLER_50_171 VGND VGND VPWR VPWR sky130_fd_sc_hd__decap_3
XFILLER_51_57 VGND VGND VPWR VPWR sky130_fd_sc_hd__decap_3
XFILLER_51_46 VGND VGND VPWR VPWR sky130_fd_sc_hd__decap_3
XFILLER_18_124 VGND VGND VPWR VPWR sky130_fd_sc_hd__decap_3
XTAP_TAPCELL_ROW_48_428 VGND VPWR sky130_fd_sc_hd__tapvpwrvgnd_1
XFILLER_58_271 VGND VGND VPWR VPWR sky130_fd_sc_hd__decap_3
XFILLER_18_168 VGND VGND VPWR VPWR sky130_fd_sc_hd__decap_3
XFILLER_33_116 VGND VGND VPWR VPWR sky130_fd_sc_hd__decap_3
XFILLER_33_149 VGND VGND VPWR VPWR sky130_fd_sc_hd__decap_3
XFILLER_14_352 VGND VGND VPWR VPWR sky130_fd_sc_hd__fill_1
XFILLER_14_363 VGND VGND VPWR VPWR sky130_fd_sc_hd__decap_3
XFILLER_14_396 VGND VGND VPWR VPWR sky130_fd_sc_hd__decap_3
XFILLER_25_91 VGND VGND VPWR VPWR sky130_fd_sc_hd__decap_3
XFILLER_41_193 VGND VGND VPWR VPWR sky130_fd_sc_hd__decap_3
X_268_ clknet_2_3__leaf_clk_regs genblk1\[13\].fa_inst.s _013_ VGND VGND VPWR VPWR
+ net43 sky130_fd_sc_hd__dfrtp_1
X_199_ _107_ _108_ VGND VGND VPWR VPWR genblk1\[14\].fa_inst.s sky130_fd_sc_hd__xnor2_1
XFILLER_41_90 VGND VGND VPWR VPWR sky130_fd_sc_hd__decap_3
XFILLER_37_3 VGND VGND VPWR VPWR sky130_fd_sc_hd__decap_3
XFILLER_2_62 VGND VGND VPWR VPWR sky130_fd_sc_hd__decap_3
XFILLER_49_293 VGND VGND VPWR VPWR sky130_fd_sc_hd__decap_3
XFILLER_64_274 VGND VGND VPWR VPWR sky130_fd_sc_hd__decap_3
XFILLER_24_138 VGND VGND VPWR VPWR sky130_fd_sc_hd__fill_2
XFILLER_64_296 VGND VGND VPWR VPWR sky130_fd_sc_hd__decap_3
XFILLER_32_193 VGND VGND VPWR VPWR sky130_fd_sc_hd__decap_3
XFILLER_20_366 VGND VGND VPWR VPWR sky130_fd_sc_hd__decap_3
XFILLER_20_399 VGND VGND VPWR VPWR sky130_fd_sc_hd__decap_3
XFILLER_21_27 VGND VGND VPWR VPWR sky130_fd_sc_hd__fill_1
XFILLER_21_38 VGND VGND VPWR VPWR sky130_fd_sc_hd__decap_3
XFILLER_47_208 VGND VGND VPWR VPWR sky130_fd_sc_hd__decap_3
XFILLER_46_24 VGND VGND VPWR VPWR sky130_fd_sc_hd__decap_3
XTAP_TAPCELL_ROW_45_409 VGND VPWR sky130_fd_sc_hd__tapvpwrvgnd_1
XFILLER_55_252 VGND VGND VPWR VPWR sky130_fd_sc_hd__decap_3
XFILLER_46_68 VGND VGND VPWR VPWR sky130_fd_sc_hd__decap_3
XFILLER_46_35 VGND VGND VPWR VPWR sky130_fd_sc_hd__decap_3
XFILLER_15_105 VGND VGND VPWR VPWR sky130_fd_sc_hd__decap_3
XFILLER_15_116 VGND VGND VPWR VPWR sky130_fd_sc_hd__decap_3
XFILLER_15_149 VGND VGND VPWR VPWR sky130_fd_sc_hd__decap_3
XFILLER_62_12 VGND VGND VPWR VPWR sky130_fd_sc_hd__decap_3
XFILLER_55_296 VGND VGND VPWR VPWR sky130_fd_sc_hd__decap_3
XTAP_TAPCELL_ROW_53_464 VGND VPWR sky130_fd_sc_hd__tapvpwrvgnd_1
XFILLER_62_56 VGND VGND VPWR VPWR sky130_fd_sc_hd__decap_3
XFILLER_11_355 VGND VGND VPWR VPWR sky130_fd_sc_hd__decap_3
XFILLER_23_193 VGND VGND VPWR VPWR sky130_fd_sc_hd__decap_3
XFILLER_7_18 VGND VGND VPWR VPWR sky130_fd_sc_hd__decap_3
XFILLER_11_388 VGND VGND VPWR VPWR sky130_fd_sc_hd__decap_3
XFILLER_7_337 VGND VGND VPWR VPWR sky130_fd_sc_hd__decap_3
XFILLER_11_71 VGND VGND VPWR VPWR sky130_fd_sc_hd__decap_3
XFILLER_23_9 VGND VGND VPWR VPWR sky130_fd_sc_hd__decap_3
XFILLER_19_400 VGND VGND VPWR VPWR sky130_fd_sc_hd__decap_3
XFILLER_46_230 VGND VGND VPWR VPWR sky130_fd_sc_hd__decap_3
XFILLER_61_211 VGND VGND VPWR VPWR sky130_fd_sc_hd__decap_3
XFILLER_46_274 VGND VGND VPWR VPWR sky130_fd_sc_hd__decap_3
XFILLER_61_255 VGND VGND VPWR VPWR sky130_fd_sc_hd__decap_3
XFILLER_14_171 VGND VGND VPWR VPWR sky130_fd_sc_hd__decap_3
XFILLER_21_119 VGND VGND VPWR VPWR sky130_fd_sc_hd__decap_3
XFILLER_61_299 VGND VGND VPWR VPWR sky130_fd_sc_hd__decap_3
Xinput10 a[3] VGND VGND VPWR VPWR net10 sky130_fd_sc_hd__clkbuf_1
Xinput21 b[13] VGND VGND VPWR VPWR net21 sky130_fd_sc_hd__clkbuf_1
Xinput32 b[9] VGND VGND VPWR VPWR net32 sky130_fd_sc_hd__clkbuf_1
XFILLER_6_381 VGND VGND VPWR VPWR sky130_fd_sc_hd__decap_3
XPHY_EDGE_ROW_12_2_Left_33 VGND VGND VPWR VPWR sky130_fd_sc_hd__decap_3
XFILLER_29_208 VGND VGND VPWR VPWR sky130_fd_sc_hd__decap_3
XFILLER_52_200 VGND VGND VPWR VPWR sky130_fd_sc_hd__decap_3
XFILLER_37_252 VGND VGND VPWR VPWR sky130_fd_sc_hd__decap_3
XFILLER_16_38 VGND VGND VPWR VPWR sky130_fd_sc_hd__decap_3
XFILLER_52_233 VGND VGND VPWR VPWR sky130_fd_sc_hd__decap_3
XFILLER_37_296 VGND VGND VPWR VPWR sky130_fd_sc_hd__decap_3
XFILLER_52_277 VGND VGND VPWR VPWR sky130_fd_sc_hd__decap_3
XFILLER_20_141 VGND VGND VPWR VPWR sky130_fd_sc_hd__decap_3
XTAP_TAPCELL_ROW_50_445 VGND VPWR sky130_fd_sc_hd__tapvpwrvgnd_1
XFILLER_32_15 VGND VGND VPWR VPWR sky130_fd_sc_hd__decap_3
XFILLER_20_174 VGND VGND VPWR VPWR sky130_fd_sc_hd__decap_3
XFILLER_32_59 VGND VGND VPWR VPWR sky130_fd_sc_hd__decap_3
XFILLER_57_12 VGND VGND VPWR VPWR sky130_fd_sc_hd__decap_3
XTAP_TAPCELL_ROW_58_501 VGND VPWR sky130_fd_sc_hd__tapvpwrvgnd_1
XTAP_TAPCELL_ROW_19_1_226 VGND VPWR sky130_fd_sc_hd__tapvpwrvgnd_1
XFILLER_57_89 VGND VGND VPWR VPWR sky130_fd_sc_hd__decap_3
XFILLER_28_230 VGND VGND VPWR VPWR sky130_fd_sc_hd__decap_3
XFILLER_28_274 VGND VGND VPWR VPWR sky130_fd_sc_hd__decap_3
XFILLER_43_211 VGND VGND VPWR VPWR sky130_fd_sc_hd__decap_3
XFILLER_43_255 VGND VGND VPWR VPWR sky130_fd_sc_hd__decap_3
XFILLER_43_299 VGND VGND VPWR VPWR sky130_fd_sc_hd__decap_3
XFILLER_11_152 VGND VGND VPWR VPWR sky130_fd_sc_hd__decap_3
XFILLER_7_134 VGND VGND VPWR VPWR sky130_fd_sc_hd__decap_3
XFILLER_22_81 VGND VGND VPWR VPWR sky130_fd_sc_hd__decap_3
XFILLER_7_167 VGND VGND VPWR VPWR sky130_fd_sc_hd__fill_1
XFILLER_7_178 VGND VGND VPWR VPWR sky130_fd_sc_hd__fill_2
XFILLER_3_340 VGND VGND VPWR VPWR sky130_fd_sc_hd__decap_3
XFILLER_3_373 VGND VGND VPWR VPWR sky130_fd_sc_hd__decap_3
XFILLER_21_6 VGND VGND VPWR VPWR sky130_fd_sc_hd__decap_3
XPHY_EDGE_ROW_29_Right_50 VGND VGND VPWR VPWR sky130_fd_sc_hd__decap_3
XFILLER_34_200 VGND VGND VPWR VPWR sky130_fd_sc_hd__decap_3
XTAP_TAPCELL_ROW_64_548 VGND VPWR sky130_fd_sc_hd__tapvpwrvgnd_1
XFILLER_34_233 VGND VGND VPWR VPWR sky130_fd_sc_hd__decap_3
XPHY_EDGE_ROW_22_Left_128 VGND VGND VPWR VPWR sky130_fd_sc_hd__decap_3
XFILLER_34_277 VGND VGND VPWR VPWR sky130_fd_sc_hd__decap_3
XFILLER_8_83 VGND VGND VPWR VPWR sky130_fd_sc_hd__fill_1
XFILLER_8_94 VGND VGND VPWR VPWR sky130_fd_sc_hd__decap_3
XPHY_EDGE_ROW_31_Left_137 VGND VGND VPWR VPWR sky130_fd_sc_hd__decap_3
XFILLER_57_314 VGND VGND VPWR VPWR sky130_fd_sc_hd__decap_3
XFILLER_27_15 VGND VGND VPWR VPWR sky130_fd_sc_hd__decap_3
XFILLER_57_358 VGND VGND VPWR VPWR sky130_fd_sc_hd__decap_3
XFILLER_25_211 VGND VGND VPWR VPWR sky130_fd_sc_hd__decap_3
XPHY_EDGE_ROW_40_Left_146 VGND VGND VPWR VPWR sky130_fd_sc_hd__decap_3
XFILLER_25_255 VGND VGND VPWR VPWR sky130_fd_sc_hd__decap_3
XFILLER_25_299 VGND VGND VPWR VPWR sky130_fd_sc_hd__decap_3
XFILLER_40_203 VGND VGND VPWR VPWR sky130_fd_sc_hd__decap_3
XFILLER_43_69 VGND VGND VPWR VPWR sky130_fd_sc_hd__decap_3
XFILLER_40_236 VGND VGND VPWR VPWR sky130_fd_sc_hd__decap_3
XFILLER_4_159 VGND VGND VPWR VPWR sky130_fd_sc_hd__decap_3
XFILLER_0_343 VGND VGND VPWR VPWR sky130_fd_sc_hd__decap_3
XFILLER_0_354 VGND VGND VPWR VPWR sky130_fd_sc_hd__decap_3
XFILLER_48_336 VGND VGND VPWR VPWR sky130_fd_sc_hd__decap_3
XFILLER_63_317 VGND VGND VPWR VPWR sky130_fd_sc_hd__decap_3
XFILLER_56_380 VGND VGND VPWR VPWR sky130_fd_sc_hd__decap_3
XFILLER_31_225 VGND VGND VPWR VPWR sky130_fd_sc_hd__decap_3
XFILLER_31_214 VGND VGND VPWR VPWR sky130_fd_sc_hd__decap_3
XFILLER_31_258 VGND VGND VPWR VPWR sky130_fd_sc_hd__decap_3
XFILLER_33_80 VGND VGND VPWR VPWR sky130_fd_sc_hd__decap_3
XFILLER_39_314 VGND VGND VPWR VPWR sky130_fd_sc_hd__decap_3
XFILLER_39_358 VGND VGND VPWR VPWR sky130_fd_sc_hd__decap_3
XFILLER_54_339 VGND VGND VPWR VPWR sky130_fd_sc_hd__decap_3
XFILLER_47_391 VGND VGND VPWR VPWR sky130_fd_sc_hd__fill_1
XFILLER_22_203 VGND VGND VPWR VPWR sky130_fd_sc_hd__decap_3
XFILLER_62_383 VGND VGND VPWR VPWR sky130_fd_sc_hd__decap_3
XFILLER_22_247 VGND VGND VPWR VPWR sky130_fd_sc_hd__decap_3
XFILLER_30_280 VGND VGND VPWR VPWR sky130_fd_sc_hd__decap_3
XTAP_TAPCELL_ROW_18_1_225 VGND VPWR sky130_fd_sc_hd__tapvpwrvgnd_1
XFILLER_57_122 VGND VGND VPWR VPWR sky130_fd_sc_hd__decap_3
XFILLER_38_47 VGND VGND VPWR VPWR sky130_fd_sc_hd__decap_3
XFILLER_57_155 VGND VGND VPWR VPWR sky130_fd_sc_hd__decap_3
XFILLER_45_317 VGND VGND VPWR VPWR sky130_fd_sc_hd__decap_3
XFILLER_57_199 VGND VGND VPWR VPWR sky130_fd_sc_hd__decap_3
XFILLER_38_380 VGND VGND VPWR VPWR sky130_fd_sc_hd__decap_3
XFILLER_60_309 VGND VGND VPWR VPWR sky130_fd_sc_hd__decap_3
XFILLER_54_35 VGND VGND VPWR VPWR sky130_fd_sc_hd__decap_3
XFILLER_54_68 VGND VGND VPWR VPWR sky130_fd_sc_hd__decap_3
XFILLER_53_361 VGND VGND VPWR VPWR sky130_fd_sc_hd__decap_3
XTAP_TAPCELL_ROW_23_253 VGND VPWR sky130_fd_sc_hd__tapvpwrvgnd_1
XFILLER_0_162 VGND VGND VPWR VPWR sky130_fd_sc_hd__decap_3
XFILLER_48_144 VGND VGND VPWR VPWR sky130_fd_sc_hd__decap_3
XFILLER_48_177 VGND VGND VPWR VPWR sky130_fd_sc_hd__decap_3
XFILLER_63_125 VGND VGND VPWR VPWR sky130_fd_sc_hd__decap_3
XFILLER_36_339 VGND VGND VPWR VPWR sky130_fd_sc_hd__decap_3
XFILLER_29_391 VGND VGND VPWR VPWR sky130_fd_sc_hd__fill_1
XFILLER_28_80 VGND VGND VPWR VPWR sky130_fd_sc_hd__decap_3
XFILLER_63_158 VGND VGND VPWR VPWR sky130_fd_sc_hd__decap_3
XFILLER_63_169 VGND VGND VPWR VPWR sky130_fd_sc_hd__decap_3
XFILLER_44_383 VGND VGND VPWR VPWR sky130_fd_sc_hd__decap_3
XPHY_EDGE_ROW_10_1_Left_116 VGND VGND VPWR VPWR sky130_fd_sc_hd__decap_3
XFILLER_39_122 VGND VGND VPWR VPWR sky130_fd_sc_hd__decap_3
XFILLER_39_111 VGND VGND VPWR VPWR sky130_fd_sc_hd__fill_1
XFILLER_27_317 VGND VGND VPWR VPWR sky130_fd_sc_hd__decap_3
XFILLER_39_155 VGND VGND VPWR VPWR sky130_fd_sc_hd__decap_3
XFILLER_54_136 VGND VGND VPWR VPWR sky130_fd_sc_hd__decap_3
XFILLER_39_199 VGND VGND VPWR VPWR sky130_fd_sc_hd__decap_3
XTAP_TAPCELL_ROW_37_356 VGND VPWR sky130_fd_sc_hd__tapvpwrvgnd_1
XFILLER_54_147 VGND VGND VPWR VPWR sky130_fd_sc_hd__decap_3
XFILLER_42_309 VGND VGND VPWR VPWR sky130_fd_sc_hd__decap_3
XFILLER_35_361 VGND VGND VPWR VPWR sky130_fd_sc_hd__decap_3
XFILLER_24_27 VGND VGND VPWR VPWR sky130_fd_sc_hd__fill_1
XFILLER_24_38 VGND VGND VPWR VPWR sky130_fd_sc_hd__decap_3
XFILLER_62_180 VGND VGND VPWR VPWR sky130_fd_sc_hd__decap_3
XFILLER_50_342 VGND VGND VPWR VPWR sky130_fd_sc_hd__decap_3
XFILLER_50_386 VGND VGND VPWR VPWR sky130_fd_sc_hd__decap_3
XFILLER_40_15 VGND VGND VPWR VPWR sky130_fd_sc_hd__decap_3
XFILLER_40_59 VGND VGND VPWR VPWR sky130_fd_sc_hd__decap_3
XFILLER_2_405 VGND VGND VPWR VPWR sky130_fd_sc_hd__fill_2
XFILLER_49_79 VGND VGND VPWR VPWR sky130_fd_sc_hd__decap_3
XFILLER_49_57 VGND VGND VPWR VPWR sky130_fd_sc_hd__decap_3
XFILLER_18_328 VGND VGND VPWR VPWR sky130_fd_sc_hd__decap_3
XFILLER_45_125 VGND VGND VPWR VPWR sky130_fd_sc_hd__decap_3
XFILLER_45_103 VGND VGND VPWR VPWR sky130_fd_sc_hd__decap_3
XFILLER_45_169 VGND VGND VPWR VPWR sky130_fd_sc_hd__decap_3
XFILLER_45_158 VGND VGND VPWR VPWR sky130_fd_sc_hd__decap_3
XFILLER_26_383 VGND VGND VPWR VPWR sky130_fd_sc_hd__decap_3
XFILLER_60_106 VGND VGND VPWR VPWR sky130_fd_sc_hd__decap_3
XFILLER_60_139 VGND VGND VPWR VPWR sky130_fd_sc_hd__fill_1
XFILLER_41_320 VGND VGND VPWR VPWR sky130_fd_sc_hd__decap_3
XFILLER_41_364 VGND VGND VPWR VPWR sky130_fd_sc_hd__decap_3
XFILLER_14_71 VGND VGND VPWR VPWR sky130_fd_sc_hd__decap_3
X_284_ clknet_2_3__leaf_clk_regs net4 _029_ VGND VGND VPWR VPWR genblk1\[12\].fa_inst.a
+ sky130_fd_sc_hd__dfrtp_1
XFILLER_53_9 VGND VGND VPWR VPWR sky130_fd_sc_hd__decap_3
XFILLER_30_70 VGND VGND VPWR VPWR sky130_fd_sc_hd__decap_3
Xinput8 a[1] VGND VGND VPWR VPWR net8 sky130_fd_sc_hd__clkbuf_1
XFILLER_39_90 VGND VGND VPWR VPWR sky130_fd_sc_hd__decap_3
XFILLER_24_309 VGND VGND VPWR VPWR sky130_fd_sc_hd__decap_3
XFILLER_36_147 VGND VGND VPWR VPWR sky130_fd_sc_hd__decap_3
XFILLER_36_136 VGND VGND VPWR VPWR sky130_fd_sc_hd__decap_3
XFILLER_17_361 VGND VGND VPWR VPWR sky130_fd_sc_hd__decap_3
XFILLER_51_128 VGND VGND VPWR VPWR sky130_fd_sc_hd__decap_3
XFILLER_17_394 VGND VGND VPWR VPWR sky130_fd_sc_hd__decap_3
XFILLER_44_180 VGND VGND VPWR VPWR sky130_fd_sc_hd__decap_3
XFILLER_32_342 VGND VGND VPWR VPWR sky130_fd_sc_hd__decap_3
XFILLER_32_386 VGND VGND VPWR VPWR sky130_fd_sc_hd__decap_3
XTAP_TAPCELL_ROW_42_392 VGND VPWR sky130_fd_sc_hd__tapvpwrvgnd_1
XFILLER_10_18 VGND VGND VPWR VPWR sky130_fd_sc_hd__decap_3
XFILLER_10_29 VGND VGND VPWR VPWR sky130_fd_sc_hd__decap_3
XFILLER_59_228 VGND VGND VPWR VPWR sky130_fd_sc_hd__decap_3
XFILLER_59_217 VGND VGND VPWR VPWR sky130_fd_sc_hd__decap_3
XFILLER_19_49 VGND VGND VPWR VPWR sky130_fd_sc_hd__decap_3
XFILLER_27_125 VGND VGND VPWR VPWR sky130_fd_sc_hd__decap_3
XFILLER_27_158 VGND VGND VPWR VPWR sky130_fd_sc_hd__decap_3
XFILLER_35_15 VGND VGND VPWR VPWR sky130_fd_sc_hd__decap_3
XFILLER_27_169 VGND VGND VPWR VPWR sky130_fd_sc_hd__decap_3
XFILLER_42_117 VGND VGND VPWR VPWR sky130_fd_sc_hd__decap_3
XFILLER_23_320 VGND VGND VPWR VPWR sky130_fd_sc_hd__decap_3
XFILLER_23_364 VGND VGND VPWR VPWR sky130_fd_sc_hd__decap_3
XFILLER_50_150 VGND VGND VPWR VPWR sky130_fd_sc_hd__decap_3
XFILLER_50_183 VGND VGND VPWR VPWR sky130_fd_sc_hd__decap_3
XFILLER_51_69 VGND VGND VPWR VPWR sky130_fd_sc_hd__fill_1
XFILLER_18_103 VGND VGND VPWR VPWR sky130_fd_sc_hd__decap_3
XTAP_TAPCELL_ROW_48_429 VGND VPWR sky130_fd_sc_hd__tapvpwrvgnd_1
XFILLER_58_283 VGND VGND VPWR VPWR sky130_fd_sc_hd__decap_3
XFILLER_46_401 VGND VGND VPWR VPWR sky130_fd_sc_hd__decap_3
XFILLER_18_136 VGND VGND VPWR VPWR sky130_fd_sc_hd__decap_3
XFILLER_18_147 VGND VGND VPWR VPWR sky130_fd_sc_hd__decap_3
XFILLER_14_331 VGND VGND VPWR VPWR sky130_fd_sc_hd__decap_3
XFILLER_26_180 VGND VGND VPWR VPWR sky130_fd_sc_hd__decap_3
XTAP_TAPCELL_ROW_56_484 VGND VPWR sky130_fd_sc_hd__tapvpwrvgnd_1
XFILLER_33_128 VGND VGND VPWR VPWR sky130_fd_sc_hd__decap_3
XFILLER_14_375 VGND VGND VPWR VPWR sky130_fd_sc_hd__decap_3
XFILLER_41_172 VGND VGND VPWR VPWR sky130_fd_sc_hd__decap_3
XFILLER_41_161 VGND VGND VPWR VPWR sky130_fd_sc_hd__decap_3
X_267_ clknet_2_3__leaf_clk_regs genblk1\[12\].fa_inst.s _012_ VGND VGND VPWR VPWR
+ net42 sky130_fd_sc_hd__dfrtp_1
X_198_ _101_ _104_ _102_ VGND VGND VPWR VPWR _108_ sky130_fd_sc_hd__a21bo_1
XFILLER_51_6 VGND VGND VPWR VPWR sky130_fd_sc_hd__decap_3
XFILLER_56_209 VGND VGND VPWR VPWR sky130_fd_sc_hd__decap_3
XFILLER_2_41 VGND VGND VPWR VPWR sky130_fd_sc_hd__decap_3
XFILLER_49_261 VGND VGND VPWR VPWR sky130_fd_sc_hd__decap_3
XFILLER_2_85 VGND VGND VPWR VPWR sky130_fd_sc_hd__decap_3
XFILLER_2_74 VGND VGND VPWR VPWR sky130_fd_sc_hd__decap_3
XFILLER_64_231 VGND VGND VPWR VPWR sky130_fd_sc_hd__decap_3
XFILLER_24_117 VGND VGND VPWR VPWR sky130_fd_sc_hd__decap_3
XFILLER_64_253 VGND VGND VPWR VPWR sky130_fd_sc_hd__decap_3
XFILLER_52_404 VGND VGND VPWR VPWR sky130_fd_sc_hd__decap_3
XFILLER_32_172 VGND VGND VPWR VPWR sky130_fd_sc_hd__decap_3
XFILLER_20_334 VGND VGND VPWR VPWR sky130_fd_sc_hd__decap_3
XFILLER_20_378 VGND VGND VPWR VPWR sky130_fd_sc_hd__decap_3
XFILLER_28_401 VGND VGND VPWR VPWR sky130_fd_sc_hd__decap_3
XFILLER_55_231 VGND VGND VPWR VPWR sky130_fd_sc_hd__decap_3
XFILLER_55_220 VGND VGND VPWR VPWR sky130_fd_sc_hd__decap_3
XFILLER_46_47 VGND VGND VPWR VPWR sky130_fd_sc_hd__decap_3
XFILLER_55_264 VGND VGND VPWR VPWR sky130_fd_sc_hd__decap_3
XFILLER_15_128 VGND VGND VPWR VPWR sky130_fd_sc_hd__decap_3
XFILLER_62_24 VGND VGND VPWR VPWR sky130_fd_sc_hd__decap_3
XFILLER_62_35 VGND VGND VPWR VPWR sky130_fd_sc_hd__decap_3
XTAP_TAPCELL_ROW_53_465 VGND VPWR sky130_fd_sc_hd__tapvpwrvgnd_1
XFILLER_30_109 VGND VGND VPWR VPWR sky130_fd_sc_hd__decap_3
XFILLER_23_161 VGND VGND VPWR VPWR sky130_fd_sc_hd__decap_3
XFILLER_23_172 VGND VGND VPWR VPWR sky130_fd_sc_hd__decap_3
XFILLER_62_68 VGND VGND VPWR VPWR sky130_fd_sc_hd__decap_3
XFILLER_11_334 VGND VGND VPWR VPWR sky130_fd_sc_hd__decap_3
XFILLER_11_367 VGND VGND VPWR VPWR sky130_fd_sc_hd__decap_3
XFILLER_7_349 VGND VGND VPWR VPWR sky130_fd_sc_hd__decap_3
XFILLER_11_83 VGND VGND VPWR VPWR sky130_fd_sc_hd__decap_3
XFILLER_38_209 VGND VGND VPWR VPWR sky130_fd_sc_hd__decap_3
XFILLER_16_9 VGND VGND VPWR VPWR sky130_fd_sc_hd__decap_3
XFILLER_46_242 VGND VGND VPWR VPWR sky130_fd_sc_hd__decap_3
XFILLER_46_253 VGND VGND VPWR VPWR sky130_fd_sc_hd__decap_3
XFILLER_34_404 VGND VGND VPWR VPWR sky130_fd_sc_hd__decap_3
XFILLER_61_234 VGND VGND VPWR VPWR sky130_fd_sc_hd__decap_3
XFILLER_61_223 VGND VGND VPWR VPWR sky130_fd_sc_hd__fill_1
XFILLER_46_286 VGND VGND VPWR VPWR sky130_fd_sc_hd__decap_3
XFILLER_36_91 VGND VGND VPWR VPWR sky130_fd_sc_hd__fill_1
XFILLER_61_267 VGND VGND VPWR VPWR sky130_fd_sc_hd__decap_3
XFILLER_14_150 VGND VGND VPWR VPWR sky130_fd_sc_hd__decap_3
Xinput11 a[4] VGND VGND VPWR VPWR net11 sky130_fd_sc_hd__clkbuf_1
Xinput22 b[14] VGND VGND VPWR VPWR net22 sky130_fd_sc_hd__clkbuf_1
Xinput33 cin VGND VGND VPWR VPWR net33 sky130_fd_sc_hd__buf_1
XFILLER_6_360 VGND VGND VPWR VPWR sky130_fd_sc_hd__decap_3
XFILLER_6_393 VGND VGND VPWR VPWR sky130_fd_sc_hd__decap_3
Xclkbuf_1_0__f_clk clknet_0_clk VGND VGND VPWR VPWR clknet_1_0__leaf_clk sky130_fd_sc_hd__clkbuf_16
XFILLER_37_231 VGND VGND VPWR VPWR sky130_fd_sc_hd__decap_3
XFILLER_37_220 VGND VGND VPWR VPWR sky130_fd_sc_hd__decap_3
XFILLER_37_264 VGND VGND VPWR VPWR sky130_fd_sc_hd__decap_3
XFILLER_52_212 VGND VGND VPWR VPWR sky130_fd_sc_hd__decap_3
XFILLER_12_109 VGND VGND VPWR VPWR sky130_fd_sc_hd__decap_3
XFILLER_52_256 VGND VGND VPWR VPWR sky130_fd_sc_hd__decap_3
XFILLER_52_245 VGND VGND VPWR VPWR sky130_fd_sc_hd__decap_3
XFILLER_52_289 VGND VGND VPWR VPWR sky130_fd_sc_hd__decap_3
XTAP_TAPCELL_ROW_50_446 VGND VPWR sky130_fd_sc_hd__tapvpwrvgnd_1
XFILLER_32_38 VGND VGND VPWR VPWR sky130_fd_sc_hd__decap_3
XFILLER_32_27 VGND VGND VPWR VPWR sky130_fd_sc_hd__fill_1
XFILLER_20_153 VGND VGND VPWR VPWR sky130_fd_sc_hd__decap_3
XPHY_EDGE_ROW_13_1_Right_12 VGND VGND VPWR VPWR sky130_fd_sc_hd__decap_3
XTAP_TAPCELL_ROW_58_502 VGND VPWR sky130_fd_sc_hd__tapvpwrvgnd_1
XFILLER_57_57 VGND VGND VPWR VPWR sky130_fd_sc_hd__decap_3
XFILLER_57_46 VGND VGND VPWR VPWR sky130_fd_sc_hd__decap_3
XTAP_TAPCELL_ROW_19_1_227 VGND VPWR sky130_fd_sc_hd__tapvpwrvgnd_1
XFILLER_28_253 VGND VGND VPWR VPWR sky130_fd_sc_hd__decap_3
XFILLER_28_242 VGND VGND VPWR VPWR sky130_fd_sc_hd__decap_3
XFILLER_43_234 VGND VGND VPWR VPWR sky130_fd_sc_hd__decap_3
XFILLER_43_223 VGND VGND VPWR VPWR sky130_fd_sc_hd__fill_1
XFILLER_28_286 VGND VGND VPWR VPWR sky130_fd_sc_hd__decap_3
XFILLER_43_267 VGND VGND VPWR VPWR sky130_fd_sc_hd__decap_3
XFILLER_11_131 VGND VGND VPWR VPWR sky130_fd_sc_hd__decap_3
XFILLER_11_164 VGND VGND VPWR VPWR sky130_fd_sc_hd__decap_3
XFILLER_7_113 VGND VGND VPWR VPWR sky130_fd_sc_hd__decap_3
XFILLER_11_175 VGND VGND VPWR VPWR sky130_fd_sc_hd__decap_3
XFILLER_7_146 VGND VGND VPWR VPWR sky130_fd_sc_hd__decap_3
XFILLER_3_352 VGND VGND VPWR VPWR sky130_fd_sc_hd__decap_3
XFILLER_3_385 VGND VGND VPWR VPWR sky130_fd_sc_hd__decap_3
XFILLER_14_6 VGND VGND VPWR VPWR sky130_fd_sc_hd__decap_3
XFILLER_47_90 VGND VGND VPWR VPWR sky130_fd_sc_hd__decap_3
XTAP_TAPCELL_ROW_64_549 VGND VPWR sky130_fd_sc_hd__tapvpwrvgnd_1
XFILLER_34_212 VGND VGND VPWR VPWR sky130_fd_sc_hd__decap_3
XFILLER_34_256 VGND VGND VPWR VPWR sky130_fd_sc_hd__decap_3
XFILLER_34_245 VGND VGND VPWR VPWR sky130_fd_sc_hd__decap_3
XFILLER_34_289 VGND VGND VPWR VPWR sky130_fd_sc_hd__decap_3
XFILLER_57_326 VGND VGND VPWR VPWR sky130_fd_sc_hd__decap_3
XFILLER_57_337 VGND VGND VPWR VPWR sky130_fd_sc_hd__decap_3
XFILLER_27_38 VGND VGND VPWR VPWR sky130_fd_sc_hd__decap_3
XFILLER_25_223 VGND VGND VPWR VPWR sky130_fd_sc_hd__fill_1
XFILLER_25_234 VGND VGND VPWR VPWR sky130_fd_sc_hd__decap_3
XFILLER_25_267 VGND VGND VPWR VPWR sky130_fd_sc_hd__decap_3
XPHY_EDGE_ROW_4_1_Left_110 VGND VGND VPWR VPWR sky130_fd_sc_hd__decap_3
XFILLER_43_15 VGND VGND VPWR VPWR sky130_fd_sc_hd__decap_3
XFILLER_40_215 VGND VGND VPWR VPWR sky130_fd_sc_hd__decap_3
XFILLER_43_48 VGND VGND VPWR VPWR sky130_fd_sc_hd__decap_3
XFILLER_40_259 VGND VGND VPWR VPWR sky130_fd_sc_hd__decap_3
XFILLER_40_248 VGND VGND VPWR VPWR sky130_fd_sc_hd__decap_3
XFILLER_4_127 VGND VGND VPWR VPWR sky130_fd_sc_hd__decap_3
XPHY_EDGE_ROW_6_2_Left_27 VGND VGND VPWR VPWR sky130_fd_sc_hd__decap_3
XFILLER_0_366 VGND VGND VPWR VPWR sky130_fd_sc_hd__decap_3
XFILLER_0_388 VGND VGND VPWR VPWR sky130_fd_sc_hd__decap_3
XFILLER_48_315 VGND VGND VPWR VPWR sky130_fd_sc_hd__decap_3
XFILLER_48_304 VGND VGND VPWR VPWR sky130_fd_sc_hd__decap_3
XFILLER_48_348 VGND VGND VPWR VPWR sky130_fd_sc_hd__decap_3
XFILLER_63_329 VGND VGND VPWR VPWR sky130_fd_sc_hd__decap_3
XFILLER_56_392 VGND VGND VPWR VPWR sky130_fd_sc_hd__decap_3
XFILLER_17_60 VGND VGND VPWR VPWR sky130_fd_sc_hd__fill_1
XFILLER_17_82 VGND VGND VPWR VPWR sky130_fd_sc_hd__decap_3
XTAP_TAPCELL_ROW_61_519 VGND VPWR sky130_fd_sc_hd__tapvpwrvgnd_1
XFILLER_31_237 VGND VGND VPWR VPWR sky130_fd_sc_hd__decap_3
XFILLER_33_92 VGND VGND VPWR VPWR sky130_fd_sc_hd__decap_3
XFILLER_39_326 VGND VGND VPWR VPWR sky130_fd_sc_hd__decap_3
XFILLER_39_337 VGND VGND VPWR VPWR sky130_fd_sc_hd__decap_3
XFILLER_54_318 VGND VGND VPWR VPWR sky130_fd_sc_hd__decap_3
XFILLER_54_307 VGND VGND VPWR VPWR sky130_fd_sc_hd__fill_1
XFILLER_47_370 VGND VGND VPWR VPWR sky130_fd_sc_hd__decap_3
XFILLER_62_351 VGND VGND VPWR VPWR sky130_fd_sc_hd__decap_3
XFILLER_22_215 VGND VGND VPWR VPWR sky130_fd_sc_hd__decap_3
XFILLER_22_259 VGND VGND VPWR VPWR sky130_fd_sc_hd__decap_3
XFILLER_62_395 VGND VGND VPWR VPWR sky130_fd_sc_hd__decap_3
XFILLER_30_292 VGND VGND VPWR VPWR sky130_fd_sc_hd__decap_3
XFILLER_1_108 VGND VGND VPWR VPWR sky130_fd_sc_hd__decap_3
XFILLER_1_119 VGND VGND VPWR VPWR sky130_fd_sc_hd__decap_3
XFILLER_57_101 VGND VGND VPWR VPWR sky130_fd_sc_hd__decap_3
XFILLER_38_15 VGND VGND VPWR VPWR sky130_fd_sc_hd__decap_3
XFILLER_57_134 VGND VGND VPWR VPWR sky130_fd_sc_hd__decap_3
XFILLER_38_59 VGND VGND VPWR VPWR sky130_fd_sc_hd__decap_3
XFILLER_57_178 VGND VGND VPWR VPWR sky130_fd_sc_hd__decap_3
XFILLER_57_167 VGND VGND VPWR VPWR sky130_fd_sc_hd__fill_1
XFILLER_45_329 VGND VGND VPWR VPWR sky130_fd_sc_hd__decap_3
XFILLER_54_47 VGND VGND VPWR VPWR sky130_fd_sc_hd__decap_3
XFILLER_53_340 VGND VGND VPWR VPWR sky130_fd_sc_hd__decap_3
XFILLER_38_392 VGND VGND VPWR VPWR sky130_fd_sc_hd__decap_3
XFILLER_53_373 VGND VGND VPWR VPWR sky130_fd_sc_hd__decap_3
XPHY_EDGE_ROW_48_Right_69 VGND VGND VPWR VPWR sky130_fd_sc_hd__decap_3
XTAP_TAPCELL_ROW_23_254 VGND VPWR sky130_fd_sc_hd__tapvpwrvgnd_1
XFILLER_21_281 VGND VGND VPWR VPWR sky130_fd_sc_hd__decap_3
XPHY_EDGE_ROW_57_Right_78 VGND VGND VPWR VPWR sky130_fd_sc_hd__decap_3
XFILLER_0_141 VGND VGND VPWR VPWR sky130_fd_sc_hd__decap_3
XFILLER_48_123 VGND VGND VPWR VPWR sky130_fd_sc_hd__decap_3
XFILLER_48_156 VGND VGND VPWR VPWR sky130_fd_sc_hd__decap_3
XFILLER_36_318 VGND VGND VPWR VPWR sky130_fd_sc_hd__decap_3
XFILLER_36_307 VGND VGND VPWR VPWR sky130_fd_sc_hd__fill_1
XFILLER_63_137 VGND VGND VPWR VPWR sky130_fd_sc_hd__decap_3
XFILLER_48_189 VGND VGND VPWR VPWR sky130_fd_sc_hd__decap_3
XFILLER_29_370 VGND VGND VPWR VPWR sky130_fd_sc_hd__decap_3
XFILLER_44_351 VGND VGND VPWR VPWR sky130_fd_sc_hd__decap_3
XFILLER_44_80 VGND VGND VPWR VPWR sky130_fd_sc_hd__decap_3
XFILLER_44_395 VGND VGND VPWR VPWR sky130_fd_sc_hd__decap_3
XFILLER_44_91 VGND VGND VPWR VPWR sky130_fd_sc_hd__fill_1
XFILLER_5_63 VGND VGND VPWR VPWR sky130_fd_sc_hd__fill_2
XFILLER_5_85 VGND VGND VPWR VPWR sky130_fd_sc_hd__decap_3
XFILLER_5_74 VGND VGND VPWR VPWR sky130_fd_sc_hd__fill_1
XFILLER_39_134 VGND VGND VPWR VPWR sky130_fd_sc_hd__decap_3
XFILLER_39_167 VGND VGND VPWR VPWR sky130_fd_sc_hd__fill_1
XFILLER_27_329 VGND VGND VPWR VPWR sky130_fd_sc_hd__decap_3
XFILLER_39_178 VGND VGND VPWR VPWR sky130_fd_sc_hd__decap_3
XTAP_TAPCELL_ROW_37_357 VGND VPWR sky130_fd_sc_hd__tapvpwrvgnd_1
XFILLER_54_159 VGND VGND VPWR VPWR sky130_fd_sc_hd__decap_3
XFILLER_35_340 VGND VGND VPWR VPWR sky130_fd_sc_hd__decap_3
XFILLER_35_373 VGND VGND VPWR VPWR sky130_fd_sc_hd__decap_3
XFILLER_62_192 VGND VGND VPWR VPWR sky130_fd_sc_hd__decap_3
XFILLER_50_321 VGND VGND VPWR VPWR sky130_fd_sc_hd__decap_3
XFILLER_50_365 VGND VGND VPWR VPWR sky130_fd_sc_hd__decap_3
XFILLER_50_354 VGND VGND VPWR VPWR sky130_fd_sc_hd__decap_3
XFILLER_50_398 VGND VGND VPWR VPWR sky130_fd_sc_hd__decap_3
XFILLER_40_27 VGND VGND VPWR VPWR sky130_fd_sc_hd__fill_1
XFILLER_40_38 VGND VGND VPWR VPWR sky130_fd_sc_hd__decap_3
XTAP_TAPCELL_ROW_18_2_579 VGND VPWR sky130_fd_sc_hd__tapvpwrvgnd_1
XTAP_TAPCELL_ROW_8_2_569 VGND VPWR sky130_fd_sc_hd__tapvpwrvgnd_1
XFILLER_49_47 VGND VGND VPWR VPWR sky130_fd_sc_hd__decap_3
XFILLER_45_137 VGND VGND VPWR VPWR sky130_fd_sc_hd__decap_3
XFILLER_26_351 VGND VGND VPWR VPWR sky130_fd_sc_hd__decap_3
XFILLER_60_118 VGND VGND VPWR VPWR sky130_fd_sc_hd__decap_3
XFILLER_26_395 VGND VGND VPWR VPWR sky130_fd_sc_hd__decap_3
XFILLER_53_181 VGND VGND VPWR VPWR sky130_fd_sc_hd__decap_3
XFILLER_41_332 VGND VGND VPWR VPWR sky130_fd_sc_hd__decap_3
XFILLER_41_376 VGND VGND VPWR VPWR sky130_fd_sc_hd__decap_3
XFILLER_41_343 VGND VGND VPWR VPWR sky130_fd_sc_hd__decap_3
X_283_ clknet_2_2__leaf_clk_regs net3 _028_ VGND VGND VPWR VPWR genblk1\[11\].fa_inst.a
+ sky130_fd_sc_hd__dfrtp_1
XFILLER_14_83 VGND VGND VPWR VPWR sky130_fd_sc_hd__fill_1
XFILLER_14_94 VGND VGND VPWR VPWR sky130_fd_sc_hd__decap_3
XFILLER_30_82 VGND VGND VPWR VPWR sky130_fd_sc_hd__fill_2
XFILLER_46_9 VGND VGND VPWR VPWR sky130_fd_sc_hd__decap_3
XFILLER_64_402 VGND VGND VPWR VPWR sky130_fd_sc_hd__fill_1
Xinput9 a[2] VGND VGND VPWR VPWR net9 sky130_fd_sc_hd__clkbuf_1
XFILLER_17_340 VGND VGND VPWR VPWR sky130_fd_sc_hd__decap_3
XFILLER_36_159 VGND VGND VPWR VPWR sky130_fd_sc_hd__decap_3
XFILLER_17_373 VGND VGND VPWR VPWR sky130_fd_sc_hd__decap_3
XFILLER_55_90 VGND VGND VPWR VPWR sky130_fd_sc_hd__decap_3
XFILLER_44_192 VGND VGND VPWR VPWR sky130_fd_sc_hd__decap_3
XFILLER_32_321 VGND VGND VPWR VPWR sky130_fd_sc_hd__decap_3
XFILLER_32_365 VGND VGND VPWR VPWR sky130_fd_sc_hd__decap_3
XFILLER_32_354 VGND VGND VPWR VPWR sky130_fd_sc_hd__decap_3
XFILLER_32_398 VGND VGND VPWR VPWR sky130_fd_sc_hd__decap_3
XFILLER_55_402 VGND VGND VPWR VPWR sky130_fd_sc_hd__decap_3
XFILLER_27_137 VGND VGND VPWR VPWR sky130_fd_sc_hd__decap_3
XFILLER_35_38 VGND VGND VPWR VPWR sky130_fd_sc_hd__decap_3
XFILLER_23_332 VGND VGND VPWR VPWR sky130_fd_sc_hd__decap_3
XFILLER_42_129 VGND VGND VPWR VPWR sky130_fd_sc_hd__decap_3
XFILLER_35_181 VGND VGND VPWR VPWR sky130_fd_sc_hd__decap_3
XFILLER_23_343 VGND VGND VPWR VPWR sky130_fd_sc_hd__decap_3
XFILLER_23_376 VGND VGND VPWR VPWR sky130_fd_sc_hd__decap_3
XFILLER_51_15 VGND VGND VPWR VPWR sky130_fd_sc_hd__decap_3
XFILLER_50_162 VGND VGND VPWR VPWR sky130_fd_sc_hd__decap_3
XFILLER_50_195 VGND VGND VPWR VPWR sky130_fd_sc_hd__fill_1
XFILLER_58_251 VGND VGND VPWR VPWR sky130_fd_sc_hd__fill_1
XFILLER_18_115 VGND VGND VPWR VPWR sky130_fd_sc_hd__decap_3
XFILLER_58_262 VGND VGND VPWR VPWR sky130_fd_sc_hd__decap_3
XFILLER_18_159 VGND VGND VPWR VPWR sky130_fd_sc_hd__decap_3
XFILLER_58_295 VGND VGND VPWR VPWR sky130_fd_sc_hd__decap_3
XFILLER_33_107 VGND VGND VPWR VPWR sky130_fd_sc_hd__decap_3
XTAP_TAPCELL_ROW_56_485 VGND VPWR sky130_fd_sc_hd__tapvpwrvgnd_1
XFILLER_14_343 VGND VGND VPWR VPWR sky130_fd_sc_hd__decap_3
XFILLER_14_354 VGND VGND VPWR VPWR sky130_fd_sc_hd__decap_3
XFILLER_25_60 VGND VGND VPWR VPWR sky130_fd_sc_hd__fill_2
XFILLER_26_192 VGND VGND VPWR VPWR sky130_fd_sc_hd__decap_3
XFILLER_41_140 VGND VGND VPWR VPWR sky130_fd_sc_hd__decap_3
XFILLER_14_387 VGND VGND VPWR VPWR sky130_fd_sc_hd__decap_3
XFILLER_25_82 VGND VGND VPWR VPWR sky130_fd_sc_hd__decap_3
XFILLER_41_184 VGND VGND VPWR VPWR sky130_fd_sc_hd__decap_3
X_266_ clknet_2_3__leaf_clk_regs genblk1\[11\].fa_inst.s _011_ VGND VGND VPWR VPWR
+ net41 sky130_fd_sc_hd__dfrtp_1
X_197_ _105_ _106_ VGND VGND VPWR VPWR _107_ sky130_fd_sc_hd__nand2_1
XFILLER_41_81 VGND VGND VPWR VPWR sky130_fd_sc_hd__decap_3
XFILLER_44_6 VGND VGND VPWR VPWR sky130_fd_sc_hd__decap_3
XFILLER_49_240 VGND VGND VPWR VPWR sky130_fd_sc_hd__decap_3
XFILLER_2_53 VGND VGND VPWR VPWR sky130_fd_sc_hd__decap_3
XFILLER_49_284 VGND VGND VPWR VPWR sky130_fd_sc_hd__decap_3
XFILLER_49_273 VGND VGND VPWR VPWR sky130_fd_sc_hd__decap_3
XFILLER_37_402 VGND VGND VPWR VPWR sky130_fd_sc_hd__fill_1
XFILLER_64_221 VGND VGND VPWR VPWR sky130_fd_sc_hd__decap_3
XFILLER_64_243 VGND VGND VPWR VPWR sky130_fd_sc_hd__decap_3
XFILLER_2_97 VGND VGND VPWR VPWR sky130_fd_sc_hd__decap_3
XFILLER_64_265 VGND VGND VPWR VPWR sky130_fd_sc_hd__decap_3
XTAP_TAPCELL_ROW_17_2_578 VGND VPWR sky130_fd_sc_hd__tapvpwrvgnd_1
XFILLER_24_129 VGND VGND VPWR VPWR sky130_fd_sc_hd__decap_3
XFILLER_64_287 VGND VGND VPWR VPWR sky130_fd_sc_hd__decap_3
XFILLER_20_346 VGND VGND VPWR VPWR sky130_fd_sc_hd__decap_3
XFILLER_20_357 VGND VGND VPWR VPWR sky130_fd_sc_hd__decap_3
XTAP_TAPCELL_ROW_7_2_568 VGND VPWR sky130_fd_sc_hd__tapvpwrvgnd_1
XFILLER_32_184 VGND VGND VPWR VPWR sky130_fd_sc_hd__decap_3
XFILLER_21_18 VGND VGND VPWR VPWR sky130_fd_sc_hd__decap_3
XFILLER_21_29 VGND VGND VPWR VPWR sky130_fd_sc_hd__decap_3
XFILLER_9_391 VGND VGND VPWR VPWR sky130_fd_sc_hd__decap_3
XFILLER_46_15 VGND VGND VPWR VPWR sky130_fd_sc_hd__decap_3
XFILLER_55_243 VGND VGND VPWR VPWR sky130_fd_sc_hd__decap_3
XFILLER_46_59 VGND VGND VPWR VPWR sky130_fd_sc_hd__decap_3
XFILLER_55_276 VGND VGND VPWR VPWR sky130_fd_sc_hd__decap_3
XFILLER_43_405 VGND VGND VPWR VPWR sky130_fd_sc_hd__fill_2
XFILLER_55_287 VGND VGND VPWR VPWR sky130_fd_sc_hd__decap_3
XFILLER_23_140 VGND VGND VPWR VPWR sky130_fd_sc_hd__decap_3
XTAP_TAPCELL_ROW_53_466 VGND VPWR sky130_fd_sc_hd__tapvpwrvgnd_1
XFILLER_62_47 VGND VGND VPWR VPWR sky130_fd_sc_hd__decap_3
XFILLER_11_346 VGND VGND VPWR VPWR sky130_fd_sc_hd__decap_3
XFILLER_23_184 VGND VGND VPWR VPWR sky130_fd_sc_hd__decap_3
XFILLER_11_379 VGND VGND VPWR VPWR sky130_fd_sc_hd__fill_2
XFILLER_11_51 VGND VGND VPWR VPWR sky130_fd_sc_hd__decap_3
XFILLER_11_95 VGND VGND VPWR VPWR sky130_fd_sc_hd__decap_3
XFILLER_46_221 VGND VGND VPWR VPWR sky130_fd_sc_hd__decap_3
XFILLER_61_202 VGND VGND VPWR VPWR sky130_fd_sc_hd__decap_3
XFILLER_46_265 VGND VGND VPWR VPWR sky130_fd_sc_hd__decap_3
XTAP_TAPCELL_ROW_44_400 VGND VPWR sky130_fd_sc_hd__tapvpwrvgnd_1
XFILLER_46_298 VGND VGND VPWR VPWR sky130_fd_sc_hd__decap_3
XFILLER_36_81 VGND VGND VPWR VPWR sky130_fd_sc_hd__decap_3
XFILLER_61_246 VGND VGND VPWR VPWR sky130_fd_sc_hd__decap_3
XFILLER_14_162 VGND VGND VPWR VPWR sky130_fd_sc_hd__decap_3
XFILLER_61_279 VGND VGND VPWR VPWR sky130_fd_sc_hd__fill_1
Xinput12 a[5] VGND VGND VPWR VPWR net12 sky130_fd_sc_hd__clkbuf_1
XFILLER_52_91 VGND VGND VPWR VPWR sky130_fd_sc_hd__decap_3
Xinput23 b[15] VGND VGND VPWR VPWR net23 sky130_fd_sc_hd__clkbuf_1
Xinput34 delay_sel[0] VGND VGND VPWR VPWR net34 sky130_fd_sc_hd__buf_2
X_249_ net60 VGND VGND VPWR VPWR _044_ sky130_fd_sc_hd__inv_2
XFILLER_10_390 VGND VGND VPWR VPWR sky130_fd_sc_hd__decap_3
XFILLER_6_372 VGND VGND VPWR VPWR sky130_fd_sc_hd__decap_3
XFILLER_37_276 VGND VGND VPWR VPWR sky130_fd_sc_hd__decap_3
XFILLER_37_243 VGND VGND VPWR VPWR sky130_fd_sc_hd__decap_3
XFILLER_16_18 VGND VGND VPWR VPWR sky130_fd_sc_hd__decap_3
XFILLER_52_224 VGND VGND VPWR VPWR sky130_fd_sc_hd__decap_3
XFILLER_37_287 VGND VGND VPWR VPWR sky130_fd_sc_hd__decap_3
XFILLER_52_268 VGND VGND VPWR VPWR sky130_fd_sc_hd__decap_3
XFILLER_20_132 VGND VGND VPWR VPWR sky130_fd_sc_hd__decap_3
XTAP_TAPCELL_ROW_50_447 VGND VPWR sky130_fd_sc_hd__tapvpwrvgnd_1
XFILLER_20_165 VGND VGND VPWR VPWR sky130_fd_sc_hd__decap_3
XTAP_TAPCELL_ROW_58_503 VGND VPWR sky130_fd_sc_hd__tapvpwrvgnd_1
XTAP_TAPCELL_ROW_19_1_228 VGND VPWR sky130_fd_sc_hd__tapvpwrvgnd_1
XFILLER_28_221 VGND VGND VPWR VPWR sky130_fd_sc_hd__decap_3
XFILLER_16_405 VGND VGND VPWR VPWR sky130_fd_sc_hd__fill_2
XFILLER_28_265 VGND VGND VPWR VPWR sky130_fd_sc_hd__decap_3
XFILLER_43_202 VGND VGND VPWR VPWR sky130_fd_sc_hd__decap_3
XFILLER_28_298 VGND VGND VPWR VPWR sky130_fd_sc_hd__decap_3
XFILLER_43_246 VGND VGND VPWR VPWR sky130_fd_sc_hd__decap_3
XFILLER_43_279 VGND VGND VPWR VPWR sky130_fd_sc_hd__fill_1
XFILLER_11_110 VGND VGND VPWR VPWR sky130_fd_sc_hd__fill_2
XFILLER_51_290 VGND VGND VPWR VPWR sky130_fd_sc_hd__decap_3
XFILLER_11_143 VGND VGND VPWR VPWR sky130_fd_sc_hd__decap_3
XFILLER_7_103 VGND VGND VPWR VPWR sky130_fd_sc_hd__decap_3
XFILLER_22_50 VGND VGND VPWR VPWR sky130_fd_sc_hd__decap_3
XFILLER_7_125 VGND VGND VPWR VPWR sky130_fd_sc_hd__decap_3
XFILLER_22_72 VGND VGND VPWR VPWR sky130_fd_sc_hd__decap_3
XFILLER_22_94 VGND VGND VPWR VPWR sky130_fd_sc_hd__decap_3
XFILLER_7_158 VGND VGND VPWR VPWR sky130_fd_sc_hd__decap_3
XFILLER_7_169 VGND VGND VPWR VPWR sky130_fd_sc_hd__decap_3
XTAP_TAPCELL_ROW_16_2_577 VGND VPWR sky130_fd_sc_hd__tapvpwrvgnd_1
XFILLER_3_331 VGND VGND VPWR VPWR sky130_fd_sc_hd__decap_3
XFILLER_3_397 VGND VGND VPWR VPWR sky130_fd_sc_hd__decap_3
XFILLER_3_364 VGND VGND VPWR VPWR sky130_fd_sc_hd__decap_3
XTAP_TAPCELL_ROW_6_2_567 VGND VPWR sky130_fd_sc_hd__tapvpwrvgnd_1
XFILLER_34_224 VGND VGND VPWR VPWR sky130_fd_sc_hd__decap_3
XFILLER_34_268 VGND VGND VPWR VPWR sky130_fd_sc_hd__decap_3
XFILLER_63_90 VGND VGND VPWR VPWR sky130_fd_sc_hd__decap_3
XFILLER_8_41 VGND VGND VPWR VPWR sky130_fd_sc_hd__decap_3
XFILLER_8_74 VGND VGND VPWR VPWR sky130_fd_sc_hd__decap_3
XFILLER_8_85 VGND VGND VPWR VPWR sky130_fd_sc_hd__decap_3
XFILLER_57_349 VGND VGND VPWR VPWR sky130_fd_sc_hd__decap_3
XFILLER_25_202 VGND VGND VPWR VPWR sky130_fd_sc_hd__decap_3
XFILLER_25_246 VGND VGND VPWR VPWR sky130_fd_sc_hd__decap_3
XFILLER_25_279 VGND VGND VPWR VPWR sky130_fd_sc_hd__fill_1
XFILLER_40_227 VGND VGND VPWR VPWR sky130_fd_sc_hd__decap_3
XFILLER_33_290 VGND VGND VPWR VPWR sky130_fd_sc_hd__decap_3
XFILLER_4_139 VGND VGND VPWR VPWR sky130_fd_sc_hd__fill_1
XFILLER_0_334 VGND VGND VPWR VPWR sky130_fd_sc_hd__decap_3
XFILLER_0_378 VGND VGND VPWR VPWR sky130_fd_sc_hd__decap_3
XFILLER_48_327 VGND VGND VPWR VPWR sky130_fd_sc_hd__decap_3
XFILLER_63_308 VGND VGND VPWR VPWR sky130_fd_sc_hd__decap_3
XFILLER_17_50 VGND VGND VPWR VPWR sky130_fd_sc_hd__decap_3
XFILLER_56_371 VGND VGND VPWR VPWR sky130_fd_sc_hd__decap_3
XFILLER_56_360 VGND VGND VPWR VPWR sky130_fd_sc_hd__decap_3
XFILLER_17_94 VGND VGND VPWR VPWR sky130_fd_sc_hd__decap_3
XFILLER_31_205 VGND VGND VPWR VPWR sky130_fd_sc_hd__decap_3
XTAP_TAPCELL_ROW_26_274 VGND VPWR sky130_fd_sc_hd__tapvpwrvgnd_1
XFILLER_31_249 VGND VGND VPWR VPWR sky130_fd_sc_hd__decap_3
XFILLER_33_60 VGND VGND VPWR VPWR sky130_fd_sc_hd__decap_3
XFILLER_3_172 VGND VGND VPWR VPWR sky130_fd_sc_hd__decap_3
XFILLER_3_161 VGND VGND VPWR VPWR sky130_fd_sc_hd__decap_3
XFILLER_39_305 VGND VGND VPWR VPWR sky130_fd_sc_hd__decap_3
Xhold1 cin_q VGND VGND VPWR VPWR net75 sky130_fd_sc_hd__dlygate4sd3_1
XFILLER_39_349 VGND VGND VPWR VPWR sky130_fd_sc_hd__decap_3
XFILLER_47_382 VGND VGND VPWR VPWR sky130_fd_sc_hd__decap_3
XFILLER_62_330 VGND VGND VPWR VPWR sky130_fd_sc_hd__decap_3
XFILLER_47_393 VGND VGND VPWR VPWR sky130_fd_sc_hd__decap_3
XFILLER_62_363 VGND VGND VPWR VPWR sky130_fd_sc_hd__fill_1
XFILLER_62_374 VGND VGND VPWR VPWR sky130_fd_sc_hd__decap_3
XFILLER_22_238 VGND VGND VPWR VPWR sky130_fd_sc_hd__decap_3
XFILLER_30_271 VGND VGND VPWR VPWR sky130_fd_sc_hd__decap_3
XFILLER_38_27 VGND VGND VPWR VPWR sky130_fd_sc_hd__fill_1
XFILLER_57_113 VGND VGND VPWR VPWR sky130_fd_sc_hd__decap_3
XFILLER_38_38 VGND VGND VPWR VPWR sky130_fd_sc_hd__decap_3
XFILLER_57_146 VGND VGND VPWR VPWR sky130_fd_sc_hd__decap_3
XFILLER_45_308 VGND VGND VPWR VPWR sky130_fd_sc_hd__decap_3
XFILLER_38_371 VGND VGND VPWR VPWR sky130_fd_sc_hd__decap_3
XFILLER_38_360 VGND VGND VPWR VPWR sky130_fd_sc_hd__decap_3
XFILLER_54_15 VGND VGND VPWR VPWR sky130_fd_sc_hd__decap_3
XTAP_TAPCELL_ROW_15_2_576 VGND VPWR sky130_fd_sc_hd__tapvpwrvgnd_1
XFILLER_54_59 VGND VGND VPWR VPWR sky130_fd_sc_hd__decap_3
XFILLER_53_352 VGND VGND VPWR VPWR sky130_fd_sc_hd__decap_3
XFILLER_53_396 VGND VGND VPWR VPWR sky130_fd_sc_hd__decap_3
XFILLER_53_385 VGND VGND VPWR VPWR sky130_fd_sc_hd__decap_3
XTAP_TAPCELL_ROW_23_255 VGND VPWR sky130_fd_sc_hd__tapvpwrvgnd_1
XTAP_TAPCELL_ROW_5_2_566 VGND VPWR sky130_fd_sc_hd__tapvpwrvgnd_1
XFILLER_21_293 VGND VGND VPWR VPWR sky130_fd_sc_hd__decap_3
XFILLER_0_131 VGND VGND VPWR VPWR sky130_fd_sc_hd__decap_3
XFILLER_0_153 VGND VGND VPWR VPWR sky130_fd_sc_hd__decap_3
XFILLER_48_135 VGND VGND VPWR VPWR sky130_fd_sc_hd__decap_3
XFILLER_48_168 VGND VGND VPWR VPWR sky130_fd_sc_hd__decap_3
XFILLER_63_105 VGND VGND VPWR VPWR sky130_fd_sc_hd__decap_3
XFILLER_63_116 VGND VGND VPWR VPWR sky130_fd_sc_hd__decap_3
XFILLER_29_382 VGND VGND VPWR VPWR sky130_fd_sc_hd__decap_3
XFILLER_28_60 VGND VGND VPWR VPWR sky130_fd_sc_hd__decap_3
XFILLER_63_149 VGND VGND VPWR VPWR sky130_fd_sc_hd__decap_3
XFILLER_44_330 VGND VGND VPWR VPWR sky130_fd_sc_hd__decap_3
XFILLER_29_393 VGND VGND VPWR VPWR sky130_fd_sc_hd__decap_3
XFILLER_44_374 VGND VGND VPWR VPWR sky130_fd_sc_hd__decap_3
XFILLER_44_363 VGND VGND VPWR VPWR sky130_fd_sc_hd__fill_1
XFILLER_60_91 VGND VGND VPWR VPWR sky130_fd_sc_hd__decap_3
XFILLER_60_80 VGND VGND VPWR VPWR sky130_fd_sc_hd__decap_3
XTAP_TAPCELL_ROW_14_1_211 VGND VPWR sky130_fd_sc_hd__tapvpwrvgnd_1
XFILLER_5_97 VGND VGND VPWR VPWR sky130_fd_sc_hd__decap_3
XFILLER_39_113 VGND VGND VPWR VPWR sky130_fd_sc_hd__decap_3
XFILLER_39_102 VGND VGND VPWR VPWR sky130_fd_sc_hd__decap_3
XFILLER_27_308 VGND VGND VPWR VPWR sky130_fd_sc_hd__decap_3
XFILLER_39_146 VGND VGND VPWR VPWR sky130_fd_sc_hd__decap_3
XFILLER_54_127 VGND VGND VPWR VPWR sky130_fd_sc_hd__decap_3
XFILLER_47_190 VGND VGND VPWR VPWR sky130_fd_sc_hd__decap_3
XFILLER_35_352 VGND VGND VPWR VPWR sky130_fd_sc_hd__decap_3
XFILLER_24_18 VGND VGND VPWR VPWR sky130_fd_sc_hd__decap_3
XFILLER_62_171 VGND VGND VPWR VPWR sky130_fd_sc_hd__decap_3
XFILLER_50_333 VGND VGND VPWR VPWR sky130_fd_sc_hd__decap_3
XFILLER_35_396 VGND VGND VPWR VPWR sky130_fd_sc_hd__decap_3
XFILLER_35_385 VGND VGND VPWR VPWR sky130_fd_sc_hd__decap_3
XFILLER_50_377 VGND VGND VPWR VPWR sky130_fd_sc_hd__decap_3
XPHY_EDGE_ROW_28_Left_134 VGND VGND VPWR VPWR sky130_fd_sc_hd__decap_3
XFILLER_6_9 VGND VGND VPWR VPWR sky130_fd_sc_hd__decap_3
XPHY_EDGE_ROW_37_Left_143 VGND VGND VPWR VPWR sky130_fd_sc_hd__decap_3
XFILLER_45_116 VGND VGND VPWR VPWR sky130_fd_sc_hd__decap_3
XFILLER_26_330 VGND VGND VPWR VPWR sky130_fd_sc_hd__decap_3
XFILLER_45_149 VGND VGND VPWR VPWR sky130_fd_sc_hd__decap_3
XFILLER_26_363 VGND VGND VPWR VPWR sky130_fd_sc_hd__fill_1
XFILLER_26_374 VGND VGND VPWR VPWR sky130_fd_sc_hd__decap_3
XFILLER_53_193 VGND VGND VPWR VPWR sky130_fd_sc_hd__decap_3
XFILLER_41_311 VGND VGND VPWR VPWR sky130_fd_sc_hd__decap_3
XFILLER_41_355 VGND VGND VPWR VPWR sky130_fd_sc_hd__decap_3
XPHY_EDGE_ROW_46_Left_152 VGND VGND VPWR VPWR sky130_fd_sc_hd__decap_3
X_282_ clknet_2_2__leaf_clk_regs net2 _027_ VGND VGND VPWR VPWR genblk1\[10\].fa_inst.a
+ sky130_fd_sc_hd__dfrtp_1
XFILLER_41_399 VGND VGND VPWR VPWR sky130_fd_sc_hd__decap_3
XFILLER_41_388 VGND VGND VPWR VPWR sky130_fd_sc_hd__decap_3
XFILLER_30_50 VGND VGND VPWR VPWR sky130_fd_sc_hd__decap_3
XFILLER_30_94 VGND VGND VPWR VPWR sky130_fd_sc_hd__decap_3
XPHY_EDGE_ROW_55_Left_161 VGND VGND VPWR VPWR sky130_fd_sc_hd__decap_3
XFILLER_39_9 VGND VGND VPWR VPWR sky130_fd_sc_hd__decap_3
XFILLER_36_127 VGND VGND VPWR VPWR sky130_fd_sc_hd__decap_3
XFILLER_29_190 VGND VGND VPWR VPWR sky130_fd_sc_hd__decap_3
XFILLER_17_352 VGND VGND VPWR VPWR sky130_fd_sc_hd__decap_3
XFILLER_51_119 VGND VGND VPWR VPWR sky130_fd_sc_hd__decap_3
XFILLER_17_385 VGND VGND VPWR VPWR sky130_fd_sc_hd__decap_3
XFILLER_44_171 VGND VGND VPWR VPWR sky130_fd_sc_hd__decap_3
XPHY_EDGE_ROW_64_Left_170 VGND VGND VPWR VPWR sky130_fd_sc_hd__decap_3
XFILLER_32_333 VGND VGND VPWR VPWR sky130_fd_sc_hd__decap_3
XFILLER_32_377 VGND VGND VPWR VPWR sky130_fd_sc_hd__decap_3
XTAP_TAPCELL_ROW_14_2_575 VGND VPWR sky130_fd_sc_hd__tapvpwrvgnd_1
XFILLER_59_208 VGND VGND VPWR VPWR sky130_fd_sc_hd__decap_3
XFILLER_27_105 VGND VGND VPWR VPWR sky130_fd_sc_hd__decap_3
XFILLER_27_116 VGND VGND VPWR VPWR sky130_fd_sc_hd__decap_3
XTAP_TAPCELL_ROW_4_2_565 VGND VPWR sky130_fd_sc_hd__tapvpwrvgnd_1
XFILLER_27_149 VGND VGND VPWR VPWR sky130_fd_sc_hd__decap_3
XFILLER_42_108 VGND VGND VPWR VPWR sky130_fd_sc_hd__decap_3
XFILLER_23_311 VGND VGND VPWR VPWR sky130_fd_sc_hd__decap_3
XFILLER_23_355 VGND VGND VPWR VPWR sky130_fd_sc_hd__decap_3
XFILLER_50_141 VGND VGND VPWR VPWR sky130_fd_sc_hd__decap_3
XFILLER_50_130 VGND VGND VPWR VPWR sky130_fd_sc_hd__decap_3
XFILLER_35_193 VGND VGND VPWR VPWR sky130_fd_sc_hd__decap_3
XFILLER_23_388 VGND VGND VPWR VPWR sky130_fd_sc_hd__decap_3
XFILLER_23_399 VGND VGND VPWR VPWR sky130_fd_sc_hd__decap_3
XFILLER_50_174 VGND VGND VPWR VPWR sky130_fd_sc_hd__decap_3
XFILLER_51_49 VGND VGND VPWR VPWR sky130_fd_sc_hd__decap_3
XFILLER_4_6 VGND VGND VPWR VPWR sky130_fd_sc_hd__fill_2
XFILLER_58_230 VGND VGND VPWR VPWR sky130_fd_sc_hd__decap_3
XFILLER_58_274 VGND VGND VPWR VPWR sky130_fd_sc_hd__decap_3
XFILLER_18_127 VGND VGND VPWR VPWR sky130_fd_sc_hd__decap_3
XFILLER_26_171 VGND VGND VPWR VPWR sky130_fd_sc_hd__decap_3
XTAP_TAPCELL_ROW_13_1_210 VGND VPWR sky130_fd_sc_hd__tapvpwrvgnd_1
XTAP_TAPCELL_ROW_56_486 VGND VPWR sky130_fd_sc_hd__tapvpwrvgnd_1
XFILLER_33_119 VGND VGND VPWR VPWR sky130_fd_sc_hd__decap_3
XFILLER_14_366 VGND VGND VPWR VPWR sky130_fd_sc_hd__decap_3
XFILLER_14_399 VGND VGND VPWR VPWR sky130_fd_sc_hd__decap_3
XFILLER_25_94 VGND VGND VPWR VPWR sky130_fd_sc_hd__decap_3
XTAP_TAPCELL_ROW_31_309 VGND VPWR sky130_fd_sc_hd__tapvpwrvgnd_1
XFILLER_41_152 VGND VGND VPWR VPWR sky130_fd_sc_hd__decap_3
X_265_ clknet_2_3__leaf_clk_regs genblk1\[10\].fa_inst.s _010_ VGND VGND VPWR VPWR
+ net40 sky130_fd_sc_hd__dfrtp_1
XFILLER_41_196 VGND VGND VPWR VPWR sky130_fd_sc_hd__decap_3
X_196_ genblk1\[14\].fa_inst.b genblk1\[14\].fa_inst.a VGND VGND VPWR VPWR _106_ sky130_fd_sc_hd__nand2_1
XFILLER_41_93 VGND VGND VPWR VPWR sky130_fd_sc_hd__decap_3
XFILLER_37_6 VGND VGND VPWR VPWR sky130_fd_sc_hd__decap_3
XFILLER_2_32 VGND VGND VPWR VPWR sky130_fd_sc_hd__decap_3
XFILLER_2_21 VGND VGND VPWR VPWR sky130_fd_sc_hd__decap_3
XFILLER_64_200 VGND VGND VPWR VPWR sky130_fd_sc_hd__decap_3
XFILLER_49_252 VGND VGND VPWR VPWR sky130_fd_sc_hd__decap_3
XFILLER_2_65 VGND VGND VPWR VPWR sky130_fd_sc_hd__decap_3
XFILLER_49_296 VGND VGND VPWR VPWR sky130_fd_sc_hd__decap_3
XFILLER_64_277 VGND VGND VPWR VPWR sky130_fd_sc_hd__decap_3
XTAP_TAPCELL_ROW_0_2_560 VGND VPWR sky130_fd_sc_hd__tapvpwrvgnd_1
XFILLER_64_299 VGND VGND VPWR VPWR sky130_fd_sc_hd__decap_3
XFILLER_32_141 VGND VGND VPWR VPWR sky130_fd_sc_hd__decap_3
XFILLER_20_369 VGND VGND VPWR VPWR sky130_fd_sc_hd__decap_3
XFILLER_9_370 VGND VGND VPWR VPWR sky130_fd_sc_hd__decap_3
XFILLER_55_211 VGND VGND VPWR VPWR sky130_fd_sc_hd__decap_3
XFILLER_46_38 VGND VGND VPWR VPWR sky130_fd_sc_hd__decap_3
XFILLER_46_27 VGND VGND VPWR VPWR sky130_fd_sc_hd__fill_1
XFILLER_15_108 VGND VGND VPWR VPWR sky130_fd_sc_hd__decap_3
XFILLER_55_255 VGND VGND VPWR VPWR sky130_fd_sc_hd__decap_3
XFILLER_15_119 VGND VGND VPWR VPWR sky130_fd_sc_hd__decap_3
XFILLER_55_299 VGND VGND VPWR VPWR sky130_fd_sc_hd__decap_3
XFILLER_62_15 VGND VGND VPWR VPWR sky130_fd_sc_hd__decap_3
XFILLER_23_152 VGND VGND VPWR VPWR sky130_fd_sc_hd__decap_3
XFILLER_62_59 VGND VGND VPWR VPWR sky130_fd_sc_hd__decap_3
XTAP_TAPCELL_ROW_53_467 VGND VPWR sky130_fd_sc_hd__tapvpwrvgnd_1
XFILLER_23_196 VGND VGND VPWR VPWR sky130_fd_sc_hd__decap_3
XFILLER_11_358 VGND VGND VPWR VPWR sky130_fd_sc_hd__decap_3
XFILLER_11_30 VGND VGND VPWR VPWR sky130_fd_sc_hd__decap_3
XFILLER_11_74 VGND VGND VPWR VPWR sky130_fd_sc_hd__decap_3
XFILLER_19_403 VGND VGND VPWR VPWR sky130_fd_sc_hd__decap_3
XFILLER_46_200 VGND VGND VPWR VPWR sky130_fd_sc_hd__decap_3
XFILLER_46_233 VGND VGND VPWR VPWR sky130_fd_sc_hd__decap_3
XTAP_TAPCELL_ROW_44_401 VGND VPWR sky130_fd_sc_hd__tapvpwrvgnd_1
XFILLER_61_225 VGND VGND VPWR VPWR sky130_fd_sc_hd__decap_3
XFILLER_61_214 VGND VGND VPWR VPWR sky130_fd_sc_hd__decap_3
XFILLER_46_277 VGND VGND VPWR VPWR sky130_fd_sc_hd__decap_3
XFILLER_36_60 VGND VGND VPWR VPWR sky130_fd_sc_hd__decap_3
XFILLER_14_130 VGND VGND VPWR VPWR sky130_fd_sc_hd__decap_3
XFILLER_61_258 VGND VGND VPWR VPWR sky130_fd_sc_hd__decap_3
XFILLER_14_141 VGND VGND VPWR VPWR sky130_fd_sc_hd__decap_3
XTAP_TAPCELL_ROW_13_2_574 VGND VPWR sky130_fd_sc_hd__tapvpwrvgnd_1
XFILLER_14_174 VGND VGND VPWR VPWR sky130_fd_sc_hd__decap_3
Xinput13 a[6] VGND VGND VPWR VPWR net13 sky130_fd_sc_hd__clkbuf_1
XFILLER_52_81 VGND VGND VPWR VPWR sky130_fd_sc_hd__decap_3
XTAP_TAPCELL_ROW_3_2_564 VGND VPWR sky130_fd_sc_hd__tapvpwrvgnd_1
Xinput24 b[1] VGND VGND VPWR VPWR net24 sky130_fd_sc_hd__buf_1
Xinput35 delay_sel[1] VGND VGND VPWR VPWR net35 sky130_fd_sc_hd__buf_2
X_248_ net59 VGND VGND VPWR VPWR _043_ sky130_fd_sc_hd__inv_2
XFILLER_6_340 VGND VGND VPWR VPWR sky130_fd_sc_hd__decap_3
X_179_ _091_ _092_ VGND VGND VPWR VPWR genblk1\[10\].fa_inst.s sky130_fd_sc_hd__xnor2_1
XFILLER_6_384 VGND VGND VPWR VPWR sky130_fd_sc_hd__decap_3
XFILLER_35_3 VGND VGND VPWR VPWR sky130_fd_sc_hd__decap_3
XFILLER_37_211 VGND VGND VPWR VPWR sky130_fd_sc_hd__decap_3
XFILLER_37_255 VGND VGND VPWR VPWR sky130_fd_sc_hd__decap_3
XFILLER_52_203 VGND VGND VPWR VPWR sky130_fd_sc_hd__decap_3
XFILLER_37_299 VGND VGND VPWR VPWR sky130_fd_sc_hd__decap_3
XFILLER_52_236 VGND VGND VPWR VPWR sky130_fd_sc_hd__decap_3
XPHY_EDGE_ROW_9_2_Left_30 VGND VGND VPWR VPWR sky130_fd_sc_hd__decap_3
XTAP_TAPCELL_ROW_50_448 VGND VPWR sky130_fd_sc_hd__tapvpwrvgnd_1
XFILLER_60_280 VGND VGND VPWR VPWR sky130_fd_sc_hd__decap_3
XFILLER_32_18 VGND VGND VPWR VPWR sky130_fd_sc_hd__decap_3
XFILLER_20_144 VGND VGND VPWR VPWR sky130_fd_sc_hd__decap_3
XFILLER_20_177 VGND VGND VPWR VPWR sky130_fd_sc_hd__decap_3
XFILLER_57_15 VGND VGND VPWR VPWR sky130_fd_sc_hd__fill_2
XTAP_TAPCELL_ROW_58_504 VGND VPWR sky130_fd_sc_hd__tapvpwrvgnd_1
XFILLER_57_37 VGND VGND VPWR VPWR sky130_fd_sc_hd__decap_3
XFILLER_28_200 VGND VGND VPWR VPWR sky130_fd_sc_hd__decap_3
XFILLER_28_233 VGND VGND VPWR VPWR sky130_fd_sc_hd__decap_3
XFILLER_43_225 VGND VGND VPWR VPWR sky130_fd_sc_hd__decap_3
XFILLER_43_214 VGND VGND VPWR VPWR sky130_fd_sc_hd__decap_3
XFILLER_28_277 VGND VGND VPWR VPWR sky130_fd_sc_hd__decap_3
XFILLER_43_258 VGND VGND VPWR VPWR sky130_fd_sc_hd__decap_3
XFILLER_11_122 VGND VGND VPWR VPWR sky130_fd_sc_hd__decap_3
XFILLER_11_155 VGND VGND VPWR VPWR sky130_fd_sc_hd__decap_3
XPHY_EDGE_ROW_9_1_Right_8 VGND VGND VPWR VPWR sky130_fd_sc_hd__decap_3
XFILLER_7_137 VGND VGND VPWR VPWR sky130_fd_sc_hd__decap_3
XFILLER_3_343 VGND VGND VPWR VPWR sky130_fd_sc_hd__decap_3
XFILLER_3_376 VGND VGND VPWR VPWR sky130_fd_sc_hd__decap_3
XFILLER_21_9 VGND VGND VPWR VPWR sky130_fd_sc_hd__decap_3
XFILLER_59_391 VGND VGND VPWR VPWR sky130_fd_sc_hd__fill_1
XFILLER_47_81 VGND VGND VPWR VPWR sky130_fd_sc_hd__decap_3
XFILLER_34_203 VGND VGND VPWR VPWR sky130_fd_sc_hd__decap_3
XFILLER_34_236 VGND VGND VPWR VPWR sky130_fd_sc_hd__decap_3
XFILLER_42_280 VGND VGND VPWR VPWR sky130_fd_sc_hd__decap_3
XFILLER_8_97 VGND VGND VPWR VPWR sky130_fd_sc_hd__decap_3
XFILLER_57_317 VGND VGND VPWR VPWR sky130_fd_sc_hd__decap_3
XFILLER_25_214 VGND VGND VPWR VPWR sky130_fd_sc_hd__decap_3
XFILLER_25_225 VGND VGND VPWR VPWR sky130_fd_sc_hd__decap_3
XFILLER_25_258 VGND VGND VPWR VPWR sky130_fd_sc_hd__decap_3
XFILLER_40_206 VGND VGND VPWR VPWR sky130_fd_sc_hd__decap_3
XFILLER_40_239 VGND VGND VPWR VPWR sky130_fd_sc_hd__decap_3
XFILLER_4_118 VGND VGND VPWR VPWR sky130_fd_sc_hd__decap_3
XFILLER_0_346 VGND VGND VPWR VPWR sky130_fd_sc_hd__decap_3
XTAP_TAPCELL_ROW_12_2_573 VGND VPWR sky130_fd_sc_hd__tapvpwrvgnd_1
XFILLER_0_357 VGND VGND VPWR VPWR sky130_fd_sc_hd__decap_3
XFILLER_48_339 VGND VGND VPWR VPWR sky130_fd_sc_hd__decap_3
XTAP_TAPCELL_ROW_2_2_563 VGND VPWR sky130_fd_sc_hd__tapvpwrvgnd_1
XFILLER_56_383 VGND VGND VPWR VPWR sky130_fd_sc_hd__decap_3
XFILLER_17_73 VGND VGND VPWR VPWR sky130_fd_sc_hd__decap_3
XFILLER_31_217 VGND VGND VPWR VPWR sky130_fd_sc_hd__decap_3
XFILLER_24_280 VGND VGND VPWR VPWR sky130_fd_sc_hd__decap_3
XTAP_TAPCELL_ROW_26_275 VGND VPWR sky130_fd_sc_hd__tapvpwrvgnd_1
XFILLER_31_228 VGND VGND VPWR VPWR sky130_fd_sc_hd__decap_3
XFILLER_8_402 VGND VGND VPWR VPWR sky130_fd_sc_hd__decap_3
XFILLER_33_83 VGND VGND VPWR VPWR sky130_fd_sc_hd__decap_3
XFILLER_3_140 VGND VGND VPWR VPWR sky130_fd_sc_hd__decap_3
XFILLER_39_317 VGND VGND VPWR VPWR sky130_fd_sc_hd__decap_3
XFILLER_58_91 VGND VGND VPWR VPWR sky130_fd_sc_hd__decap_3
XFILLER_54_309 VGND VGND VPWR VPWR sky130_fd_sc_hd__decap_3
XPHY_EDGE_ROW_12_1_Right_11 VGND VGND VPWR VPWR sky130_fd_sc_hd__decap_3
XFILLER_47_361 VGND VGND VPWR VPWR sky130_fd_sc_hd__decap_3
XFILLER_62_342 VGND VGND VPWR VPWR sky130_fd_sc_hd__decap_3
XFILLER_22_206 VGND VGND VPWR VPWR sky130_fd_sc_hd__decap_3
XFILLER_62_386 VGND VGND VPWR VPWR sky130_fd_sc_hd__decap_3
XFILLER_30_283 VGND VGND VPWR VPWR sky130_fd_sc_hd__decap_3
XFILLER_57_125 VGND VGND VPWR VPWR sky130_fd_sc_hd__decap_3
XFILLER_57_169 VGND VGND VPWR VPWR sky130_fd_sc_hd__decap_3
XFILLER_57_158 VGND VGND VPWR VPWR sky130_fd_sc_hd__decap_3
XFILLER_54_38 VGND VGND VPWR VPWR sky130_fd_sc_hd__decap_3
XFILLER_54_27 VGND VGND VPWR VPWR sky130_fd_sc_hd__fill_1
XFILLER_53_320 VGND VGND VPWR VPWR sky130_fd_sc_hd__decap_3
XFILLER_38_383 VGND VGND VPWR VPWR sky130_fd_sc_hd__decap_3
XFILLER_53_364 VGND VGND VPWR VPWR sky130_fd_sc_hd__decap_3
XFILLER_21_272 VGND VGND VPWR VPWR sky130_fd_sc_hd__decap_3
XTAP_TAPCELL_ROW_23_256 VGND VPWR sky130_fd_sc_hd__tapvpwrvgnd_1
XFILLER_0_165 VGND VGND VPWR VPWR sky130_fd_sc_hd__decap_3
XFILLER_48_147 VGND VGND VPWR VPWR sky130_fd_sc_hd__decap_3
XFILLER_36_309 VGND VGND VPWR VPWR sky130_fd_sc_hd__decap_3
XFILLER_63_128 VGND VGND VPWR VPWR sky130_fd_sc_hd__decap_3
XFILLER_29_361 VGND VGND VPWR VPWR sky130_fd_sc_hd__decap_3
XFILLER_28_83 VGND VGND VPWR VPWR sky130_fd_sc_hd__fill_1
XFILLER_56_180 VGND VGND VPWR VPWR sky130_fd_sc_hd__decap_3
XFILLER_44_342 VGND VGND VPWR VPWR sky130_fd_sc_hd__decap_3
XFILLER_44_386 VGND VGND VPWR VPWR sky130_fd_sc_hd__decap_3
XTAP_TAPCELL_ROW_14_1_212 VGND VPWR sky130_fd_sc_hd__tapvpwrvgnd_1
XFILLER_39_125 VGND VGND VPWR VPWR sky130_fd_sc_hd__decap_3
XFILLER_39_158 VGND VGND VPWR VPWR sky130_fd_sc_hd__decap_3
XFILLER_39_169 VGND VGND VPWR VPWR sky130_fd_sc_hd__decap_3
XFILLER_54_139 VGND VGND VPWR VPWR sky130_fd_sc_hd__fill_1
XFILLER_35_320 VGND VGND VPWR VPWR sky130_fd_sc_hd__decap_3
XFILLER_62_150 VGND VGND VPWR VPWR sky130_fd_sc_hd__decap_3
XFILLER_35_364 VGND VGND VPWR VPWR sky130_fd_sc_hd__decap_3
XFILLER_62_183 VGND VGND VPWR VPWR sky130_fd_sc_hd__decap_3
XFILLER_50_312 VGND VGND VPWR VPWR sky130_fd_sc_hd__decap_3
XFILLER_50_301 VGND VGND VPWR VPWR sky130_fd_sc_hd__decap_3
XFILLER_50_345 VGND VGND VPWR VPWR sky130_fd_sc_hd__decap_3
XTAP_TAPCELL_ROW_11_2_572 VGND VPWR sky130_fd_sc_hd__tapvpwrvgnd_1
XFILLER_50_389 VGND VGND VPWR VPWR sky130_fd_sc_hd__decap_3
XFILLER_40_18 VGND VGND VPWR VPWR sky130_fd_sc_hd__decap_3
XFILLER_40_29 VGND VGND VPWR VPWR sky130_fd_sc_hd__decap_3
XTAP_TAPCELL_ROW_1_2_562 VGND VPWR sky130_fd_sc_hd__tapvpwrvgnd_1
XFILLER_49_38 VGND VGND VPWR VPWR sky130_fd_sc_hd__decap_3
XFILLER_58_401 VGND VGND VPWR VPWR sky130_fd_sc_hd__decap_3
XFILLER_45_106 VGND VGND VPWR VPWR sky130_fd_sc_hd__decap_3
XFILLER_45_128 VGND VGND VPWR VPWR sky130_fd_sc_hd__decap_3
XFILLER_38_180 VGND VGND VPWR VPWR sky130_fd_sc_hd__decap_3
XFILLER_26_342 VGND VGND VPWR VPWR sky130_fd_sc_hd__decap_3
XFILLER_60_109 VGND VGND VPWR VPWR sky130_fd_sc_hd__decap_3
XFILLER_26_386 VGND VGND VPWR VPWR sky130_fd_sc_hd__decap_3
XFILLER_53_172 VGND VGND VPWR VPWR sky130_fd_sc_hd__decap_3
XFILLER_53_161 VGND VGND VPWR VPWR sky130_fd_sc_hd__decap_3
XFILLER_41_323 VGND VGND VPWR VPWR sky130_fd_sc_hd__decap_3
XFILLER_41_367 VGND VGND VPWR VPWR sky130_fd_sc_hd__decap_3
XFILLER_14_41 VGND VGND VPWR VPWR sky130_fd_sc_hd__decap_3
X_281_ clknet_2_2__leaf_clk_regs net16 _026_ VGND VGND VPWR VPWR genblk1\[9\].fa_inst.a
+ sky130_fd_sc_hd__dfrtp_1
XFILLER_14_74 VGND VGND VPWR VPWR sky130_fd_sc_hd__decap_3
XFILLER_14_85 VGND VGND VPWR VPWR sky130_fd_sc_hd__decap_3
XFILLER_30_73 VGND VGND VPWR VPWR sky130_fd_sc_hd__decap_3
XFILLER_39_60 VGND VGND VPWR VPWR sky130_fd_sc_hd__decap_3
XFILLER_39_93 VGND VGND VPWR VPWR sky130_fd_sc_hd__decap_3
XFILLER_17_331 VGND VGND VPWR VPWR sky130_fd_sc_hd__decap_3
XFILLER_36_139 VGND VGND VPWR VPWR sky130_fd_sc_hd__fill_1
XFILLER_17_364 VGND VGND VPWR VPWR sky130_fd_sc_hd__decap_3
XFILLER_55_81 VGND VGND VPWR VPWR sky130_fd_sc_hd__decap_3
XFILLER_44_150 VGND VGND VPWR VPWR sky130_fd_sc_hd__decap_3
XFILLER_17_397 VGND VGND VPWR VPWR sky130_fd_sc_hd__decap_3
XFILLER_44_183 VGND VGND VPWR VPWR sky130_fd_sc_hd__decap_3
XFILLER_32_312 VGND VGND VPWR VPWR sky130_fd_sc_hd__decap_3
XFILLER_32_301 VGND VGND VPWR VPWR sky130_fd_sc_hd__decap_3
XFILLER_32_345 VGND VGND VPWR VPWR sky130_fd_sc_hd__decap_3
XFILLER_32_389 VGND VGND VPWR VPWR sky130_fd_sc_hd__decap_3
XFILLER_27_128 VGND VGND VPWR VPWR sky130_fd_sc_hd__decap_3
XFILLER_23_323 VGND VGND VPWR VPWR sky130_fd_sc_hd__decap_3
XFILLER_35_172 VGND VGND VPWR VPWR sky130_fd_sc_hd__decap_3
XFILLER_35_161 VGND VGND VPWR VPWR sky130_fd_sc_hd__decap_3
XFILLER_23_367 VGND VGND VPWR VPWR sky130_fd_sc_hd__decap_3
XFILLER_50_153 VGND VGND VPWR VPWR sky130_fd_sc_hd__decap_3
XFILLER_50_197 VGND VGND VPWR VPWR sky130_fd_sc_hd__decap_3
XFILLER_50_186 VGND VGND VPWR VPWR sky130_fd_sc_hd__decap_3
XFILLER_58_242 VGND VGND VPWR VPWR sky130_fd_sc_hd__decap_3
XFILLER_18_106 VGND VGND VPWR VPWR sky130_fd_sc_hd__decap_3
XFILLER_58_253 VGND VGND VPWR VPWR sky130_fd_sc_hd__decap_3
XFILLER_46_404 VGND VGND VPWR VPWR sky130_fd_sc_hd__decap_3
XFILLER_18_139 VGND VGND VPWR VPWR sky130_fd_sc_hd__fill_1
XFILLER_58_286 VGND VGND VPWR VPWR sky130_fd_sc_hd__decap_3
XFILLER_26_150 VGND VGND VPWR VPWR sky130_fd_sc_hd__decap_3
XTAP_TAPCELL_ROW_56_487 VGND VPWR sky130_fd_sc_hd__tapvpwrvgnd_1
XFILLER_14_334 VGND VGND VPWR VPWR sky130_fd_sc_hd__decap_3
XFILLER_25_51 VGND VGND VPWR VPWR sky130_fd_sc_hd__decap_3
XFILLER_26_183 VGND VGND VPWR VPWR sky130_fd_sc_hd__decap_3
XFILLER_41_131 VGND VGND VPWR VPWR sky130_fd_sc_hd__decap_3
XFILLER_14_378 VGND VGND VPWR VPWR sky130_fd_sc_hd__decap_3
XFILLER_25_73 VGND VGND VPWR VPWR sky130_fd_sc_hd__decap_3
XFILLER_41_175 VGND VGND VPWR VPWR sky130_fd_sc_hd__decap_3
XFILLER_41_164 VGND VGND VPWR VPWR sky130_fd_sc_hd__decap_3
X_264_ clknet_2_2__leaf_clk_regs genblk1\[9\].fa_inst.s _009_ VGND VGND VPWR VPWR
+ net54 sky130_fd_sc_hd__dfrtp_1
XFILLER_41_50 VGND VGND VPWR VPWR sky130_fd_sc_hd__fill_1
X_195_ genblk1\[14\].fa_inst.b genblk1\[14\].fa_inst.a VGND VGND VPWR VPWR _105_ sky130_fd_sc_hd__or2_1
XFILLER_51_9 VGND VGND VPWR VPWR sky130_fd_sc_hd__decap_3
XTAP_TAPCELL_ROW_10_2_571 VGND VPWR sky130_fd_sc_hd__tapvpwrvgnd_1
XFILLER_49_231 VGND VGND VPWR VPWR sky130_fd_sc_hd__decap_3
XFILLER_49_220 VGND VGND VPWR VPWR sky130_fd_sc_hd__decap_3
XFILLER_2_44 VGND VGND VPWR VPWR sky130_fd_sc_hd__decap_3
XFILLER_49_264 VGND VGND VPWR VPWR sky130_fd_sc_hd__decap_3
XFILLER_2_77 VGND VGND VPWR VPWR sky130_fd_sc_hd__decap_3
XFILLER_64_212 VGND VGND VPWR VPWR sky130_fd_sc_hd__decap_3
XFILLER_64_234 VGND VGND VPWR VPWR sky130_fd_sc_hd__decap_3
XTAP_TAPCELL_ROW_47_421 VGND VPWR sky130_fd_sc_hd__tapvpwrvgnd_1
XFILLER_2_88 VGND VGND VPWR VPWR sky130_fd_sc_hd__decap_3
XFILLER_64_256 VGND VGND VPWR VPWR sky130_fd_sc_hd__decap_3
XTAP_TAPCELL_ROW_0_2_561 VGND VPWR sky130_fd_sc_hd__tapvpwrvgnd_1
XFILLER_17_161 VGND VGND VPWR VPWR sky130_fd_sc_hd__decap_3
XFILLER_17_172 VGND VGND VPWR VPWR sky130_fd_sc_hd__decap_3
XFILLER_32_120 VGND VGND VPWR VPWR sky130_fd_sc_hd__decap_3
XFILLER_20_337 VGND VGND VPWR VPWR sky130_fd_sc_hd__decap_3
XFILLER_32_197 VGND VGND VPWR VPWR sky130_fd_sc_hd__decap_3
XFILLER_32_175 VGND VGND VPWR VPWR sky130_fd_sc_hd__decap_3
XFILLER_9_382 VGND VGND VPWR VPWR sky130_fd_sc_hd__decap_3
XFILLER_28_404 VGND VGND VPWR VPWR sky130_fd_sc_hd__decap_3
XFILLER_55_234 VGND VGND VPWR VPWR sky130_fd_sc_hd__decap_3
XFILLER_55_223 VGND VGND VPWR VPWR sky130_fd_sc_hd__fill_1
XFILLER_55_267 VGND VGND VPWR VPWR sky130_fd_sc_hd__decap_3
XFILLER_23_131 VGND VGND VPWR VPWR sky130_fd_sc_hd__decap_3
XFILLER_62_27 VGND VGND VPWR VPWR sky130_fd_sc_hd__fill_1
XFILLER_23_164 VGND VGND VPWR VPWR sky130_fd_sc_hd__decap_3
XFILLER_62_38 VGND VGND VPWR VPWR sky130_fd_sc_hd__decap_3
XTAP_TAPCELL_ROW_53_468 VGND VPWR sky130_fd_sc_hd__tapvpwrvgnd_1
XFILLER_11_337 VGND VGND VPWR VPWR sky130_fd_sc_hd__decap_3
XFILLER_23_175 VGND VGND VPWR VPWR sky130_fd_sc_hd__decap_3
XFILLER_11_42 VGND VGND VPWR VPWR sky130_fd_sc_hd__decap_3
XFILLER_11_86 VGND VGND VPWR VPWR sky130_fd_sc_hd__decap_3
XFILLER_46_212 VGND VGND VPWR VPWR sky130_fd_sc_hd__decap_3
XFILLER_46_256 VGND VGND VPWR VPWR sky130_fd_sc_hd__decap_3
XFILLER_46_245 VGND VGND VPWR VPWR sky130_fd_sc_hd__decap_3
XTAP_TAPCELL_ROW_44_402 VGND VPWR sky130_fd_sc_hd__tapvpwrvgnd_1
XFILLER_46_289 VGND VGND VPWR VPWR sky130_fd_sc_hd__decap_3
XFILLER_61_237 VGND VGND VPWR VPWR sky130_fd_sc_hd__decap_3
XFILLER_14_153 VGND VGND VPWR VPWR sky130_fd_sc_hd__decap_3
Xinput14 a[7] VGND VGND VPWR VPWR net14 sky130_fd_sc_hd__clkbuf_1
Xinput25 b[2] VGND VGND VPWR VPWR net25 sky130_fd_sc_hd__clkbuf_1
Xinput36 delay_sel[2] VGND VGND VPWR VPWR net36 sky130_fd_sc_hd__clkbuf_2
X_247_ net59 VGND VGND VPWR VPWR _042_ sky130_fd_sc_hd__inv_2
XFILLER_10_381 VGND VGND VPWR VPWR sky130_fd_sc_hd__decap_3
XFILLER_6_352 VGND VGND VPWR VPWR sky130_fd_sc_hd__fill_1
X_178_ _085_ _088_ _086_ VGND VGND VPWR VPWR _092_ sky130_fd_sc_hd__a21bo_1
XFILLER_6_363 VGND VGND VPWR VPWR sky130_fd_sc_hd__decap_3
XFILLER_6_396 VGND VGND VPWR VPWR sky130_fd_sc_hd__decap_3
XPHY_EDGE_ROW_1_2_Left_22 VGND VGND VPWR VPWR sky130_fd_sc_hd__decap_3
XFILLER_37_223 VGND VGND VPWR VPWR sky130_fd_sc_hd__fill_1
XFILLER_37_234 VGND VGND VPWR VPWR sky130_fd_sc_hd__decap_3
XFILLER_52_215 VGND VGND VPWR VPWR sky130_fd_sc_hd__decap_3
XFILLER_37_267 VGND VGND VPWR VPWR sky130_fd_sc_hd__decap_3
XFILLER_52_259 VGND VGND VPWR VPWR sky130_fd_sc_hd__decap_3
XFILLER_52_248 VGND VGND VPWR VPWR sky130_fd_sc_hd__decap_3
XFILLER_20_123 VGND VGND VPWR VPWR sky130_fd_sc_hd__decap_3
XFILLER_60_292 VGND VGND VPWR VPWR sky130_fd_sc_hd__decap_3
XFILLER_20_156 VGND VGND VPWR VPWR sky130_fd_sc_hd__decap_3
XFILLER_57_49 VGND VGND VPWR VPWR sky130_fd_sc_hd__decap_3
XFILLER_28_212 VGND VGND VPWR VPWR sky130_fd_sc_hd__decap_3
XFILLER_28_256 VGND VGND VPWR VPWR sky130_fd_sc_hd__decap_3
XFILLER_28_245 VGND VGND VPWR VPWR sky130_fd_sc_hd__decap_3
XFILLER_28_289 VGND VGND VPWR VPWR sky130_fd_sc_hd__decap_3
XFILLER_43_237 VGND VGND VPWR VPWR sky130_fd_sc_hd__decap_3
XFILLER_11_101 VGND VGND VPWR VPWR sky130_fd_sc_hd__decap_3
XFILLER_51_281 VGND VGND VPWR VPWR sky130_fd_sc_hd__decap_3
XFILLER_51_270 VGND VGND VPWR VPWR sky130_fd_sc_hd__decap_3
XFILLER_11_134 VGND VGND VPWR VPWR sky130_fd_sc_hd__decap_3
XFILLER_11_167 VGND VGND VPWR VPWR sky130_fd_sc_hd__fill_1
XFILLER_11_178 VGND VGND VPWR VPWR sky130_fd_sc_hd__fill_2
XFILLER_22_41 VGND VGND VPWR VPWR sky130_fd_sc_hd__decap_3
XFILLER_7_116 VGND VGND VPWR VPWR sky130_fd_sc_hd__decap_3
XFILLER_22_85 VGND VGND VPWR VPWR sky130_fd_sc_hd__decap_3
XFILLER_7_149 VGND VGND VPWR VPWR sky130_fd_sc_hd__decap_3
XFILLER_3_388 VGND VGND VPWR VPWR sky130_fd_sc_hd__decap_3
XFILLER_3_355 VGND VGND VPWR VPWR sky130_fd_sc_hd__decap_3
XFILLER_14_9 VGND VGND VPWR VPWR sky130_fd_sc_hd__decap_3
XFILLER_59_370 VGND VGND VPWR VPWR sky130_fd_sc_hd__decap_3
XFILLER_47_60 VGND VGND VPWR VPWR sky130_fd_sc_hd__decap_3
XFILLER_47_93 VGND VGND VPWR VPWR sky130_fd_sc_hd__decap_3
XFILLER_34_215 VGND VGND VPWR VPWR sky130_fd_sc_hd__decap_3
XTAP_TAPCELL_ROW_29_295 VGND VPWR sky130_fd_sc_hd__tapvpwrvgnd_1
XFILLER_34_248 VGND VGND VPWR VPWR sky130_fd_sc_hd__decap_3
XFILLER_34_259 VGND VGND VPWR VPWR sky130_fd_sc_hd__decap_3
XFILLER_63_81 VGND VGND VPWR VPWR sky130_fd_sc_hd__decap_3
XFILLER_8_21 VGND VGND VPWR VPWR sky130_fd_sc_hd__decap_3
XFILLER_8_32 VGND VGND VPWR VPWR sky130_fd_sc_hd__decap_3
XFILLER_42_292 VGND VGND VPWR VPWR sky130_fd_sc_hd__decap_3
XFILLER_6_171 VGND VGND VPWR VPWR sky130_fd_sc_hd__decap_3
XFILLER_57_329 VGND VGND VPWR VPWR sky130_fd_sc_hd__decap_3
XFILLER_25_237 VGND VGND VPWR VPWR sky130_fd_sc_hd__decap_3
XTAP_TAPCELL_ROW_15_1_214 VGND VPWR sky130_fd_sc_hd__tapvpwrvgnd_1
XFILLER_43_18 VGND VGND VPWR VPWR sky130_fd_sc_hd__fill_1
XFILLER_40_218 VGND VGND VPWR VPWR sky130_fd_sc_hd__decap_3
XFILLER_33_281 VGND VGND VPWR VPWR sky130_fd_sc_hd__decap_3
XFILLER_33_270 VGND VGND VPWR VPWR sky130_fd_sc_hd__decap_3
XFILLER_0_369 VGND VGND VPWR VPWR sky130_fd_sc_hd__decap_3
XFILLER_48_307 VGND VGND VPWR VPWR sky130_fd_sc_hd__fill_1
XFILLER_48_318 VGND VGND VPWR VPWR sky130_fd_sc_hd__decap_3
XFILLER_17_41 VGND VGND VPWR VPWR sky130_fd_sc_hd__decap_3
XFILLER_56_351 VGND VGND VPWR VPWR sky130_fd_sc_hd__decap_3
XFILLER_56_395 VGND VGND VPWR VPWR sky130_fd_sc_hd__decap_3
XFILLER_17_85 VGND VGND VPWR VPWR sky130_fd_sc_hd__decap_3
XTAP_TAPCELL_ROW_26_276 VGND VPWR sky130_fd_sc_hd__tapvpwrvgnd_1
XFILLER_24_292 VGND VGND VPWR VPWR sky130_fd_sc_hd__decap_3
XFILLER_33_95 VGND VGND VPWR VPWR sky130_fd_sc_hd__decap_3
XFILLER_3_152 VGND VGND VPWR VPWR sky130_fd_sc_hd__decap_3
XFILLER_58_81 VGND VGND VPWR VPWR sky130_fd_sc_hd__decap_3
XFILLER_39_329 VGND VGND VPWR VPWR sky130_fd_sc_hd__decap_3
XFILLER_12_6 VGND VGND VPWR VPWR sky130_fd_sc_hd__fill_2
XFILLER_47_340 VGND VGND VPWR VPWR sky130_fd_sc_hd__decap_3
XFILLER_47_373 VGND VGND VPWR VPWR sky130_fd_sc_hd__decap_3
XFILLER_62_321 VGND VGND VPWR VPWR sky130_fd_sc_hd__decap_3
XFILLER_62_354 VGND VGND VPWR VPWR sky130_fd_sc_hd__decap_3
XFILLER_62_365 VGND VGND VPWR VPWR sky130_fd_sc_hd__decap_3
XFILLER_62_398 VGND VGND VPWR VPWR sky130_fd_sc_hd__decap_3
XFILLER_30_262 VGND VGND VPWR VPWR sky130_fd_sc_hd__decap_3
XFILLER_30_251 VGND VGND VPWR VPWR sky130_fd_sc_hd__fill_1
XFILLER_30_295 VGND VGND VPWR VPWR sky130_fd_sc_hd__decap_3
XFILLER_38_18 VGND VGND VPWR VPWR sky130_fd_sc_hd__decap_3
XFILLER_57_104 VGND VGND VPWR VPWR sky130_fd_sc_hd__decap_3
XFILLER_57_137 VGND VGND VPWR VPWR sky130_fd_sc_hd__decap_3
XFILLER_38_351 VGND VGND VPWR VPWR sky130_fd_sc_hd__decap_3
XFILLER_53_332 VGND VGND VPWR VPWR sky130_fd_sc_hd__decap_3
XFILLER_38_395 VGND VGND VPWR VPWR sky130_fd_sc_hd__decap_3
XFILLER_53_343 VGND VGND VPWR VPWR sky130_fd_sc_hd__decap_3
XFILLER_53_376 VGND VGND VPWR VPWR sky130_fd_sc_hd__decap_3
XFILLER_21_251 VGND VGND VPWR VPWR sky130_fd_sc_hd__fill_1
XFILLER_21_262 VGND VGND VPWR VPWR sky130_fd_sc_hd__decap_3
XTAP_TAPCELL_ROW_23_257 VGND VPWR sky130_fd_sc_hd__tapvpwrvgnd_1
XFILLER_21_284 VGND VGND VPWR VPWR sky130_fd_sc_hd__decap_3
XFILLER_0_100 VGND VGND VPWR VPWR sky130_fd_sc_hd__decap_3
XFILLER_0_122 VGND VGND VPWR VPWR sky130_fd_sc_hd__decap_3
XFILLER_0_144 VGND VGND VPWR VPWR sky130_fd_sc_hd__decap_3
XFILLER_48_126 VGND VGND VPWR VPWR sky130_fd_sc_hd__decap_3
XPHY_EDGE_ROW_26_Right_47 VGND VGND VPWR VPWR sky130_fd_sc_hd__decap_3
XFILLER_48_159 VGND VGND VPWR VPWR sky130_fd_sc_hd__decap_3
XFILLER_29_373 VGND VGND VPWR VPWR sky130_fd_sc_hd__decap_3
XFILLER_29_340 VGND VGND VPWR VPWR sky130_fd_sc_hd__decap_3
XFILLER_28_51 VGND VGND VPWR VPWR sky130_fd_sc_hd__decap_3
XFILLER_56_192 VGND VGND VPWR VPWR sky130_fd_sc_hd__decap_3
XFILLER_44_321 VGND VGND VPWR VPWR sky130_fd_sc_hd__decap_3
XFILLER_44_365 VGND VGND VPWR VPWR sky130_fd_sc_hd__decap_3
XFILLER_44_354 VGND VGND VPWR VPWR sky130_fd_sc_hd__decap_3
XFILLER_44_50 VGND VGND VPWR VPWR sky130_fd_sc_hd__decap_3
XFILLER_44_398 VGND VGND VPWR VPWR sky130_fd_sc_hd__decap_3
XFILLER_44_83 VGND VGND VPWR VPWR sky130_fd_sc_hd__fill_1
XPHY_EDGE_ROW_35_Right_56 VGND VGND VPWR VPWR sky130_fd_sc_hd__decap_3
XFILLER_60_71 VGND VGND VPWR VPWR sky130_fd_sc_hd__decap_3
XTAP_TAPCELL_ROW_14_1_213 VGND VPWR sky130_fd_sc_hd__tapvpwrvgnd_1
XFILLER_5_33 VGND VGND VPWR VPWR sky130_fd_sc_hd__decap_3
XFILLER_5_88 VGND VGND VPWR VPWR sky130_fd_sc_hd__decap_3
XPHY_EDGE_ROW_44_Right_65 VGND VGND VPWR VPWR sky130_fd_sc_hd__decap_3
XFILLER_39_137 VGND VGND VPWR VPWR sky130_fd_sc_hd__decap_3
XFILLER_54_118 VGND VGND VPWR VPWR sky130_fd_sc_hd__decap_3
XFILLER_47_181 VGND VGND VPWR VPWR sky130_fd_sc_hd__decap_3
XFILLER_35_332 VGND VGND VPWR VPWR sky130_fd_sc_hd__decap_3
XFILLER_35_343 VGND VGND VPWR VPWR sky130_fd_sc_hd__decap_3
XFILLER_62_162 VGND VGND VPWR VPWR sky130_fd_sc_hd__decap_3
XFILLER_50_324 VGND VGND VPWR VPWR sky130_fd_sc_hd__decap_3
XFILLER_35_376 VGND VGND VPWR VPWR sky130_fd_sc_hd__decap_3
XFILLER_62_195 VGND VGND VPWR VPWR sky130_fd_sc_hd__fill_1
XPHY_EDGE_ROW_53_Right_74 VGND VGND VPWR VPWR sky130_fd_sc_hd__decap_3
XFILLER_50_357 VGND VGND VPWR VPWR sky130_fd_sc_hd__decap_3
XFILLER_50_368 VGND VGND VPWR VPWR sky130_fd_sc_hd__decap_3
XPHY_EDGE_ROW_62_Right_83 VGND VGND VPWR VPWR sky130_fd_sc_hd__decap_3
XFILLER_26_321 VGND VGND VPWR VPWR sky130_fd_sc_hd__decap_3
XFILLER_26_354 VGND VGND VPWR VPWR sky130_fd_sc_hd__decap_3
XFILLER_26_365 VGND VGND VPWR VPWR sky130_fd_sc_hd__decap_3
XFILLER_53_140 VGND VGND VPWR VPWR sky130_fd_sc_hd__decap_3
XFILLER_38_192 VGND VGND VPWR VPWR sky130_fd_sc_hd__decap_3
XFILLER_26_398 VGND VGND VPWR VPWR sky130_fd_sc_hd__decap_3
XFILLER_53_184 VGND VGND VPWR VPWR sky130_fd_sc_hd__decap_3
XFILLER_41_302 VGND VGND VPWR VPWR sky130_fd_sc_hd__decap_3
X_280_ clknet_2_1__leaf_clk_regs net15 _025_ VGND VGND VPWR VPWR genblk1\[8\].fa_inst.a
+ sky130_fd_sc_hd__dfrtp_1
XFILLER_41_346 VGND VGND VPWR VPWR sky130_fd_sc_hd__decap_3
XFILLER_41_335 VGND VGND VPWR VPWR sky130_fd_sc_hd__fill_1
XFILLER_41_379 VGND VGND VPWR VPWR sky130_fd_sc_hd__decap_3
XFILLER_14_97 VGND VGND VPWR VPWR sky130_fd_sc_hd__decap_3
XFILLER_30_41 VGND VGND VPWR VPWR sky130_fd_sc_hd__decap_3
XFILLER_30_85 VGND VGND VPWR VPWR sky130_fd_sc_hd__decap_3
XFILLER_39_50 VGND VGND VPWR VPWR sky130_fd_sc_hd__decap_3
XFILLER_36_118 VGND VGND VPWR VPWR sky130_fd_sc_hd__decap_3
XFILLER_29_181 VGND VGND VPWR VPWR sky130_fd_sc_hd__decap_3
XFILLER_17_343 VGND VGND VPWR VPWR sky130_fd_sc_hd__decap_3
XFILLER_55_60 VGND VGND VPWR VPWR sky130_fd_sc_hd__fill_2
XFILLER_17_376 VGND VGND VPWR VPWR sky130_fd_sc_hd__decap_3
XFILLER_55_93 VGND VGND VPWR VPWR sky130_fd_sc_hd__decap_3
XFILLER_44_162 VGND VGND VPWR VPWR sky130_fd_sc_hd__decap_3
XFILLER_44_195 VGND VGND VPWR VPWR sky130_fd_sc_hd__fill_1
XFILLER_32_357 VGND VGND VPWR VPWR sky130_fd_sc_hd__decap_3
XFILLER_32_324 VGND VGND VPWR VPWR sky130_fd_sc_hd__decap_3
XFILLER_32_368 VGND VGND VPWR VPWR sky130_fd_sc_hd__decap_3
XFILLER_55_405 VGND VGND VPWR VPWR sky130_fd_sc_hd__fill_2
XFILLER_35_140 VGND VGND VPWR VPWR sky130_fd_sc_hd__decap_3
XFILLER_23_302 VGND VGND VPWR VPWR sky130_fd_sc_hd__decap_3
XFILLER_23_335 VGND VGND VPWR VPWR sky130_fd_sc_hd__fill_1
XFILLER_23_346 VGND VGND VPWR VPWR sky130_fd_sc_hd__decap_3
XFILLER_50_121 VGND VGND VPWR VPWR sky130_fd_sc_hd__decap_3
XFILLER_35_184 VGND VGND VPWR VPWR sky130_fd_sc_hd__decap_3
XFILLER_23_379 VGND VGND VPWR VPWR sky130_fd_sc_hd__decap_3
XFILLER_51_18 VGND VGND VPWR VPWR sky130_fd_sc_hd__fill_2
XFILLER_50_165 VGND VGND VPWR VPWR sky130_fd_sc_hd__decap_3
Xclkbuf_0_clk_regs clk_regs VGND VGND VPWR VPWR clknet_0_clk_regs sky130_fd_sc_hd__clkbuf_16
XFILLER_58_221 VGND VGND VPWR VPWR sky130_fd_sc_hd__decap_3
XFILLER_58_265 VGND VGND VPWR VPWR sky130_fd_sc_hd__decap_3
XFILLER_18_118 VGND VGND VPWR VPWR sky130_fd_sc_hd__decap_3
XFILLER_58_298 VGND VGND VPWR VPWR sky130_fd_sc_hd__decap_3
XFILLER_26_162 VGND VGND VPWR VPWR sky130_fd_sc_hd__decap_3
XTAP_TAPCELL_ROW_56_488 VGND VPWR sky130_fd_sc_hd__tapvpwrvgnd_1
XFILLER_14_346 VGND VGND VPWR VPWR sky130_fd_sc_hd__decap_3
XFILLER_26_195 VGND VGND VPWR VPWR sky130_fd_sc_hd__fill_1
XFILLER_14_357 VGND VGND VPWR VPWR sky130_fd_sc_hd__decap_3
XFILLER_25_85 VGND VGND VPWR VPWR sky130_fd_sc_hd__decap_3
XFILLER_41_143 VGND VGND VPWR VPWR sky130_fd_sc_hd__decap_3
X_263_ clknet_2_2__leaf_clk_regs genblk1\[8\].fa_inst.s _008_ VGND VGND VPWR VPWR
+ net53 sky130_fd_sc_hd__dfrtp_1
XFILLER_41_187 VGND VGND VPWR VPWR sky130_fd_sc_hd__decap_3
X_194_ _103_ _104_ VGND VGND VPWR VPWR genblk1\[13\].fa_inst.s sky130_fd_sc_hd__xnor2_1
XFILLER_41_84 VGND VGND VPWR VPWR sky130_fd_sc_hd__decap_3
XFILLER_41_62 VGND VGND VPWR VPWR sky130_fd_sc_hd__fill_2
XFILLER_44_9 VGND VGND VPWR VPWR sky130_fd_sc_hd__decap_3
XFILLER_2_12 VGND VGND VPWR VPWR sky130_fd_sc_hd__decap_3
XFILLER_49_243 VGND VGND VPWR VPWR sky130_fd_sc_hd__decap_3
XFILLER_2_56 VGND VGND VPWR VPWR sky130_fd_sc_hd__decap_3
XTAP_TAPCELL_ROW_47_422 VGND VPWR sky130_fd_sc_hd__tapvpwrvgnd_1
XFILLER_49_287 VGND VGND VPWR VPWR sky130_fd_sc_hd__decap_3
XFILLER_49_276 VGND VGND VPWR VPWR sky130_fd_sc_hd__decap_3
XFILLER_64_246 VGND VGND VPWR VPWR sky130_fd_sc_hd__decap_3
XFILLER_64_268 VGND VGND VPWR VPWR sky130_fd_sc_hd__decap_3
XFILLER_17_140 VGND VGND VPWR VPWR sky130_fd_sc_hd__decap_3
XFILLER_32_132 VGND VGND VPWR VPWR sky130_fd_sc_hd__decap_3
XFILLER_32_187 VGND VGND VPWR VPWR sky130_fd_sc_hd__decap_3
XFILLER_20_349 VGND VGND VPWR VPWR sky130_fd_sc_hd__decap_3
XFILLER_9_361 VGND VGND VPWR VPWR sky130_fd_sc_hd__decap_3
XFILLER_9_394 VGND VGND VPWR VPWR sky130_fd_sc_hd__decap_3
XFILLER_55_202 VGND VGND VPWR VPWR sky130_fd_sc_hd__decap_3
XFILLER_46_29 VGND VGND VPWR VPWR sky130_fd_sc_hd__decap_3
XFILLER_46_18 VGND VGND VPWR VPWR sky130_fd_sc_hd__decap_3
XFILLER_55_246 VGND VGND VPWR VPWR sky130_fd_sc_hd__decap_3
XFILLER_55_279 VGND VGND VPWR VPWR sky130_fd_sc_hd__fill_1
XFILLER_63_290 VGND VGND VPWR VPWR sky130_fd_sc_hd__decap_3
XFILLER_23_143 VGND VGND VPWR VPWR sky130_fd_sc_hd__decap_3
XTAP_TAPCELL_ROW_53_469 VGND VPWR sky130_fd_sc_hd__tapvpwrvgnd_1
XFILLER_23_187 VGND VGND VPWR VPWR sky130_fd_sc_hd__decap_3
XFILLER_11_349 VGND VGND VPWR VPWR sky130_fd_sc_hd__decap_3
XFILLER_11_21 VGND VGND VPWR VPWR sky130_fd_sc_hd__decap_3
XFILLER_11_54 VGND VGND VPWR VPWR sky130_fd_sc_hd__fill_2
XFILLER_11_98 VGND VGND VPWR VPWR sky130_fd_sc_hd__decap_3
XFILLER_46_224 VGND VGND VPWR VPWR sky130_fd_sc_hd__decap_3
XTAP_TAPCELL_ROW_44_403 VGND VPWR sky130_fd_sc_hd__tapvpwrvgnd_1
XFILLER_61_205 VGND VGND VPWR VPWR sky130_fd_sc_hd__decap_3
XFILLER_46_268 VGND VGND VPWR VPWR sky130_fd_sc_hd__decap_3
XFILLER_36_51 VGND VGND VPWR VPWR sky130_fd_sc_hd__decap_3
XFILLER_14_121 VGND VGND VPWR VPWR sky130_fd_sc_hd__decap_3
XFILLER_61_249 VGND VGND VPWR VPWR sky130_fd_sc_hd__decap_3
XFILLER_14_165 VGND VGND VPWR VPWR sky130_fd_sc_hd__decap_3
XFILLER_52_50 VGND VGND VPWR VPWR sky130_fd_sc_hd__fill_1
XFILLER_52_94 VGND VGND VPWR VPWR sky130_fd_sc_hd__fill_2
XFILLER_10_360 VGND VGND VPWR VPWR sky130_fd_sc_hd__decap_3
Xinput15 a[8] VGND VGND VPWR VPWR net15 sky130_fd_sc_hd__clkbuf_1
Xinput26 b[3] VGND VGND VPWR VPWR net26 sky130_fd_sc_hd__clkbuf_1
Xinput37 rst VGND VGND VPWR VPWR net37 sky130_fd_sc_hd__clkbuf_1
X_246_ net59 VGND VGND VPWR VPWR _041_ sky130_fd_sc_hd__inv_2
XFILLER_10_393 VGND VGND VPWR VPWR sky130_fd_sc_hd__decap_3
XFILLER_6_331 VGND VGND VPWR VPWR sky130_fd_sc_hd__decap_3
X_177_ _089_ _090_ VGND VGND VPWR VPWR _091_ sky130_fd_sc_hd__nand2_1
XFILLER_6_375 VGND VGND VPWR VPWR sky130_fd_sc_hd__decap_3
XFILLER_42_6 VGND VGND VPWR VPWR sky130_fd_sc_hd__decap_3
XPHY_EDGE_ROW_16_2_Left_37 VGND VGND VPWR VPWR sky130_fd_sc_hd__decap_3
XFILLER_37_202 VGND VGND VPWR VPWR sky130_fd_sc_hd__decap_3
XFILLER_37_246 VGND VGND VPWR VPWR sky130_fd_sc_hd__decap_3
XFILLER_37_279 VGND VGND VPWR VPWR sky130_fd_sc_hd__fill_1
XFILLER_52_227 VGND VGND VPWR VPWR sky130_fd_sc_hd__decap_3
XFILLER_45_290 VGND VGND VPWR VPWR sky130_fd_sc_hd__decap_3
XFILLER_60_271 VGND VGND VPWR VPWR sky130_fd_sc_hd__decap_3
XFILLER_20_135 VGND VGND VPWR VPWR sky130_fd_sc_hd__decap_3
XFILLER_20_168 VGND VGND VPWR VPWR sky130_fd_sc_hd__decap_3
XPHY_EDGE_ROW_19_1_Left_125 VGND VGND VPWR VPWR sky130_fd_sc_hd__decap_3
XFILLER_28_224 VGND VGND VPWR VPWR sky130_fd_sc_hd__decap_3
XFILLER_43_205 VGND VGND VPWR VPWR sky130_fd_sc_hd__decap_3
XFILLER_28_268 VGND VGND VPWR VPWR sky130_fd_sc_hd__decap_3
XFILLER_43_249 VGND VGND VPWR VPWR sky130_fd_sc_hd__decap_3
XFILLER_11_113 VGND VGND VPWR VPWR sky130_fd_sc_hd__decap_3
XFILLER_11_146 VGND VGND VPWR VPWR sky130_fd_sc_hd__decap_3
XFILLER_51_293 VGND VGND VPWR VPWR sky130_fd_sc_hd__decap_3
XFILLER_7_106 VGND VGND VPWR VPWR sky130_fd_sc_hd__decap_3
XFILLER_7_128 VGND VGND VPWR VPWR sky130_fd_sc_hd__decap_3
XFILLER_22_53 VGND VGND VPWR VPWR sky130_fd_sc_hd__decap_3
XFILLER_22_75 VGND VGND VPWR VPWR sky130_fd_sc_hd__decap_3
XFILLER_22_97 VGND VGND VPWR VPWR sky130_fd_sc_hd__decap_3
XFILLER_3_334 VGND VGND VPWR VPWR sky130_fd_sc_hd__decap_3
XFILLER_3_367 VGND VGND VPWR VPWR sky130_fd_sc_hd__decap_3
XFILLER_59_382 VGND VGND VPWR VPWR sky130_fd_sc_hd__decap_3
XFILLER_59_393 VGND VGND VPWR VPWR sky130_fd_sc_hd__decap_3
XFILLER_47_72 VGND VGND VPWR VPWR sky130_fd_sc_hd__decap_3
Xpmu_inst VGND VPWR clknet_1_0__leaf_clk net34 net35 net36 cout_next net63 net64 net65
+ net66 net67 net68 net69 net70 net71 net72 net62 net73 net74 net55 pmu
XTAP_TAPCELL_ROW_29_296 VGND VPWR sky130_fd_sc_hd__tapvpwrvgnd_1
XFILLER_34_227 VGND VGND VPWR VPWR sky130_fd_sc_hd__decap_3
XFILLER_27_290 VGND VGND VPWR VPWR sky130_fd_sc_hd__decap_3
XFILLER_63_60 VGND VGND VPWR VPWR sky130_fd_sc_hd__decap_3
XFILLER_63_93 VGND VGND VPWR VPWR sky130_fd_sc_hd__decap_3
XFILLER_42_271 VGND VGND VPWR VPWR sky130_fd_sc_hd__decap_3
XFILLER_8_44 VGND VGND VPWR VPWR sky130_fd_sc_hd__fill_1
XFILLER_8_77 VGND VGND VPWR VPWR sky130_fd_sc_hd__decap_3
XFILLER_8_88 VGND VGND VPWR VPWR sky130_fd_sc_hd__decap_3
X_229_ net58 VGND VGND VPWR VPWR _024_ sky130_fd_sc_hd__inv_2
XFILLER_6_150 VGND VGND VPWR VPWR sky130_fd_sc_hd__decap_3
XFILLER_25_205 VGND VGND VPWR VPWR sky130_fd_sc_hd__decap_3
XFILLER_25_249 VGND VGND VPWR VPWR sky130_fd_sc_hd__decap_3
XTAP_TAPCELL_ROW_15_1_215 VGND VPWR sky130_fd_sc_hd__tapvpwrvgnd_1
XFILLER_33_293 VGND VGND VPWR VPWR sky130_fd_sc_hd__decap_3
XFILLER_0_337 VGND VGND VPWR VPWR sky130_fd_sc_hd__decap_3
XFILLER_56_330 VGND VGND VPWR VPWR sky130_fd_sc_hd__decap_3
XFILLER_56_374 VGND VGND VPWR VPWR sky130_fd_sc_hd__decap_3
XFILLER_56_363 VGND VGND VPWR VPWR sky130_fd_sc_hd__fill_1
XFILLER_17_53 VGND VGND VPWR VPWR sky130_fd_sc_hd__decap_3
XFILLER_17_64 VGND VGND VPWR VPWR sky130_fd_sc_hd__fill_2
XFILLER_17_97 VGND VGND VPWR VPWR sky130_fd_sc_hd__decap_3
XFILLER_31_208 VGND VGND VPWR VPWR sky130_fd_sc_hd__decap_3
XFILLER_24_271 VGND VGND VPWR VPWR sky130_fd_sc_hd__decap_3
XTAP_TAPCELL_ROW_26_277 VGND VPWR sky130_fd_sc_hd__tapvpwrvgnd_1
XFILLER_33_74 VGND VGND VPWR VPWR sky130_fd_sc_hd__decap_3
XFILLER_3_131 VGND VGND VPWR VPWR sky130_fd_sc_hd__decap_3
XFILLER_3_175 VGND VGND VPWR VPWR sky130_fd_sc_hd__decap_3
XFILLER_3_164 VGND VGND VPWR VPWR sky130_fd_sc_hd__decap_3
XFILLER_39_308 VGND VGND VPWR VPWR sky130_fd_sc_hd__decap_3
XFILLER_58_60 VGND VGND VPWR VPWR sky130_fd_sc_hd__decap_3
XFILLER_59_190 VGND VGND VPWR VPWR sky130_fd_sc_hd__decap_3
XFILLER_47_352 VGND VGND VPWR VPWR sky130_fd_sc_hd__decap_3
XFILLER_62_333 VGND VGND VPWR VPWR sky130_fd_sc_hd__decap_3
XFILLER_47_396 VGND VGND VPWR VPWR sky130_fd_sc_hd__decap_3
XFILLER_47_385 VGND VGND VPWR VPWR sky130_fd_sc_hd__decap_3
XFILLER_62_377 VGND VGND VPWR VPWR sky130_fd_sc_hd__decap_3
XTAP_TAPCELL_ROW_60_512 VGND VPWR sky130_fd_sc_hd__tapvpwrvgnd_1
XFILLER_30_230 VGND VGND VPWR VPWR sky130_fd_sc_hd__decap_3
XFILLER_30_274 VGND VGND VPWR VPWR sky130_fd_sc_hd__decap_3
XFILLER_57_116 VGND VGND VPWR VPWR sky130_fd_sc_hd__decap_3
XFILLER_57_149 VGND VGND VPWR VPWR sky130_fd_sc_hd__decap_3
XFILLER_38_330 VGND VGND VPWR VPWR sky130_fd_sc_hd__decap_3
XFILLER_38_363 VGND VGND VPWR VPWR sky130_fd_sc_hd__fill_1
XFILLER_54_18 VGND VGND VPWR VPWR sky130_fd_sc_hd__decap_3
XFILLER_53_311 VGND VGND VPWR VPWR sky130_fd_sc_hd__decap_3
XFILLER_38_374 VGND VGND VPWR VPWR sky130_fd_sc_hd__decap_3
XFILLER_53_355 VGND VGND VPWR VPWR sky130_fd_sc_hd__decap_3
XFILLER_53_399 VGND VGND VPWR VPWR sky130_fd_sc_hd__decap_3
XFILLER_53_388 VGND VGND VPWR VPWR sky130_fd_sc_hd__decap_3
XTAP_TAPCELL_ROW_23_258 VGND VPWR sky130_fd_sc_hd__tapvpwrvgnd_1
XFILLER_21_296 VGND VGND VPWR VPWR sky130_fd_sc_hd__decap_3
XFILLER_0_134 VGND VGND VPWR VPWR sky130_fd_sc_hd__decap_3
XFILLER_0_156 VGND VGND VPWR VPWR sky130_fd_sc_hd__decap_3
XFILLER_48_138 VGND VGND VPWR VPWR sky130_fd_sc_hd__fill_2
XFILLER_63_108 VGND VGND VPWR VPWR sky130_fd_sc_hd__decap_3
XFILLER_63_119 VGND VGND VPWR VPWR sky130_fd_sc_hd__decap_3
XFILLER_29_352 VGND VGND VPWR VPWR sky130_fd_sc_hd__decap_3
XFILLER_28_74 VGND VGND VPWR VPWR sky130_fd_sc_hd__decap_3
XFILLER_28_63 VGND VGND VPWR VPWR sky130_fd_sc_hd__decap_3
XFILLER_56_171 VGND VGND VPWR VPWR sky130_fd_sc_hd__decap_3
XFILLER_29_396 VGND VGND VPWR VPWR sky130_fd_sc_hd__decap_3
XFILLER_29_385 VGND VGND VPWR VPWR sky130_fd_sc_hd__decap_3
XFILLER_28_85 VGND VGND VPWR VPWR sky130_fd_sc_hd__decap_3
XFILLER_44_333 VGND VGND VPWR VPWR sky130_fd_sc_hd__decap_3
XFILLER_44_62 VGND VGND VPWR VPWR sky130_fd_sc_hd__decap_3
XFILLER_44_377 VGND VGND VPWR VPWR sky130_fd_sc_hd__decap_3
XFILLER_60_83 VGND VGND VPWR VPWR sky130_fd_sc_hd__fill_1
XFILLER_60_50 VGND VGND VPWR VPWR sky130_fd_sc_hd__decap_3
XFILLER_60_94 VGND VGND VPWR VPWR sky130_fd_sc_hd__decap_3
XFILLER_39_116 VGND VGND VPWR VPWR sky130_fd_sc_hd__decap_3
XFILLER_39_105 VGND VGND VPWR VPWR sky130_fd_sc_hd__decap_3
XFILLER_39_149 VGND VGND VPWR VPWR sky130_fd_sc_hd__decap_3
XFILLER_35_311 VGND VGND VPWR VPWR sky130_fd_sc_hd__decap_3
XFILLER_62_141 VGND VGND VPWR VPWR sky130_fd_sc_hd__decap_3
XFILLER_62_130 VGND VGND VPWR VPWR sky130_fd_sc_hd__decap_3
XFILLER_47_193 VGND VGND VPWR VPWR sky130_fd_sc_hd__decap_3
XFILLER_35_355 VGND VGND VPWR VPWR sky130_fd_sc_hd__decap_3
XFILLER_62_174 VGND VGND VPWR VPWR sky130_fd_sc_hd__decap_3
XFILLER_35_399 VGND VGND VPWR VPWR sky130_fd_sc_hd__decap_3
XFILLER_35_388 VGND VGND VPWR VPWR sky130_fd_sc_hd__decap_3
XFILLER_50_336 VGND VGND VPWR VPWR sky130_fd_sc_hd__decap_3
XFILLER_45_119 VGND VGND VPWR VPWR sky130_fd_sc_hd__decap_3
XFILLER_38_171 VGND VGND VPWR VPWR sky130_fd_sc_hd__decap_3
XFILLER_26_333 VGND VGND VPWR VPWR sky130_fd_sc_hd__decap_3
XFILLER_26_377 VGND VGND VPWR VPWR sky130_fd_sc_hd__decap_3
XTAP_TAPCELL_ROW_36_350 VGND VPWR sky130_fd_sc_hd__tapvpwrvgnd_1
XFILLER_53_152 VGND VGND VPWR VPWR sky130_fd_sc_hd__decap_3
XFILLER_41_314 VGND VGND VPWR VPWR sky130_fd_sc_hd__decap_3
XFILLER_53_196 VGND VGND VPWR VPWR sky130_fd_sc_hd__decap_3
XFILLER_41_358 VGND VGND VPWR VPWR sky130_fd_sc_hd__decap_3
XFILLER_14_21 VGND VGND VPWR VPWR sky130_fd_sc_hd__fill_1
XFILLER_14_32 VGND VGND VPWR VPWR sky130_fd_sc_hd__decap_3
XFILLER_14_54 VGND VGND VPWR VPWR sky130_fd_sc_hd__decap_3
XPHY_EDGE_ROW_11_1_Right_10 VGND VGND VPWR VPWR sky130_fd_sc_hd__decap_3
XFILLER_30_53 VGND VGND VPWR VPWR sky130_fd_sc_hd__decap_3
XFILLER_30_97 VGND VGND VPWR VPWR sky130_fd_sc_hd__decap_3
XPHY_EDGE_ROW_24_Left_130 VGND VGND VPWR VPWR sky130_fd_sc_hd__decap_3
XFILLER_17_355 VGND VGND VPWR VPWR sky130_fd_sc_hd__decap_3
XFILLER_44_141 VGND VGND VPWR VPWR sky130_fd_sc_hd__decap_3
XFILLER_44_130 VGND VGND VPWR VPWR sky130_fd_sc_hd__decap_3
XFILLER_29_193 VGND VGND VPWR VPWR sky130_fd_sc_hd__decap_3
XFILLER_17_388 VGND VGND VPWR VPWR sky130_fd_sc_hd__decap_3
XFILLER_44_174 VGND VGND VPWR VPWR sky130_fd_sc_hd__decap_3
XFILLER_32_336 VGND VGND VPWR VPWR sky130_fd_sc_hd__decap_3
XTAP_TAPCELL_ROW_42_386 VGND VPWR sky130_fd_sc_hd__tapvpwrvgnd_1
XFILLER_40_380 VGND VGND VPWR VPWR sky130_fd_sc_hd__decap_3
XFILLER_27_108 VGND VGND VPWR VPWR sky130_fd_sc_hd__decap_3
XFILLER_27_119 VGND VGND VPWR VPWR sky130_fd_sc_hd__decap_3
XFILLER_23_314 VGND VGND VPWR VPWR sky130_fd_sc_hd__decap_3
XFILLER_35_152 VGND VGND VPWR VPWR sky130_fd_sc_hd__decap_3
XFILLER_50_133 VGND VGND VPWR VPWR sky130_fd_sc_hd__decap_3
XFILLER_50_100 VGND VGND VPWR VPWR sky130_fd_sc_hd__decap_3
XFILLER_35_196 VGND VGND VPWR VPWR sky130_fd_sc_hd__decap_3
XFILLER_23_358 VGND VGND VPWR VPWR sky130_fd_sc_hd__decap_3
XFILLER_50_144 VGND VGND VPWR VPWR sky130_fd_sc_hd__decap_3
XFILLER_50_177 VGND VGND VPWR VPWR sky130_fd_sc_hd__decap_3
XFILLER_31_391 VGND VGND VPWR VPWR sky130_fd_sc_hd__fill_1
XFILLER_58_233 VGND VGND VPWR VPWR sky130_fd_sc_hd__decap_3
XFILLER_58_200 VGND VGND VPWR VPWR sky130_fd_sc_hd__decap_3
XFILLER_58_277 VGND VGND VPWR VPWR sky130_fd_sc_hd__decap_3
XFILLER_26_130 VGND VGND VPWR VPWR sky130_fd_sc_hd__decap_3
XFILLER_26_141 VGND VGND VPWR VPWR sky130_fd_sc_hd__decap_3
XTAP_TAPCELL_ROW_56_489 VGND VPWR sky130_fd_sc_hd__tapvpwrvgnd_1
XFILLER_25_42 VGND VGND VPWR VPWR sky130_fd_sc_hd__decap_3
XFILLER_26_174 VGND VGND VPWR VPWR sky130_fd_sc_hd__decap_3
XFILLER_41_122 VGND VGND VPWR VPWR sky130_fd_sc_hd__decap_3
XFILLER_41_111 VGND VGND VPWR VPWR sky130_fd_sc_hd__fill_1
XFILLER_14_369 VGND VGND VPWR VPWR sky130_fd_sc_hd__decap_3
XFILLER_25_97 VGND VGND VPWR VPWR sky130_fd_sc_hd__decap_3
XFILLER_41_155 VGND VGND VPWR VPWR sky130_fd_sc_hd__decap_3
XFILLER_22_380 VGND VGND VPWR VPWR sky130_fd_sc_hd__decap_3
X_262_ clknet_2_1__leaf_clk_regs genblk1\[7\].fa_inst.s _007_ VGND VGND VPWR VPWR
+ net52 sky130_fd_sc_hd__dfrtp_1
XFILLER_41_199 VGND VGND VPWR VPWR sky130_fd_sc_hd__decap_3
X_193_ _097_ _100_ _098_ VGND VGND VPWR VPWR _104_ sky130_fd_sc_hd__a21bo_1
XFILLER_41_41 VGND VGND VPWR VPWR sky130_fd_sc_hd__decap_3
XFILLER_41_96 VGND VGND VPWR VPWR sky130_fd_sc_hd__decap_3
XFILLER_37_9 VGND VGND VPWR VPWR sky130_fd_sc_hd__decap_3
XFILLER_49_211 VGND VGND VPWR VPWR sky130_fd_sc_hd__decap_3
XFILLER_2_35 VGND VGND VPWR VPWR sky130_fd_sc_hd__decap_3
XFILLER_2_24 VGND VGND VPWR VPWR sky130_fd_sc_hd__decap_3
XFILLER_49_255 VGND VGND VPWR VPWR sky130_fd_sc_hd__decap_3
XFILLER_2_68 VGND VGND VPWR VPWR sky130_fd_sc_hd__decap_3
XFILLER_64_203 VGND VGND VPWR VPWR sky130_fd_sc_hd__decap_3
XFILLER_64_225 VGND VGND VPWR VPWR sky130_fd_sc_hd__decap_3
XFILLER_49_299 VGND VGND VPWR VPWR sky130_fd_sc_hd__decap_3
XTAP_TAPCELL_ROW_47_423 VGND VPWR sky130_fd_sc_hd__tapvpwrvgnd_1
XFILLER_17_152 VGND VGND VPWR VPWR sky130_fd_sc_hd__decap_3
XFILLER_32_144 VGND VGND VPWR VPWR sky130_fd_sc_hd__fill_2
XFILLER_20_328 VGND VGND VPWR VPWR sky130_fd_sc_hd__decap_3
XFILLER_32_166 VGND VGND VPWR VPWR sky130_fd_sc_hd__decap_3
XFILLER_13_391 VGND VGND VPWR VPWR sky130_fd_sc_hd__decap_3
XFILLER_9_340 VGND VGND VPWR VPWR sky130_fd_sc_hd__decap_3
XPHY_EDGE_ROW_4_1_Right_3 VGND VGND VPWR VPWR sky130_fd_sc_hd__decap_3
XFILLER_9_373 VGND VGND VPWR VPWR sky130_fd_sc_hd__decap_3
XFILLER_55_225 VGND VGND VPWR VPWR sky130_fd_sc_hd__decap_3
XFILLER_55_214 VGND VGND VPWR VPWR sky130_fd_sc_hd__decap_3
XFILLER_55_258 VGND VGND VPWR VPWR sky130_fd_sc_hd__decap_3
XFILLER_23_111 VGND VGND VPWR VPWR sky130_fd_sc_hd__fill_1
XFILLER_23_122 VGND VGND VPWR VPWR sky130_fd_sc_hd__decap_3
XFILLER_62_18 VGND VGND VPWR VPWR sky130_fd_sc_hd__decap_3
XFILLER_23_155 VGND VGND VPWR VPWR sky130_fd_sc_hd__decap_3
XFILLER_62_29 VGND VGND VPWR VPWR sky130_fd_sc_hd__decap_3
XFILLER_11_328 VGND VGND VPWR VPWR sky130_fd_sc_hd__decap_3
XFILLER_23_199 VGND VGND VPWR VPWR sky130_fd_sc_hd__decap_3
XFILLER_11_33 VGND VGND VPWR VPWR sky130_fd_sc_hd__decap_3
XTAP_TAPCELL_ROW_16_1_217 VGND VPWR sky130_fd_sc_hd__tapvpwrvgnd_1
XFILLER_11_77 VGND VGND VPWR VPWR sky130_fd_sc_hd__decap_3
XFILLER_2_6 VGND VGND VPWR VPWR sky130_fd_sc_hd__decap_3
XFILLER_19_406 VGND VGND VPWR VPWR sky130_fd_sc_hd__fill_1
XFILLER_46_203 VGND VGND VPWR VPWR sky130_fd_sc_hd__decap_3
XFILLER_46_236 VGND VGND VPWR VPWR sky130_fd_sc_hd__decap_3
XTAP_TAPCELL_ROW_44_404 VGND VPWR sky130_fd_sc_hd__tapvpwrvgnd_1
XFILLER_61_217 VGND VGND VPWR VPWR sky130_fd_sc_hd__decap_3
XFILLER_36_63 VGND VGND VPWR VPWR sky130_fd_sc_hd__decap_3
XFILLER_14_100 VGND VGND VPWR VPWR sky130_fd_sc_hd__decap_3
XFILLER_61_228 VGND VGND VPWR VPWR sky130_fd_sc_hd__decap_3
XFILLER_54_280 VGND VGND VPWR VPWR sky130_fd_sc_hd__decap_3
XFILLER_36_85 VGND VGND VPWR VPWR sky130_fd_sc_hd__decap_3
XFILLER_14_133 VGND VGND VPWR VPWR sky130_fd_sc_hd__decap_3
XFILLER_14_144 VGND VGND VPWR VPWR sky130_fd_sc_hd__decap_3
XFILLER_14_177 VGND VGND VPWR VPWR sky130_fd_sc_hd__decap_3
X_245_ net59 VGND VGND VPWR VPWR _040_ sky130_fd_sc_hd__inv_2
XFILLER_52_62 VGND VGND VPWR VPWR sky130_fd_sc_hd__fill_2
Xinput16 a[9] VGND VGND VPWR VPWR net16 sky130_fd_sc_hd__clkbuf_1
Xinput27 b[4] VGND VGND VPWR VPWR net27 sky130_fd_sc_hd__clkbuf_1
XFILLER_10_372 VGND VGND VPWR VPWR sky130_fd_sc_hd__decap_3
XFILLER_6_343 VGND VGND VPWR VPWR sky130_fd_sc_hd__decap_3
X_176_ genblk1\[10\].fa_inst.b genblk1\[10\].fa_inst.a VGND VGND VPWR VPWR _090_ sky130_fd_sc_hd__nand2_1
XFILLER_6_354 VGND VGND VPWR VPWR sky130_fd_sc_hd__decap_3
XFILLER_6_387 VGND VGND VPWR VPWR sky130_fd_sc_hd__decap_3
XFILLER_35_6 VGND VGND VPWR VPWR sky130_fd_sc_hd__decap_3
XFILLER_37_214 VGND VGND VPWR VPWR sky130_fd_sc_hd__decap_3
XFILLER_37_225 VGND VGND VPWR VPWR sky130_fd_sc_hd__decap_3
XFILLER_52_206 VGND VGND VPWR VPWR sky130_fd_sc_hd__decap_3
XFILLER_37_258 VGND VGND VPWR VPWR sky130_fd_sc_hd__decap_3
XFILLER_52_239 VGND VGND VPWR VPWR sky130_fd_sc_hd__decap_3
XFILLER_60_283 VGND VGND VPWR VPWR sky130_fd_sc_hd__decap_3
XFILLER_20_147 VGND VGND VPWR VPWR sky130_fd_sc_hd__decap_3
XFILLER_28_203 VGND VGND VPWR VPWR sky130_fd_sc_hd__decap_3
XFILLER_28_236 VGND VGND VPWR VPWR sky130_fd_sc_hd__decap_3
XFILLER_43_228 VGND VGND VPWR VPWR sky130_fd_sc_hd__decap_3
XFILLER_43_217 VGND VGND VPWR VPWR sky130_fd_sc_hd__decap_3
XFILLER_36_280 VGND VGND VPWR VPWR sky130_fd_sc_hd__decap_3
XFILLER_51_261 VGND VGND VPWR VPWR sky130_fd_sc_hd__decap_3
XFILLER_11_125 VGND VGND VPWR VPWR sky130_fd_sc_hd__decap_3
XFILLER_11_158 VGND VGND VPWR VPWR sky130_fd_sc_hd__decap_3
XFILLER_11_169 VGND VGND VPWR VPWR sky130_fd_sc_hd__decap_3
XFILLER_22_21 VGND VGND VPWR VPWR sky130_fd_sc_hd__decap_3
XFILLER_22_32 VGND VGND VPWR VPWR sky130_fd_sc_hd__decap_3
XFILLER_3_379 VGND VGND VPWR VPWR sky130_fd_sc_hd__fill_2
XFILLER_3_346 VGND VGND VPWR VPWR sky130_fd_sc_hd__decap_3
XFILLER_59_361 VGND VGND VPWR VPWR sky130_fd_sc_hd__decap_3
XFILLER_47_51 VGND VGND VPWR VPWR sky130_fd_sc_hd__decap_3
XFILLER_47_84 VGND VGND VPWR VPWR sky130_fd_sc_hd__decap_3
XFILLER_34_206 VGND VGND VPWR VPWR sky130_fd_sc_hd__decap_3
XFILLER_34_239 VGND VGND VPWR VPWR sky130_fd_sc_hd__decap_3
XTAP_TAPCELL_ROW_29_297 VGND VPWR sky130_fd_sc_hd__tapvpwrvgnd_1
XFILLER_63_72 VGND VGND VPWR VPWR sky130_fd_sc_hd__decap_3
XFILLER_30_401 VGND VGND VPWR VPWR sky130_fd_sc_hd__decap_3
XFILLER_8_12 VGND VGND VPWR VPWR sky130_fd_sc_hd__decap_3
XFILLER_42_283 VGND VGND VPWR VPWR sky130_fd_sc_hd__decap_3
X_228_ net58 VGND VGND VPWR VPWR _023_ sky130_fd_sc_hd__inv_2
XFILLER_6_162 VGND VGND VPWR VPWR sky130_fd_sc_hd__decap_3
X_159_ _075_ _076_ VGND VGND VPWR VPWR genblk1\[6\].fa_inst.s sky130_fd_sc_hd__xnor2_1
XFILLER_33_3 VGND VGND VPWR VPWR sky130_fd_sc_hd__decap_3
XFILLER_2_390 VGND VGND VPWR VPWR sky130_fd_sc_hd__decap_3
XFILLER_25_217 VGND VGND VPWR VPWR sky130_fd_sc_hd__decap_3
XFILLER_25_228 VGND VGND VPWR VPWR sky130_fd_sc_hd__decap_3
XTAP_TAPCELL_ROW_15_1_216 VGND VPWR sky130_fd_sc_hd__tapvpwrvgnd_1
XFILLER_40_209 VGND VGND VPWR VPWR sky130_fd_sc_hd__decap_3
XFILLER_33_261 VGND VGND VPWR VPWR sky130_fd_sc_hd__decap_3
XFILLER_0_349 VGND VGND VPWR VPWR sky130_fd_sc_hd__decap_3
XFILLER_48_309 VGND VGND VPWR VPWR sky130_fd_sc_hd__decap_3
XFILLER_56_342 VGND VGND VPWR VPWR sky130_fd_sc_hd__decap_3
XFILLER_56_386 VGND VGND VPWR VPWR sky130_fd_sc_hd__decap_3
XFILLER_17_76 VGND VGND VPWR VPWR sky130_fd_sc_hd__decap_3
XTAP_TAPCELL_ROW_26_278 VGND VPWR sky130_fd_sc_hd__tapvpwrvgnd_1
XFILLER_24_283 VGND VGND VPWR VPWR sky130_fd_sc_hd__decap_3
XFILLER_33_42 VGND VGND VPWR VPWR sky130_fd_sc_hd__decap_3
XFILLER_8_405 VGND VGND VPWR VPWR sky130_fd_sc_hd__fill_2
XFILLER_33_86 VGND VGND VPWR VPWR sky130_fd_sc_hd__decap_3
XFILLER_3_143 VGND VGND VPWR VPWR sky130_fd_sc_hd__decap_3
XFILLER_58_72 VGND VGND VPWR VPWR sky130_fd_sc_hd__decap_3
XFILLER_58_50 VGND VGND VPWR VPWR sky130_fd_sc_hd__fill_2
XFILLER_58_94 VGND VGND VPWR VPWR sky130_fd_sc_hd__decap_3
XFILLER_47_320 VGND VGND VPWR VPWR sky130_fd_sc_hd__decap_3
XFILLER_47_364 VGND VGND VPWR VPWR sky130_fd_sc_hd__decap_3
XFILLER_62_301 VGND VGND VPWR VPWR sky130_fd_sc_hd__decap_3
XFILLER_62_312 VGND VGND VPWR VPWR sky130_fd_sc_hd__decap_3
XFILLER_62_345 VGND VGND VPWR VPWR sky130_fd_sc_hd__decap_3
XFILLER_22_209 VGND VGND VPWR VPWR sky130_fd_sc_hd__decap_3
XFILLER_62_389 VGND VGND VPWR VPWR sky130_fd_sc_hd__decap_3
XTAP_TAPCELL_ROW_60_513 VGND VPWR sky130_fd_sc_hd__tapvpwrvgnd_1
XFILLER_30_253 VGND VGND VPWR VPWR sky130_fd_sc_hd__decap_3
XFILLER_30_242 VGND VGND VPWR VPWR sky130_fd_sc_hd__decap_3
XFILLER_30_286 VGND VGND VPWR VPWR sky130_fd_sc_hd__decap_3
XFILLER_57_128 VGND VGND VPWR VPWR sky130_fd_sc_hd__decap_3
XFILLER_38_342 VGND VGND VPWR VPWR sky130_fd_sc_hd__decap_3
XFILLER_53_323 VGND VGND VPWR VPWR sky130_fd_sc_hd__decap_3
XFILLER_38_386 VGND VGND VPWR VPWR sky130_fd_sc_hd__decap_3
XFILLER_53_367 VGND VGND VPWR VPWR sky130_fd_sc_hd__decap_3
XFILLER_21_253 VGND VGND VPWR VPWR sky130_fd_sc_hd__decap_3
XTAP_TAPCELL_ROW_23_259 VGND VPWR sky130_fd_sc_hd__tapvpwrvgnd_1
XFILLER_21_275 VGND VGND VPWR VPWR sky130_fd_sc_hd__decap_3
XFILLER_0_113 VGND VGND VPWR VPWR sky130_fd_sc_hd__decap_3
XFILLER_48_117 VGND VGND VPWR VPWR sky130_fd_sc_hd__decap_3
XFILLER_29_320 VGND VGND VPWR VPWR sky130_fd_sc_hd__decap_3
XFILLER_29_364 VGND VGND VPWR VPWR sky130_fd_sc_hd__decap_3
XFILLER_28_42 VGND VGND VPWR VPWR sky130_fd_sc_hd__decap_3
XTAP_TAPCELL_ROW_39_370 VGND VPWR sky130_fd_sc_hd__tapvpwrvgnd_1
XFILLER_56_183 VGND VGND VPWR VPWR sky130_fd_sc_hd__decap_3
XFILLER_56_150 VGND VGND VPWR VPWR sky130_fd_sc_hd__decap_3
XFILLER_44_312 VGND VGND VPWR VPWR sky130_fd_sc_hd__decap_3
XFILLER_44_301 VGND VGND VPWR VPWR sky130_fd_sc_hd__decap_3
XFILLER_44_345 VGND VGND VPWR VPWR sky130_fd_sc_hd__decap_3
XFILLER_44_41 VGND VGND VPWR VPWR sky130_fd_sc_hd__decap_3
XFILLER_44_389 VGND VGND VPWR VPWR sky130_fd_sc_hd__decap_3
XFILLER_44_85 VGND VGND VPWR VPWR sky130_fd_sc_hd__decap_3
XFILLER_60_62 VGND VGND VPWR VPWR sky130_fd_sc_hd__decap_3
XFILLER_5_68 VGND VGND VPWR VPWR sky130_fd_sc_hd__decap_3
XFILLER_39_128 VGND VGND VPWR VPWR sky130_fd_sc_hd__decap_3
XFILLER_47_172 VGND VGND VPWR VPWR sky130_fd_sc_hd__decap_3
XFILLER_47_161 VGND VGND VPWR VPWR sky130_fd_sc_hd__decap_3
XFILLER_35_323 VGND VGND VPWR VPWR sky130_fd_sc_hd__decap_3
XFILLER_62_153 VGND VGND VPWR VPWR sky130_fd_sc_hd__decap_3
XFILLER_50_315 VGND VGND VPWR VPWR sky130_fd_sc_hd__decap_3
XFILLER_50_304 VGND VGND VPWR VPWR sky130_fd_sc_hd__decap_3
XFILLER_35_367 VGND VGND VPWR VPWR sky130_fd_sc_hd__decap_3
XFILLER_62_186 VGND VGND VPWR VPWR sky130_fd_sc_hd__decap_3
XFILLER_62_197 VGND VGND VPWR VPWR sky130_fd_sc_hd__decap_3
XFILLER_50_348 VGND VGND VPWR VPWR sky130_fd_sc_hd__decap_3
XFILLER_58_404 VGND VGND VPWR VPWR sky130_fd_sc_hd__decap_3
XFILLER_26_301 VGND VGND VPWR VPWR sky130_fd_sc_hd__decap_3
XFILLER_26_312 VGND VGND VPWR VPWR sky130_fd_sc_hd__decap_3
XFILLER_45_109 VGND VGND VPWR VPWR sky130_fd_sc_hd__decap_3
XFILLER_38_150 VGND VGND VPWR VPWR sky130_fd_sc_hd__decap_3
XFILLER_26_345 VGND VGND VPWR VPWR sky130_fd_sc_hd__decap_3
XFILLER_53_131 VGND VGND VPWR VPWR sky130_fd_sc_hd__decap_3
XFILLER_38_183 VGND VGND VPWR VPWR sky130_fd_sc_hd__decap_3
XFILLER_26_389 VGND VGND VPWR VPWR sky130_fd_sc_hd__decap_3
XFILLER_53_175 VGND VGND VPWR VPWR sky130_fd_sc_hd__decap_3
XFILLER_53_164 VGND VGND VPWR VPWR sky130_fd_sc_hd__decap_3
XFILLER_41_337 VGND VGND VPWR VPWR sky130_fd_sc_hd__decap_3
XFILLER_41_326 VGND VGND VPWR VPWR sky130_fd_sc_hd__decap_3
XFILLER_14_44 VGND VGND VPWR VPWR sky130_fd_sc_hd__fill_2
XFILLER_14_77 VGND VGND VPWR VPWR sky130_fd_sc_hd__decap_3
XFILLER_14_88 VGND VGND VPWR VPWR sky130_fd_sc_hd__decap_3
XFILLER_30_32 VGND VGND VPWR VPWR sky130_fd_sc_hd__decap_3
XFILLER_30_21 VGND VGND VPWR VPWR sky130_fd_sc_hd__decap_3
XFILLER_1_400 VGND VGND VPWR VPWR sky130_fd_sc_hd__decap_3
XFILLER_30_76 VGND VGND VPWR VPWR sky130_fd_sc_hd__decap_3
XFILLER_39_41 VGND VGND VPWR VPWR sky130_fd_sc_hd__decap_3
XFILLER_39_63 VGND VGND VPWR VPWR sky130_fd_sc_hd__decap_3
XFILLER_39_96 VGND VGND VPWR VPWR sky130_fd_sc_hd__decap_3
XFILLER_29_172 VGND VGND VPWR VPWR sky130_fd_sc_hd__decap_3
XFILLER_29_161 VGND VGND VPWR VPWR sky130_fd_sc_hd__decap_3
XFILLER_17_334 VGND VGND VPWR VPWR sky130_fd_sc_hd__decap_3
XFILLER_55_40 VGND VGND VPWR VPWR sky130_fd_sc_hd__decap_3
XFILLER_17_367 VGND VGND VPWR VPWR sky130_fd_sc_hd__decap_3
XFILLER_55_84 VGND VGND VPWR VPWR sky130_fd_sc_hd__decap_3
XFILLER_44_153 VGND VGND VPWR VPWR sky130_fd_sc_hd__decap_3
XFILLER_32_304 VGND VGND VPWR VPWR sky130_fd_sc_hd__decap_3
XFILLER_44_197 VGND VGND VPWR VPWR sky130_fd_sc_hd__decap_3
XFILLER_44_186 VGND VGND VPWR VPWR sky130_fd_sc_hd__decap_3
XFILLER_32_348 VGND VGND VPWR VPWR sky130_fd_sc_hd__decap_3
XFILLER_32_315 VGND VGND VPWR VPWR sky130_fd_sc_hd__decap_3
XTAP_TAPCELL_ROW_42_387 VGND VPWR sky130_fd_sc_hd__tapvpwrvgnd_1
XFILLER_40_392 VGND VGND VPWR VPWR sky130_fd_sc_hd__decap_3
XFILLER_35_131 VGND VGND VPWR VPWR sky130_fd_sc_hd__decap_3
XFILLER_35_164 VGND VGND VPWR VPWR sky130_fd_sc_hd__decap_3
XFILLER_23_326 VGND VGND VPWR VPWR sky130_fd_sc_hd__decap_3
XFILLER_23_337 VGND VGND VPWR VPWR sky130_fd_sc_hd__decap_3
XFILLER_50_112 VGND VGND VPWR VPWR sky130_fd_sc_hd__decap_3
XFILLER_35_175 VGND VGND VPWR VPWR sky130_fd_sc_hd__decap_3
XFILLER_50_156 VGND VGND VPWR VPWR sky130_fd_sc_hd__decap_3
XFILLER_50_189 VGND VGND VPWR VPWR sky130_fd_sc_hd__decap_3
XFILLER_31_370 VGND VGND VPWR VPWR sky130_fd_sc_hd__decap_3
Xpmu_inst_70 VGND VGND VPWR VPWR pmu_inst_70/HI net70 sky130_fd_sc_hd__conb_1
XFILLER_58_212 VGND VGND VPWR VPWR sky130_fd_sc_hd__decap_3
XFILLER_58_256 VGND VGND VPWR VPWR sky130_fd_sc_hd__decap_3
XFILLER_58_245 VGND VGND VPWR VPWR sky130_fd_sc_hd__decap_3
XFILLER_18_109 VGND VGND VPWR VPWR sky130_fd_sc_hd__decap_3
XFILLER_58_289 VGND VGND VPWR VPWR sky130_fd_sc_hd__decap_3
XFILLER_26_153 VGND VGND VPWR VPWR sky130_fd_sc_hd__decap_3
XFILLER_14_337 VGND VGND VPWR VPWR sky130_fd_sc_hd__decap_3
XFILLER_25_54 VGND VGND VPWR VPWR sky130_fd_sc_hd__fill_2
XFILLER_26_186 VGND VGND VPWR VPWR sky130_fd_sc_hd__decap_3
XFILLER_26_197 VGND VGND VPWR VPWR sky130_fd_sc_hd__decap_3
XFILLER_25_65 VGND VGND VPWR VPWR sky130_fd_sc_hd__fill_1
XFILLER_25_76 VGND VGND VPWR VPWR sky130_fd_sc_hd__decap_3
XFILLER_41_134 VGND VGND VPWR VPWR sky130_fd_sc_hd__decap_3
XPHY_EDGE_ROW_19_2_Left_40 VGND VGND VPWR VPWR sky130_fd_sc_hd__decap_3
X_261_ clknet_2_1__leaf_clk_regs genblk1\[6\].fa_inst.s _006_ VGND VGND VPWR VPWR
+ net51 sky130_fd_sc_hd__dfrtp_1
XFILLER_41_178 VGND VGND VPWR VPWR sky130_fd_sc_hd__decap_3
XFILLER_41_167 VGND VGND VPWR VPWR sky130_fd_sc_hd__fill_1
XFILLER_22_392 VGND VGND VPWR VPWR sky130_fd_sc_hd__decap_3
X_192_ _101_ _102_ VGND VGND VPWR VPWR _103_ sky130_fd_sc_hd__nand2_1
XFILLER_41_75 VGND VGND VPWR VPWR sky130_fd_sc_hd__decap_3
XFILLER_49_223 VGND VGND VPWR VPWR sky130_fd_sc_hd__fill_1
XFILLER_49_234 VGND VGND VPWR VPWR sky130_fd_sc_hd__decap_3
XFILLER_2_47 VGND VGND VPWR VPWR sky130_fd_sc_hd__decap_3
XFILLER_64_215 VGND VGND VPWR VPWR sky130_fd_sc_hd__decap_3
XFILLER_49_267 VGND VGND VPWR VPWR sky130_fd_sc_hd__decap_3
XFILLER_64_237 VGND VGND VPWR VPWR sky130_fd_sc_hd__decap_3
XFILLER_64_259 VGND VGND VPWR VPWR sky130_fd_sc_hd__decap_3
XTAP_TAPCELL_ROW_47_424 VGND VPWR sky130_fd_sc_hd__tapvpwrvgnd_1
XFILLER_17_131 VGND VGND VPWR VPWR sky130_fd_sc_hd__decap_3
XFILLER_17_164 VGND VGND VPWR VPWR sky130_fd_sc_hd__decap_3
XFILLER_17_175 VGND VGND VPWR VPWR sky130_fd_sc_hd__decap_3
XFILLER_32_123 VGND VGND VPWR VPWR sky130_fd_sc_hd__decap_3
XFILLER_13_370 VGND VGND VPWR VPWR sky130_fd_sc_hd__decap_3
XTAP_TAPCELL_ROW_30_302 VGND VPWR sky130_fd_sc_hd__tapvpwrvgnd_1
XFILLER_32_178 VGND VGND VPWR VPWR sky130_fd_sc_hd__decap_3
XFILLER_9_352 VGND VGND VPWR VPWR sky130_fd_sc_hd__decap_3
XFILLER_9_385 VGND VGND VPWR VPWR sky130_fd_sc_hd__decap_3
XFILLER_55_237 VGND VGND VPWR VPWR sky130_fd_sc_hd__decap_3
XFILLER_63_270 VGND VGND VPWR VPWR sky130_fd_sc_hd__decap_3
XFILLER_63_281 VGND VGND VPWR VPWR sky130_fd_sc_hd__decap_3
XFILLER_23_134 VGND VGND VPWR VPWR sky130_fd_sc_hd__decap_3
XPHY_EDGE_ROW_43_Left_149 VGND VGND VPWR VPWR sky130_fd_sc_hd__decap_3
XFILLER_23_167 VGND VGND VPWR VPWR sky130_fd_sc_hd__fill_1
XFILLER_23_178 VGND VGND VPWR VPWR sky130_fd_sc_hd__decap_3
XPHY_EDGE_ROW_59_Right_80 VGND VGND VPWR VPWR sky130_fd_sc_hd__decap_3
XFILLER_11_12 VGND VGND VPWR VPWR sky130_fd_sc_hd__decap_3
XFILLER_11_45 VGND VGND VPWR VPWR sky130_fd_sc_hd__decap_3
XTAP_TAPCELL_ROW_16_1_218 VGND VPWR sky130_fd_sc_hd__tapvpwrvgnd_1
XFILLER_11_89 VGND VGND VPWR VPWR sky130_fd_sc_hd__decap_3
XPHY_EDGE_ROW_52_Left_158 VGND VGND VPWR VPWR sky130_fd_sc_hd__decap_3
XFILLER_46_215 VGND VGND VPWR VPWR sky130_fd_sc_hd__decap_3
XFILLER_46_248 VGND VGND VPWR VPWR sky130_fd_sc_hd__decap_3
XTAP_TAPCELL_ROW_44_405 VGND VPWR sky130_fd_sc_hd__tapvpwrvgnd_1
XFILLER_46_259 VGND VGND VPWR VPWR sky130_fd_sc_hd__decap_3
XFILLER_36_42 VGND VGND VPWR VPWR sky130_fd_sc_hd__decap_3
XFILLER_14_112 VGND VGND VPWR VPWR sky130_fd_sc_hd__decap_3
XPHY_EDGE_ROW_61_Left_167 VGND VGND VPWR VPWR sky130_fd_sc_hd__decap_3
XFILLER_36_75 VGND VGND VPWR VPWR sky130_fd_sc_hd__decap_3
XFILLER_54_292 VGND VGND VPWR VPWR sky130_fd_sc_hd__decap_3
XFILLER_14_156 VGND VGND VPWR VPWR sky130_fd_sc_hd__decap_3
XTAP_TAPCELL_ROW_52_460 VGND VPWR sky130_fd_sc_hd__tapvpwrvgnd_1
XFILLER_52_41 VGND VGND VPWR VPWR sky130_fd_sc_hd__decap_3
X_244_ net62 VGND VGND VPWR VPWR _039_ sky130_fd_sc_hd__inv_2
XFILLER_52_85 VGND VGND VPWR VPWR sky130_fd_sc_hd__decap_3
XFILLER_10_340 VGND VGND VPWR VPWR sky130_fd_sc_hd__decap_3
Xinput17 b[0] VGND VGND VPWR VPWR net17 sky130_fd_sc_hd__buf_1
Xinput28 b[5] VGND VGND VPWR VPWR net28 sky130_fd_sc_hd__clkbuf_1
XFILLER_10_384 VGND VGND VPWR VPWR sky130_fd_sc_hd__decap_3
X_175_ genblk1\[10\].fa_inst.b genblk1\[10\].fa_inst.a VGND VGND VPWR VPWR _089_ sky130_fd_sc_hd__or2_1
XFILLER_6_366 VGND VGND VPWR VPWR sky130_fd_sc_hd__decap_3
XFILLER_6_399 VGND VGND VPWR VPWR sky130_fd_sc_hd__decap_3
XFILLER_28_6 VGND VGND VPWR VPWR sky130_fd_sc_hd__decap_3
XFILLER_37_237 VGND VGND VPWR VPWR sky130_fd_sc_hd__decap_3
XFILLER_52_218 VGND VGND VPWR VPWR sky130_fd_sc_hd__decap_3
XFILLER_45_281 VGND VGND VPWR VPWR sky130_fd_sc_hd__decap_3
XFILLER_45_270 VGND VGND VPWR VPWR sky130_fd_sc_hd__decap_3
XFILLER_60_262 VGND VGND VPWR VPWR sky130_fd_sc_hd__decap_3
XFILLER_60_251 VGND VGND VPWR VPWR sky130_fd_sc_hd__fill_1
XFILLER_20_126 VGND VGND VPWR VPWR sky130_fd_sc_hd__decap_3
XFILLER_60_295 VGND VGND VPWR VPWR sky130_fd_sc_hd__decap_3
XFILLER_20_159 VGND VGND VPWR VPWR sky130_fd_sc_hd__decap_3
XFILLER_3_90 VGND VGND VPWR VPWR sky130_fd_sc_hd__fill_2
XFILLER_28_248 VGND VGND VPWR VPWR sky130_fd_sc_hd__decap_3
XFILLER_28_215 VGND VGND VPWR VPWR sky130_fd_sc_hd__decap_3
XFILLER_28_259 VGND VGND VPWR VPWR sky130_fd_sc_hd__decap_3
XFILLER_51_240 VGND VGND VPWR VPWR sky130_fd_sc_hd__decap_3
XFILLER_36_292 VGND VGND VPWR VPWR sky130_fd_sc_hd__decap_3
XFILLER_11_104 VGND VGND VPWR VPWR sky130_fd_sc_hd__decap_3
XFILLER_51_273 VGND VGND VPWR VPWR sky130_fd_sc_hd__decap_3
XFILLER_11_137 VGND VGND VPWR VPWR sky130_fd_sc_hd__decap_3
XFILLER_51_284 VGND VGND VPWR VPWR sky130_fd_sc_hd__decap_3
XFILLER_7_119 VGND VGND VPWR VPWR sky130_fd_sc_hd__decap_3
XFILLER_22_44 VGND VGND VPWR VPWR sky130_fd_sc_hd__decap_3
XFILLER_22_88 VGND VGND VPWR VPWR sky130_fd_sc_hd__decap_3
XFILLER_3_358 VGND VGND VPWR VPWR sky130_fd_sc_hd__decap_3
XFILLER_59_340 VGND VGND VPWR VPWR sky130_fd_sc_hd__decap_3
XFILLER_59_373 VGND VGND VPWR VPWR sky130_fd_sc_hd__decap_3
XFILLER_47_30 VGND VGND VPWR VPWR sky130_fd_sc_hd__decap_3
XFILLER_47_63 VGND VGND VPWR VPWR sky130_fd_sc_hd__decap_3
XFILLER_47_96 VGND VGND VPWR VPWR sky130_fd_sc_hd__decap_3
XFILLER_27_270 VGND VGND VPWR VPWR sky130_fd_sc_hd__decap_3
XFILLER_34_218 VGND VGND VPWR VPWR sky130_fd_sc_hd__decap_3
XFILLER_27_281 VGND VGND VPWR VPWR sky130_fd_sc_hd__decap_3
XFILLER_63_40 VGND VGND VPWR VPWR sky130_fd_sc_hd__decap_3
XTAP_TAPCELL_ROW_29_298 VGND VPWR sky130_fd_sc_hd__tapvpwrvgnd_1
XFILLER_63_84 VGND VGND VPWR VPWR sky130_fd_sc_hd__decap_3
XFILLER_42_262 VGND VGND VPWR VPWR sky130_fd_sc_hd__decap_3
XFILLER_42_251 VGND VGND VPWR VPWR sky130_fd_sc_hd__fill_1
XFILLER_8_24 VGND VGND VPWR VPWR sky130_fd_sc_hd__decap_3
XFILLER_42_295 VGND VGND VPWR VPWR sky130_fd_sc_hd__decap_3
XFILLER_8_35 VGND VGND VPWR VPWR sky130_fd_sc_hd__decap_3
XFILLER_8_68 VGND VGND VPWR VPWR sky130_fd_sc_hd__decap_3
X_227_ net58 VGND VGND VPWR VPWR _022_ sky130_fd_sc_hd__inv_2
XFILLER_6_130 VGND VGND VPWR VPWR sky130_fd_sc_hd__decap_3
XFILLER_6_141 VGND VGND VPWR VPWR sky130_fd_sc_hd__decap_3
X_158_ _069_ _072_ _070_ VGND VGND VPWR VPWR _076_ sky130_fd_sc_hd__a21bo_1
XFILLER_6_174 VGND VGND VPWR VPWR sky130_fd_sc_hd__decap_3
XTAP_TAPCELL_ROW_63_533 VGND VPWR sky130_fd_sc_hd__tapvpwrvgnd_1
XFILLER_21_402 VGND VGND VPWR VPWR sky130_fd_sc_hd__fill_1
XFILLER_33_240 VGND VGND VPWR VPWR sky130_fd_sc_hd__decap_3
XFILLER_33_284 VGND VGND VPWR VPWR sky130_fd_sc_hd__decap_3
XFILLER_33_273 VGND VGND VPWR VPWR sky130_fd_sc_hd__decap_3
XFILLER_56_321 VGND VGND VPWR VPWR sky130_fd_sc_hd__decap_3
XFILLER_56_365 VGND VGND VPWR VPWR sky130_fd_sc_hd__decap_3
XFILLER_56_354 VGND VGND VPWR VPWR sky130_fd_sc_hd__decap_3
XFILLER_17_44 VGND VGND VPWR VPWR sky130_fd_sc_hd__decap_3
XFILLER_56_398 VGND VGND VPWR VPWR sky130_fd_sc_hd__decap_3
XFILLER_17_88 VGND VGND VPWR VPWR sky130_fd_sc_hd__decap_3
XFILLER_12_402 VGND VGND VPWR VPWR sky130_fd_sc_hd__decap_3
XFILLER_24_251 VGND VGND VPWR VPWR sky130_fd_sc_hd__fill_1
XFILLER_24_262 VGND VGND VPWR VPWR sky130_fd_sc_hd__decap_3
XTAP_TAPCELL_ROW_26_279 VGND VPWR sky130_fd_sc_hd__tapvpwrvgnd_1
XFILLER_24_295 VGND VGND VPWR VPWR sky130_fd_sc_hd__decap_3
XFILLER_33_98 VGND VGND VPWR VPWR sky130_fd_sc_hd__decap_3
XFILLER_3_122 VGND VGND VPWR VPWR sky130_fd_sc_hd__decap_3
XFILLER_3_155 VGND VGND VPWR VPWR sky130_fd_sc_hd__decap_3
XFILLER_59_181 VGND VGND VPWR VPWR sky130_fd_sc_hd__decap_3
XPHY_EDGE_ROW_18_1_Left_124 VGND VGND VPWR VPWR sky130_fd_sc_hd__decap_3
XFILLER_47_343 VGND VGND VPWR VPWR sky130_fd_sc_hd__decap_3
XFILLER_47_332 VGND VGND VPWR VPWR sky130_fd_sc_hd__decap_3
XFILLER_62_324 VGND VGND VPWR VPWR sky130_fd_sc_hd__decap_3
XFILLER_47_376 VGND VGND VPWR VPWR sky130_fd_sc_hd__decap_3
XFILLER_62_357 VGND VGND VPWR VPWR sky130_fd_sc_hd__decap_3
XFILLER_62_368 VGND VGND VPWR VPWR sky130_fd_sc_hd__decap_3
XTAP_TAPCELL_ROW_60_514 VGND VPWR sky130_fd_sc_hd__tapvpwrvgnd_1
XFILLER_30_221 VGND VGND VPWR VPWR sky130_fd_sc_hd__decap_3
XFILLER_30_298 VGND VGND VPWR VPWR sky130_fd_sc_hd__decap_3
XFILLER_30_265 VGND VGND VPWR VPWR sky130_fd_sc_hd__decap_3
XFILLER_57_107 VGND VGND VPWR VPWR sky130_fd_sc_hd__decap_3
XFILLER_38_321 VGND VGND VPWR VPWR sky130_fd_sc_hd__decap_3
XFILLER_38_354 VGND VGND VPWR VPWR sky130_fd_sc_hd__decap_3
XFILLER_53_302 VGND VGND VPWR VPWR sky130_fd_sc_hd__decap_3
XFILLER_38_398 VGND VGND VPWR VPWR sky130_fd_sc_hd__decap_3
XFILLER_38_365 VGND VGND VPWR VPWR sky130_fd_sc_hd__decap_3
XFILLER_53_346 VGND VGND VPWR VPWR sky130_fd_sc_hd__decap_3
XFILLER_53_335 VGND VGND VPWR VPWR sky130_fd_sc_hd__fill_1
XFILLER_0_91 VGND VGND VPWR VPWR sky130_fd_sc_hd__decap_3
XFILLER_53_379 VGND VGND VPWR VPWR sky130_fd_sc_hd__decap_3
XFILLER_21_221 VGND VGND VPWR VPWR sky130_fd_sc_hd__decap_3
XFILLER_21_265 VGND VGND VPWR VPWR sky130_fd_sc_hd__fill_1
XFILLER_21_287 VGND VGND VPWR VPWR sky130_fd_sc_hd__decap_3
XFILLER_0_103 VGND VGND VPWR VPWR sky130_fd_sc_hd__decap_3
XFILLER_0_125 VGND VGND VPWR VPWR sky130_fd_sc_hd__decap_3
XFILLER_0_147 VGND VGND VPWR VPWR sky130_fd_sc_hd__decap_3
XFILLER_0_169 VGND VGND VPWR VPWR sky130_fd_sc_hd__decap_3
XFILLER_48_129 VGND VGND VPWR VPWR sky130_fd_sc_hd__decap_3
XFILLER_28_21 VGND VGND VPWR VPWR sky130_fd_sc_hd__decap_3
XFILLER_29_343 VGND VGND VPWR VPWR sky130_fd_sc_hd__decap_3
XFILLER_29_332 VGND VGND VPWR VPWR sky130_fd_sc_hd__decap_3
XFILLER_28_54 VGND VGND VPWR VPWR sky130_fd_sc_hd__decap_3
XFILLER_56_162 VGND VGND VPWR VPWR sky130_fd_sc_hd__decap_3
XFILLER_29_376 VGND VGND VPWR VPWR sky130_fd_sc_hd__decap_3
XTAP_TAPCELL_ROW_39_371 VGND VPWR sky130_fd_sc_hd__tapvpwrvgnd_1
XFILLER_56_195 VGND VGND VPWR VPWR sky130_fd_sc_hd__fill_1
XFILLER_44_357 VGND VGND VPWR VPWR sky130_fd_sc_hd__decap_3
XFILLER_44_324 VGND VGND VPWR VPWR sky130_fd_sc_hd__decap_3
XFILLER_44_53 VGND VGND VPWR VPWR sky130_fd_sc_hd__decap_3
XFILLER_44_368 VGND VGND VPWR VPWR sky130_fd_sc_hd__decap_3
XFILLER_60_74 VGND VGND VPWR VPWR sky130_fd_sc_hd__decap_3
XFILLER_60_41 VGND VGND VPWR VPWR sky130_fd_sc_hd__decap_3
XFILLER_60_85 VGND VGND VPWR VPWR sky130_fd_sc_hd__decap_3
XFILLER_10_6 VGND VGND VPWR VPWR sky130_fd_sc_hd__decap_3
XFILLER_47_140 VGND VGND VPWR VPWR sky130_fd_sc_hd__decap_3
XFILLER_35_302 VGND VGND VPWR VPWR sky130_fd_sc_hd__decap_3
XFILLER_62_121 VGND VGND VPWR VPWR sky130_fd_sc_hd__decap_3
XFILLER_47_184 VGND VGND VPWR VPWR sky130_fd_sc_hd__decap_3
XFILLER_35_346 VGND VGND VPWR VPWR sky130_fd_sc_hd__decap_3
XFILLER_35_335 VGND VGND VPWR VPWR sky130_fd_sc_hd__fill_1
XFILLER_62_165 VGND VGND VPWR VPWR sky130_fd_sc_hd__decap_3
XFILLER_35_379 VGND VGND VPWR VPWR sky130_fd_sc_hd__decap_3
XFILLER_50_327 VGND VGND VPWR VPWR sky130_fd_sc_hd__decap_3
XPHY_EDGE_ROW_22_Right_43 VGND VGND VPWR VPWR sky130_fd_sc_hd__decap_3
XPHY_EDGE_ROW_31_Right_52 VGND VGND VPWR VPWR sky130_fd_sc_hd__decap_3
XFILLER_38_162 VGND VGND VPWR VPWR sky130_fd_sc_hd__decap_3
XFILLER_26_324 VGND VGND VPWR VPWR sky130_fd_sc_hd__decap_3
XFILLER_38_195 VGND VGND VPWR VPWR sky130_fd_sc_hd__fill_1
XFILLER_26_357 VGND VGND VPWR VPWR sky130_fd_sc_hd__decap_3
XFILLER_26_368 VGND VGND VPWR VPWR sky130_fd_sc_hd__decap_3
XFILLER_53_143 VGND VGND VPWR VPWR sky130_fd_sc_hd__decap_3
XFILLER_41_305 VGND VGND VPWR VPWR sky130_fd_sc_hd__decap_3
XFILLER_53_187 VGND VGND VPWR VPWR sky130_fd_sc_hd__decap_3
XFILLER_41_349 VGND VGND VPWR VPWR sky130_fd_sc_hd__decap_3
XFILLER_14_12 VGND VGND VPWR VPWR sky130_fd_sc_hd__decap_3
XPHY_EDGE_ROW_40_Right_61 VGND VGND VPWR VPWR sky130_fd_sc_hd__decap_3
XFILLER_30_44 VGND VGND VPWR VPWR sky130_fd_sc_hd__decap_3
XFILLER_30_88 VGND VGND VPWR VPWR sky130_fd_sc_hd__decap_3
XTAP_TAPCELL_ROW_10_1_200 VGND VPWR sky130_fd_sc_hd__tapvpwrvgnd_1
XFILLER_39_53 VGND VGND VPWR VPWR sky130_fd_sc_hd__decap_3
XFILLER_29_140 VGND VGND VPWR VPWR sky130_fd_sc_hd__decap_3
XFILLER_17_346 VGND VGND VPWR VPWR sky130_fd_sc_hd__decap_3
XFILLER_44_121 VGND VGND VPWR VPWR sky130_fd_sc_hd__decap_3
XFILLER_29_184 VGND VGND VPWR VPWR sky130_fd_sc_hd__decap_3
XFILLER_17_379 VGND VGND VPWR VPWR sky130_fd_sc_hd__fill_2
XFILLER_55_96 VGND VGND VPWR VPWR sky130_fd_sc_hd__decap_3
XFILLER_44_165 VGND VGND VPWR VPWR sky130_fd_sc_hd__decap_3
XFILLER_32_327 VGND VGND VPWR VPWR sky130_fd_sc_hd__decap_3
XTAP_TAPCELL_ROW_42_388 VGND VPWR sky130_fd_sc_hd__tapvpwrvgnd_1
XFILLER_40_371 VGND VGND VPWR VPWR sky130_fd_sc_hd__decap_3
XFILLER_40_360 VGND VGND VPWR VPWR sky130_fd_sc_hd__decap_3
XFILLER_58_6 VGND VGND VPWR VPWR sky130_fd_sc_hd__decap_3
XFILLER_23_305 VGND VGND VPWR VPWR sky130_fd_sc_hd__decap_3
XFILLER_35_143 VGND VGND VPWR VPWR sky130_fd_sc_hd__decap_3
XFILLER_50_124 VGND VGND VPWR VPWR sky130_fd_sc_hd__decap_3
XFILLER_35_187 VGND VGND VPWR VPWR sky130_fd_sc_hd__decap_3
XFILLER_16_390 VGND VGND VPWR VPWR sky130_fd_sc_hd__decap_3
XFILLER_23_349 VGND VGND VPWR VPWR sky130_fd_sc_hd__decap_3
XFILLER_50_168 VGND VGND VPWR VPWR sky130_fd_sc_hd__decap_3
XFILLER_31_393 VGND VGND VPWR VPWR sky130_fd_sc_hd__decap_3
XFILLER_31_382 VGND VGND VPWR VPWR sky130_fd_sc_hd__decap_3
Xpmu_inst_71 VGND VGND VPWR VPWR pmu_inst_71/HI net71 sky130_fd_sc_hd__conb_1
XFILLER_58_224 VGND VGND VPWR VPWR sky130_fd_sc_hd__decap_3
XPHY_EDGE_ROW_11_2_Left_32 VGND VGND VPWR VPWR sky130_fd_sc_hd__decap_3
XFILLER_58_268 VGND VGND VPWR VPWR sky130_fd_sc_hd__decap_3
XFILLER_26_121 VGND VGND VPWR VPWR sky130_fd_sc_hd__decap_3
XFILLER_26_165 VGND VGND VPWR VPWR sky130_fd_sc_hd__decap_3
XFILLER_41_113 VGND VGND VPWR VPWR sky130_fd_sc_hd__decap_3
XFILLER_41_102 VGND VGND VPWR VPWR sky130_fd_sc_hd__decap_3
XFILLER_14_349 VGND VGND VPWR VPWR sky130_fd_sc_hd__decap_3
XFILLER_25_88 VGND VGND VPWR VPWR sky130_fd_sc_hd__decap_3
XFILLER_41_146 VGND VGND VPWR VPWR sky130_fd_sc_hd__decap_3
XFILLER_22_360 VGND VGND VPWR VPWR sky130_fd_sc_hd__decap_3
XFILLER_22_371 VGND VGND VPWR VPWR sky130_fd_sc_hd__decap_3
X_260_ clknet_2_0__leaf_clk_regs genblk1\[5\].fa_inst.s _005_ VGND VGND VPWR VPWR
+ net50 sky130_fd_sc_hd__dfrtp_1
X_191_ genblk1\[13\].fa_inst.b genblk1\[13\].fa_inst.a VGND VGND VPWR VPWR _102_ sky130_fd_sc_hd__nand2_1
XFILLER_41_54 VGND VGND VPWR VPWR sky130_fd_sc_hd__fill_2
XFILLER_41_87 VGND VGND VPWR VPWR sky130_fd_sc_hd__decap_3
XFILLER_49_202 VGND VGND VPWR VPWR sky130_fd_sc_hd__decap_3
XFILLER_2_15 VGND VGND VPWR VPWR sky130_fd_sc_hd__decap_3
XFILLER_49_246 VGND VGND VPWR VPWR sky130_fd_sc_hd__decap_3
XFILLER_2_59 VGND VGND VPWR VPWR sky130_fd_sc_hd__decap_3
XFILLER_49_279 VGND VGND VPWR VPWR sky130_fd_sc_hd__fill_1
XFILLER_64_249 VGND VGND VPWR VPWR sky130_fd_sc_hd__decap_3
XTAP_TAPCELL_ROW_47_425 VGND VPWR sky130_fd_sc_hd__tapvpwrvgnd_1
XFILLER_17_143 VGND VGND VPWR VPWR sky130_fd_sc_hd__decap_3
XTAP_TAPCELL_ROW_55_480 VGND VPWR sky130_fd_sc_hd__tapvpwrvgnd_1
XFILLER_32_135 VGND VGND VPWR VPWR sky130_fd_sc_hd__decap_3
XTAP_TAPCELL_ROW_30_303 VGND VPWR sky130_fd_sc_hd__tapvpwrvgnd_1
XFILLER_13_382 VGND VGND VPWR VPWR sky130_fd_sc_hd__decap_3
XFILLER_9_331 VGND VGND VPWR VPWR sky130_fd_sc_hd__decap_3
XFILLER_9_364 VGND VGND VPWR VPWR sky130_fd_sc_hd__decap_3
XFILLER_9_397 VGND VGND VPWR VPWR sky130_fd_sc_hd__decap_3
XFILLER_55_205 VGND VGND VPWR VPWR sky130_fd_sc_hd__decap_3
XFILLER_55_249 VGND VGND VPWR VPWR sky130_fd_sc_hd__decap_3
XFILLER_23_102 VGND VGND VPWR VPWR sky130_fd_sc_hd__decap_3
XFILLER_23_113 VGND VGND VPWR VPWR sky130_fd_sc_hd__decap_3
XFILLER_23_146 VGND VGND VPWR VPWR sky130_fd_sc_hd__decap_3
XFILLER_63_293 VGND VGND VPWR VPWR sky130_fd_sc_hd__decap_3
XFILLER_31_190 VGND VGND VPWR VPWR sky130_fd_sc_hd__decap_3
XFILLER_11_24 VGND VGND VPWR VPWR sky130_fd_sc_hd__decap_3
XFILLER_11_57 VGND VGND VPWR VPWR sky130_fd_sc_hd__decap_3
XTAP_TAPCELL_ROW_16_1_219 VGND VPWR sky130_fd_sc_hd__tapvpwrvgnd_1
XFILLER_11_68 VGND VGND VPWR VPWR sky130_fd_sc_hd__decap_3
XFILLER_46_227 VGND VGND VPWR VPWR sky130_fd_sc_hd__decap_3
XFILLER_36_21 VGND VGND VPWR VPWR sky130_fd_sc_hd__decap_3
XFILLER_61_208 VGND VGND VPWR VPWR sky130_fd_sc_hd__decap_3
XFILLER_39_290 VGND VGND VPWR VPWR sky130_fd_sc_hd__decap_3
XFILLER_36_54 VGND VGND VPWR VPWR sky130_fd_sc_hd__decap_3
XTAP_TAPCELL_ROW_44_406 VGND VPWR sky130_fd_sc_hd__tapvpwrvgnd_1
XFILLER_54_271 VGND VGND VPWR VPWR sky130_fd_sc_hd__decap_3
XFILLER_14_124 VGND VGND VPWR VPWR sky130_fd_sc_hd__decap_3
XFILLER_14_168 VGND VGND VPWR VPWR sky130_fd_sc_hd__decap_3
XTAP_TAPCELL_ROW_52_461 VGND VPWR sky130_fd_sc_hd__tapvpwrvgnd_1
X_243_ net62 VGND VGND VPWR VPWR _038_ sky130_fd_sc_hd__inv_2
XFILLER_52_75 VGND VGND VPWR VPWR sky130_fd_sc_hd__decap_3
XFILLER_10_352 VGND VGND VPWR VPWR sky130_fd_sc_hd__fill_1
Xinput18 b[10] VGND VGND VPWR VPWR net18 sky130_fd_sc_hd__clkbuf_1
XFILLER_10_363 VGND VGND VPWR VPWR sky130_fd_sc_hd__decap_3
XFILLER_6_334 VGND VGND VPWR VPWR sky130_fd_sc_hd__decap_3
Xinput29 b[6] VGND VGND VPWR VPWR net29 sky130_fd_sc_hd__clkbuf_1
X_174_ _087_ _088_ VGND VGND VPWR VPWR genblk1\[9\].fa_inst.s sky130_fd_sc_hd__xnor2_1
XFILLER_10_396 VGND VGND VPWR VPWR sky130_fd_sc_hd__decap_3
XFILLER_6_378 VGND VGND VPWR VPWR sky130_fd_sc_hd__decap_3
XFILLER_42_9 VGND VGND VPWR VPWR sky130_fd_sc_hd__decap_3
XFILLER_37_205 VGND VGND VPWR VPWR sky130_fd_sc_hd__decap_3
XFILLER_37_249 VGND VGND VPWR VPWR sky130_fd_sc_hd__decap_3
XFILLER_60_230 VGND VGND VPWR VPWR sky130_fd_sc_hd__decap_3
XFILLER_45_293 VGND VGND VPWR VPWR sky130_fd_sc_hd__decap_3
XFILLER_60_274 VGND VGND VPWR VPWR sky130_fd_sc_hd__decap_3
XFILLER_20_138 VGND VGND VPWR VPWR sky130_fd_sc_hd__fill_2
XFILLER_9_161 VGND VGND VPWR VPWR sky130_fd_sc_hd__decap_3
XFILLER_9_172 VGND VGND VPWR VPWR sky130_fd_sc_hd__decap_3
XFILLER_28_227 VGND VGND VPWR VPWR sky130_fd_sc_hd__decap_3
XFILLER_43_208 VGND VGND VPWR VPWR sky130_fd_sc_hd__decap_3
XFILLER_36_271 VGND VGND VPWR VPWR sky130_fd_sc_hd__decap_3
XFILLER_51_252 VGND VGND VPWR VPWR sky130_fd_sc_hd__decap_3
XFILLER_11_116 VGND VGND VPWR VPWR sky130_fd_sc_hd__decap_3
XFILLER_51_296 VGND VGND VPWR VPWR sky130_fd_sc_hd__decap_3
XFILLER_11_149 VGND VGND VPWR VPWR sky130_fd_sc_hd__decap_3
XFILLER_22_12 VGND VGND VPWR VPWR sky130_fd_sc_hd__decap_3
XFILLER_7_109 VGND VGND VPWR VPWR sky130_fd_sc_hd__decap_3
XFILLER_22_56 VGND VGND VPWR VPWR sky130_fd_sc_hd__decap_3
XFILLER_22_78 VGND VGND VPWR VPWR sky130_fd_sc_hd__decap_3
XFILLER_3_337 VGND VGND VPWR VPWR sky130_fd_sc_hd__decap_3
XFILLER_59_352 VGND VGND VPWR VPWR sky130_fd_sc_hd__decap_3
XFILLER_59_396 VGND VGND VPWR VPWR sky130_fd_sc_hd__decap_3
XFILLER_59_385 VGND VGND VPWR VPWR sky130_fd_sc_hd__decap_3
XFILLER_47_42 VGND VGND VPWR VPWR sky130_fd_sc_hd__decap_3
XFILLER_47_75 VGND VGND VPWR VPWR sky130_fd_sc_hd__decap_3
XFILLER_15_400 VGND VGND VPWR VPWR sky130_fd_sc_hd__decap_3
XFILLER_27_293 VGND VGND VPWR VPWR sky130_fd_sc_hd__decap_3
XTAP_TAPCELL_ROW_29_299 VGND VPWR sky130_fd_sc_hd__tapvpwrvgnd_1
XFILLER_42_230 VGND VGND VPWR VPWR sky130_fd_sc_hd__decap_3
XFILLER_63_52 VGND VGND VPWR VPWR sky130_fd_sc_hd__decap_3
XFILLER_63_63 VGND VGND VPWR VPWR sky130_fd_sc_hd__decap_3
XFILLER_63_96 VGND VGND VPWR VPWR sky130_fd_sc_hd__decap_3
XFILLER_42_274 VGND VGND VPWR VPWR sky130_fd_sc_hd__decap_3
X_226_ net56 VGND VGND VPWR VPWR _021_ sky130_fd_sc_hd__inv_2
XFILLER_10_171 VGND VGND VPWR VPWR sky130_fd_sc_hd__decap_3
XFILLER_6_153 VGND VGND VPWR VPWR sky130_fd_sc_hd__decap_3
X_157_ _073_ _074_ VGND VGND VPWR VPWR _075_ sky130_fd_sc_hd__nand2_1
XFILLER_40_6 VGND VGND VPWR VPWR sky130_fd_sc_hd__decap_3
XFILLER_2_381 VGND VGND VPWR VPWR sky130_fd_sc_hd__decap_3
XFILLER_19_3 VGND VGND VPWR VPWR sky130_fd_sc_hd__decap_3
XFILLER_25_208 VGND VGND VPWR VPWR sky130_fd_sc_hd__decap_3
XTAP_TAPCELL_ROW_63_534 VGND VPWR sky130_fd_sc_hd__tapvpwrvgnd_1
XFILLER_33_252 VGND VGND VPWR VPWR sky130_fd_sc_hd__decap_3
XFILLER_33_296 VGND VGND VPWR VPWR sky130_fd_sc_hd__decap_3
XFILLER_17_12 VGND VGND VPWR VPWR sky130_fd_sc_hd__decap_3
XFILLER_56_333 VGND VGND VPWR VPWR sky130_fd_sc_hd__decap_3
XFILLER_56_377 VGND VGND VPWR VPWR sky130_fd_sc_hd__decap_3
XFILLER_24_230 VGND VGND VPWR VPWR sky130_fd_sc_hd__decap_3
XFILLER_24_274 VGND VGND VPWR VPWR sky130_fd_sc_hd__decap_3
XFILLER_33_77 VGND VGND VPWR VPWR sky130_fd_sc_hd__decap_3
XTAP_TAPCELL_ROW_7_1_190 VGND VPWR sky130_fd_sc_hd__tapvpwrvgnd_1
XFILLER_3_134 VGND VGND VPWR VPWR sky130_fd_sc_hd__decap_3
XFILLER_3_178 VGND VGND VPWR VPWR sky130_fd_sc_hd__fill_2
XFILLER_3_167 VGND VGND VPWR VPWR sky130_fd_sc_hd__fill_1
XFILLER_58_63 VGND VGND VPWR VPWR sky130_fd_sc_hd__decap_3
XFILLER_58_41 VGND VGND VPWR VPWR sky130_fd_sc_hd__decap_3
XFILLER_58_85 VGND VGND VPWR VPWR sky130_fd_sc_hd__decap_3
XFILLER_47_311 VGND VGND VPWR VPWR sky130_fd_sc_hd__decap_3
XFILLER_59_193 VGND VGND VPWR VPWR sky130_fd_sc_hd__decap_3
XFILLER_47_355 VGND VGND VPWR VPWR sky130_fd_sc_hd__decap_3
XFILLER_47_388 VGND VGND VPWR VPWR sky130_fd_sc_hd__decap_3
XFILLER_62_336 VGND VGND VPWR VPWR sky130_fd_sc_hd__decap_3
XFILLER_47_399 VGND VGND VPWR VPWR sky130_fd_sc_hd__decap_3
XTAP_TAPCELL_ROW_11_1_202 VGND VPWR sky130_fd_sc_hd__tapvpwrvgnd_1
XTAP_TAPCELL_ROW_60_515 VGND VPWR sky130_fd_sc_hd__tapvpwrvgnd_1
XFILLER_30_200 VGND VGND VPWR VPWR sky130_fd_sc_hd__decap_3
XFILLER_30_233 VGND VGND VPWR VPWR sky130_fd_sc_hd__decap_3
XFILLER_30_277 VGND VGND VPWR VPWR sky130_fd_sc_hd__decap_3
X_209_ net57 VGND VGND VPWR VPWR _004_ sky130_fd_sc_hd__inv_2
XFILLER_57_119 VGND VGND VPWR VPWR sky130_fd_sc_hd__decap_3
XFILLER_38_333 VGND VGND VPWR VPWR sky130_fd_sc_hd__decap_3
XFILLER_53_314 VGND VGND VPWR VPWR sky130_fd_sc_hd__decap_3
XFILLER_38_377 VGND VGND VPWR VPWR sky130_fd_sc_hd__decap_3
XFILLER_0_81 VGND VGND VPWR VPWR sky130_fd_sc_hd__decap_3
XFILLER_53_358 VGND VGND VPWR VPWR sky130_fd_sc_hd__decap_3
XFILLER_21_200 VGND VGND VPWR VPWR sky130_fd_sc_hd__decap_3
XFILLER_61_391 VGND VGND VPWR VPWR sky130_fd_sc_hd__fill_1
XFILLER_9_90 VGND VGND VPWR VPWR sky130_fd_sc_hd__decap_3
XFILLER_21_299 VGND VGND VPWR VPWR sky130_fd_sc_hd__decap_3
XFILLER_0_137 VGND VGND VPWR VPWR sky130_fd_sc_hd__decap_3
XFILLER_0_159 VGND VGND VPWR VPWR sky130_fd_sc_hd__decap_3
XFILLER_29_311 VGND VGND VPWR VPWR sky130_fd_sc_hd__decap_3
XFILLER_56_130 VGND VGND VPWR VPWR sky130_fd_sc_hd__decap_3
XFILLER_29_355 VGND VGND VPWR VPWR sky130_fd_sc_hd__decap_3
XFILLER_28_66 VGND VGND VPWR VPWR sky130_fd_sc_hd__fill_1
XFILLER_28_33 VGND VGND VPWR VPWR sky130_fd_sc_hd__decap_3
XFILLER_56_174 VGND VGND VPWR VPWR sky130_fd_sc_hd__decap_3
XFILLER_56_141 VGND VGND VPWR VPWR sky130_fd_sc_hd__decap_3
XFILLER_29_388 VGND VGND VPWR VPWR sky130_fd_sc_hd__decap_3
XFILLER_28_77 VGND VGND VPWR VPWR sky130_fd_sc_hd__decap_3
XFILLER_44_336 VGND VGND VPWR VPWR sky130_fd_sc_hd__decap_3
XFILLER_29_399 VGND VGND VPWR VPWR sky130_fd_sc_hd__fill_2
XFILLER_44_32 VGND VGND VPWR VPWR sky130_fd_sc_hd__decap_3
XFILLER_44_21 VGND VGND VPWR VPWR sky130_fd_sc_hd__decap_3
XFILLER_52_380 VGND VGND VPWR VPWR sky130_fd_sc_hd__decap_3
XTAP_TAPCELL_ROW_22_250 VGND VPWR sky130_fd_sc_hd__tapvpwrvgnd_1
XFILLER_60_53 VGND VGND VPWR VPWR sky130_fd_sc_hd__decap_3
XFILLER_60_97 VGND VGND VPWR VPWR sky130_fd_sc_hd__decap_3
XFILLER_39_119 VGND VGND VPWR VPWR sky130_fd_sc_hd__decap_3
XFILLER_39_108 VGND VGND VPWR VPWR sky130_fd_sc_hd__decap_3
XFILLER_47_152 VGND VGND VPWR VPWR sky130_fd_sc_hd__decap_3
XFILLER_35_314 VGND VGND VPWR VPWR sky130_fd_sc_hd__decap_3
XFILLER_62_133 VGND VGND VPWR VPWR sky130_fd_sc_hd__decap_3
XFILLER_62_100 VGND VGND VPWR VPWR sky130_fd_sc_hd__decap_3
XFILLER_47_196 VGND VGND VPWR VPWR sky130_fd_sc_hd__decap_3
XFILLER_62_144 VGND VGND VPWR VPWR sky130_fd_sc_hd__decap_3
XFILLER_35_358 VGND VGND VPWR VPWR sky130_fd_sc_hd__decap_3
XFILLER_62_177 VGND VGND VPWR VPWR sky130_fd_sc_hd__decap_3
XFILLER_50_339 VGND VGND VPWR VPWR sky130_fd_sc_hd__decap_3
XFILLER_43_391 VGND VGND VPWR VPWR sky130_fd_sc_hd__fill_1
XFILLER_38_130 VGND VGND VPWR VPWR sky130_fd_sc_hd__decap_3
XFILLER_38_141 VGND VGND VPWR VPWR sky130_fd_sc_hd__decap_3
XFILLER_26_336 VGND VGND VPWR VPWR sky130_fd_sc_hd__decap_3
XFILLER_53_122 VGND VGND VPWR VPWR sky130_fd_sc_hd__decap_3
XFILLER_53_111 VGND VGND VPWR VPWR sky130_fd_sc_hd__fill_1
XFILLER_38_174 VGND VGND VPWR VPWR sky130_fd_sc_hd__decap_3
XFILLER_53_155 VGND VGND VPWR VPWR sky130_fd_sc_hd__decap_3
XFILLER_53_199 VGND VGND VPWR VPWR sky130_fd_sc_hd__decap_3
XFILLER_41_317 VGND VGND VPWR VPWR sky130_fd_sc_hd__decap_3
XFILLER_14_35 VGND VGND VPWR VPWR sky130_fd_sc_hd__decap_3
XFILLER_34_380 VGND VGND VPWR VPWR sky130_fd_sc_hd__decap_3
XFILLER_14_57 VGND VGND VPWR VPWR sky130_fd_sc_hd__decap_3
XFILLER_30_12 VGND VGND VPWR VPWR sky130_fd_sc_hd__decap_3
XFILLER_30_56 VGND VGND VPWR VPWR sky130_fd_sc_hd__decap_3
XTAP_TAPCELL_ROW_10_1_201 VGND VPWR sky130_fd_sc_hd__tapvpwrvgnd_1
XFILLER_29_152 VGND VGND VPWR VPWR sky130_fd_sc_hd__decap_3
XFILLER_29_196 VGND VGND VPWR VPWR sky130_fd_sc_hd__decap_3
XFILLER_17_358 VGND VGND VPWR VPWR sky130_fd_sc_hd__decap_3
XFILLER_44_144 VGND VGND VPWR VPWR sky130_fd_sc_hd__decap_3
XFILLER_44_133 VGND VGND VPWR VPWR sky130_fd_sc_hd__decap_3
XFILLER_44_177 VGND VGND VPWR VPWR sky130_fd_sc_hd__decap_3
XFILLER_32_339 VGND VGND VPWR VPWR sky130_fd_sc_hd__decap_3
XFILLER_25_391 VGND VGND VPWR VPWR sky130_fd_sc_hd__fill_1
XTAP_TAPCELL_ROW_42_389 VGND VPWR sky130_fd_sc_hd__tapvpwrvgnd_1
XFILLER_40_383 VGND VGND VPWR VPWR sky130_fd_sc_hd__decap_3
XPHY_EDGE_ROW_20_2_Right_106 VGND VGND VPWR VPWR sky130_fd_sc_hd__decap_3
XFILLER_35_122 VGND VGND VPWR VPWR sky130_fd_sc_hd__decap_3
XFILLER_35_155 VGND VGND VPWR VPWR sky130_fd_sc_hd__decap_3
XFILLER_23_317 VGND VGND VPWR VPWR sky130_fd_sc_hd__decap_3
XFILLER_50_103 VGND VGND VPWR VPWR sky130_fd_sc_hd__decap_3
XTAP_TAPCELL_ROW_33_323 VGND VPWR sky130_fd_sc_hd__tapvpwrvgnd_1
XFILLER_50_147 VGND VGND VPWR VPWR sky130_fd_sc_hd__decap_3
XFILLER_50_136 VGND VGND VPWR VPWR sky130_fd_sc_hd__decap_3
XFILLER_35_199 VGND VGND VPWR VPWR sky130_fd_sc_hd__decap_3
XFILLER_31_361 VGND VGND VPWR VPWR sky130_fd_sc_hd__decap_3
XFILLER_6_91 VGND VGND VPWR VPWR sky130_fd_sc_hd__decap_3
Xpmu_inst_72 VGND VGND VPWR VPWR pmu_inst_72/HI net72 sky130_fd_sc_hd__conb_1
XFILLER_58_203 VGND VGND VPWR VPWR sky130_fd_sc_hd__decap_3
XFILLER_58_236 VGND VGND VPWR VPWR sky130_fd_sc_hd__decap_3
XFILLER_26_100 VGND VGND VPWR VPWR sky130_fd_sc_hd__decap_3
XFILLER_25_12 VGND VGND VPWR VPWR sky130_fd_sc_hd__decap_3
XFILLER_26_133 VGND VGND VPWR VPWR sky130_fd_sc_hd__decap_3
XFILLER_26_144 VGND VGND VPWR VPWR sky130_fd_sc_hd__decap_3
XFILLER_14_328 VGND VGND VPWR VPWR sky130_fd_sc_hd__decap_3
XFILLER_25_45 VGND VGND VPWR VPWR sky130_fd_sc_hd__decap_3
XFILLER_26_177 VGND VGND VPWR VPWR sky130_fd_sc_hd__decap_3
XFILLER_41_125 VGND VGND VPWR VPWR sky130_fd_sc_hd__decap_3
XFILLER_41_169 VGND VGND VPWR VPWR sky130_fd_sc_hd__decap_3
XFILLER_41_158 VGND VGND VPWR VPWR sky130_fd_sc_hd__decap_3
XFILLER_22_383 VGND VGND VPWR VPWR sky130_fd_sc_hd__decap_3
X_190_ genblk1\[13\].fa_inst.b genblk1\[13\].fa_inst.a VGND VGND VPWR VPWR _101_ sky130_fd_sc_hd__or2_1
XFILLER_41_44 VGND VGND VPWR VPWR sky130_fd_sc_hd__decap_3
XFILLER_41_99 VGND VGND VPWR VPWR sky130_fd_sc_hd__decap_3
XFILLER_49_214 VGND VGND VPWR VPWR sky130_fd_sc_hd__decap_3
XFILLER_49_225 VGND VGND VPWR VPWR sky130_fd_sc_hd__decap_3
XFILLER_2_38 VGND VGND VPWR VPWR sky130_fd_sc_hd__decap_3
XFILLER_2_27 VGND VGND VPWR VPWR sky130_fd_sc_hd__fill_1
XFILLER_64_206 VGND VGND VPWR VPWR sky130_fd_sc_hd__decap_3
XFILLER_49_258 VGND VGND VPWR VPWR sky130_fd_sc_hd__decap_3
XFILLER_17_100 VGND VGND VPWR VPWR sky130_fd_sc_hd__fill_2
XFILLER_64_228 VGND VGND VPWR VPWR sky130_fd_sc_hd__decap_3
XTAP_TAPCELL_ROW_47_426 VGND VPWR sky130_fd_sc_hd__tapvpwrvgnd_1
XFILLER_17_122 VGND VGND VPWR VPWR sky130_fd_sc_hd__decap_3
XFILLER_17_155 VGND VGND VPWR VPWR sky130_fd_sc_hd__decap_3
XFILLER_60_401 VGND VGND VPWR VPWR sky130_fd_sc_hd__decap_3
XFILLER_32_114 VGND VGND VPWR VPWR sky130_fd_sc_hd__decap_3
XTAP_TAPCELL_ROW_55_481 VGND VPWR sky130_fd_sc_hd__tapvpwrvgnd_1
XFILLER_13_361 VGND VGND VPWR VPWR sky130_fd_sc_hd__decap_3
XFILLER_32_169 VGND VGND VPWR VPWR sky130_fd_sc_hd__decap_3
XFILLER_13_394 VGND VGND VPWR VPWR sky130_fd_sc_hd__decap_3
XFILLER_9_343 VGND VGND VPWR VPWR sky130_fd_sc_hd__decap_3
XTAP_TAPCELL_ROW_30_304 VGND VPWR sky130_fd_sc_hd__tapvpwrvgnd_1
XFILLER_40_180 VGND VGND VPWR VPWR sky130_fd_sc_hd__decap_3
XFILLER_9_376 VGND VGND VPWR VPWR sky130_fd_sc_hd__decap_3
XFILLER_49_3 VGND VGND VPWR VPWR sky130_fd_sc_hd__decap_3
XFILLER_55_228 VGND VGND VPWR VPWR sky130_fd_sc_hd__decap_3
XFILLER_55_217 VGND VGND VPWR VPWR sky130_fd_sc_hd__decap_3
XFILLER_48_280 VGND VGND VPWR VPWR sky130_fd_sc_hd__decap_3
XFILLER_63_261 VGND VGND VPWR VPWR sky130_fd_sc_hd__decap_3
XFILLER_23_125 VGND VGND VPWR VPWR sky130_fd_sc_hd__decap_3
XFILLER_23_158 VGND VGND VPWR VPWR sky130_fd_sc_hd__decap_3
XFILLER_23_169 VGND VGND VPWR VPWR sky130_fd_sc_hd__decap_3
XFILLER_11_36 VGND VGND VPWR VPWR sky130_fd_sc_hd__decap_3
XFILLER_2_9 VGND VGND VPWR VPWR sky130_fd_sc_hd__decap_3
XFILLER_46_206 VGND VGND VPWR VPWR sky130_fd_sc_hd__decap_3
XFILLER_46_239 VGND VGND VPWR VPWR sky130_fd_sc_hd__decap_3
XFILLER_36_33 VGND VGND VPWR VPWR sky130_fd_sc_hd__decap_3
XFILLER_14_103 VGND VGND VPWR VPWR sky130_fd_sc_hd__decap_3
XFILLER_42_401 VGND VGND VPWR VPWR sky130_fd_sc_hd__decap_3
XFILLER_36_88 VGND VGND VPWR VPWR sky130_fd_sc_hd__decap_3
XFILLER_36_66 VGND VGND VPWR VPWR sky130_fd_sc_hd__fill_2
XFILLER_14_136 VGND VGND VPWR VPWR sky130_fd_sc_hd__decap_3
XFILLER_54_283 VGND VGND VPWR VPWR sky130_fd_sc_hd__decap_3
XFILLER_14_147 VGND VGND VPWR VPWR sky130_fd_sc_hd__decap_3
XTAP_TAPCELL_ROW_52_462 VGND VPWR sky130_fd_sc_hd__tapvpwrvgnd_1
XFILLER_52_32 VGND VGND VPWR VPWR sky130_fd_sc_hd__decap_3
X_242_ net58 VGND VGND VPWR VPWR _037_ sky130_fd_sc_hd__inv_2
XFILLER_10_331 VGND VGND VPWR VPWR sky130_fd_sc_hd__decap_3
XFILLER_22_180 VGND VGND VPWR VPWR sky130_fd_sc_hd__decap_3
Xinput19 b[11] VGND VGND VPWR VPWR net19 sky130_fd_sc_hd__clkbuf_1
X_173_ _081_ _084_ _082_ VGND VGND VPWR VPWR _088_ sky130_fd_sc_hd__a21bo_1
XFILLER_10_375 VGND VGND VPWR VPWR sky130_fd_sc_hd__decap_3
XFILLER_6_346 VGND VGND VPWR VPWR sky130_fd_sc_hd__decap_3
XFILLER_6_357 VGND VGND VPWR VPWR sky130_fd_sc_hd__decap_3
XFILLER_35_9 VGND VGND VPWR VPWR sky130_fd_sc_hd__decap_3
XFILLER_37_228 VGND VGND VPWR VPWR sky130_fd_sc_hd__decap_3
XFILLER_37_217 VGND VGND VPWR VPWR sky130_fd_sc_hd__decap_3
XPHY_EDGE_ROW_5_2_Left_26 VGND VGND VPWR VPWR sky130_fd_sc_hd__decap_3
XFILLER_52_209 VGND VGND VPWR VPWR sky130_fd_sc_hd__decap_3
XFILLER_45_261 VGND VGND VPWR VPWR sky130_fd_sc_hd__decap_3
XFILLER_60_253 VGND VGND VPWR VPWR sky130_fd_sc_hd__decap_3
XFILLER_60_242 VGND VGND VPWR VPWR sky130_fd_sc_hd__decap_3
XFILLER_60_286 VGND VGND VPWR VPWR sky130_fd_sc_hd__decap_3
XFILLER_9_140 VGND VGND VPWR VPWR sky130_fd_sc_hd__decap_3
XFILLER_3_81 VGND VGND VPWR VPWR sky130_fd_sc_hd__decap_3
XFILLER_28_239 VGND VGND VPWR VPWR sky130_fd_sc_hd__decap_3
XFILLER_28_206 VGND VGND VPWR VPWR sky130_fd_sc_hd__decap_3
XFILLER_24_401 VGND VGND VPWR VPWR sky130_fd_sc_hd__decap_3
XFILLER_51_231 VGND VGND VPWR VPWR sky130_fd_sc_hd__decap_3
XFILLER_51_220 VGND VGND VPWR VPWR sky130_fd_sc_hd__decap_3
XFILLER_36_283 VGND VGND VPWR VPWR sky130_fd_sc_hd__decap_3
XFILLER_51_264 VGND VGND VPWR VPWR sky130_fd_sc_hd__decap_3
XFILLER_11_128 VGND VGND VPWR VPWR sky130_fd_sc_hd__decap_3
XFILLER_22_24 VGND VGND VPWR VPWR sky130_fd_sc_hd__decap_3
XFILLER_22_35 VGND VGND VPWR VPWR sky130_fd_sc_hd__decap_3
XFILLER_3_349 VGND VGND VPWR VPWR sky130_fd_sc_hd__decap_3
XFILLER_59_320 VGND VGND VPWR VPWR sky130_fd_sc_hd__decap_3
XFILLER_59_364 VGND VGND VPWR VPWR sky130_fd_sc_hd__decap_3
XFILLER_47_21 VGND VGND VPWR VPWR sky130_fd_sc_hd__decap_3
XFILLER_47_54 VGND VGND VPWR VPWR sky130_fd_sc_hd__fill_2
XFILLER_47_87 VGND VGND VPWR VPWR sky130_fd_sc_hd__decap_3
XFILLER_27_261 VGND VGND VPWR VPWR sky130_fd_sc_hd__decap_3
XFILLER_34_209 VGND VGND VPWR VPWR sky130_fd_sc_hd__decap_3
XFILLER_63_31 VGND VGND VPWR VPWR sky130_fd_sc_hd__decap_3
XFILLER_63_75 VGND VGND VPWR VPWR sky130_fd_sc_hd__decap_3
XFILLER_42_253 VGND VGND VPWR VPWR sky130_fd_sc_hd__decap_3
XFILLER_42_242 VGND VGND VPWR VPWR sky130_fd_sc_hd__decap_3
XFILLER_30_404 VGND VGND VPWR VPWR sky130_fd_sc_hd__decap_3
XFILLER_8_15 VGND VGND VPWR VPWR sky130_fd_sc_hd__decap_3
XFILLER_42_286 VGND VGND VPWR VPWR sky130_fd_sc_hd__decap_3
XFILLER_10_150 VGND VGND VPWR VPWR sky130_fd_sc_hd__decap_3
X_225_ net56 VGND VGND VPWR VPWR _020_ sky130_fd_sc_hd__inv_2
XFILLER_6_121 VGND VGND VPWR VPWR sky130_fd_sc_hd__decap_3
X_156_ genblk1\[6\].fa_inst.b genblk1\[6\].fa_inst.a VGND VGND VPWR VPWR _074_ sky130_fd_sc_hd__nand2_1
XFILLER_6_165 VGND VGND VPWR VPWR sky130_fd_sc_hd__decap_3
XFILLER_33_6 VGND VGND VPWR VPWR sky130_fd_sc_hd__decap_3
XFILLER_2_393 VGND VGND VPWR VPWR sky130_fd_sc_hd__decap_3
XFILLER_2_360 VGND VGND VPWR VPWR sky130_fd_sc_hd__decap_3
XTAP_TAPCELL_ROW_63_535 VGND VPWR sky130_fd_sc_hd__tapvpwrvgnd_1
XFILLER_33_220 VGND VGND VPWR VPWR sky130_fd_sc_hd__decap_3
XFILLER_33_231 VGND VGND VPWR VPWR sky130_fd_sc_hd__decap_3
XFILLER_33_264 VGND VGND VPWR VPWR sky130_fd_sc_hd__decap_3
XTAP_TAPCELL_ROW_20_2_581 VGND VPWR sky130_fd_sc_hd__tapvpwrvgnd_1
XFILLER_56_312 VGND VGND VPWR VPWR sky130_fd_sc_hd__decap_3
XFILLER_56_301 VGND VGND VPWR VPWR sky130_fd_sc_hd__decap_3
XFILLER_56_345 VGND VGND VPWR VPWR sky130_fd_sc_hd__decap_3
XFILLER_17_35 VGND VGND VPWR VPWR sky130_fd_sc_hd__decap_3
XFILLER_56_389 VGND VGND VPWR VPWR sky130_fd_sc_hd__decap_3
XFILLER_17_57 VGND VGND VPWR VPWR sky130_fd_sc_hd__decap_3
XFILLER_17_79 VGND VGND VPWR VPWR sky130_fd_sc_hd__decap_3
XFILLER_24_242 VGND VGND VPWR VPWR sky130_fd_sc_hd__decap_3
XFILLER_24_253 VGND VGND VPWR VPWR sky130_fd_sc_hd__decap_3
XFILLER_24_286 VGND VGND VPWR VPWR sky130_fd_sc_hd__decap_3
XFILLER_33_12 VGND VGND VPWR VPWR sky130_fd_sc_hd__decap_3
XFILLER_33_45 VGND VGND VPWR VPWR sky130_fd_sc_hd__decap_3
XPHY_EDGE_ROW_49_Left_155 VGND VGND VPWR VPWR sky130_fd_sc_hd__decap_3
XFILLER_33_89 VGND VGND VPWR VPWR sky130_fd_sc_hd__decap_3
XTAP_TAPCELL_ROW_7_1_191 VGND VPWR sky130_fd_sc_hd__tapvpwrvgnd_1
XFILLER_3_146 VGND VGND VPWR VPWR sky130_fd_sc_hd__decap_3
XPHY_EDGE_ROW_58_Left_164 VGND VGND VPWR VPWR sky130_fd_sc_hd__decap_3
XFILLER_59_172 VGND VGND VPWR VPWR sky130_fd_sc_hd__decap_3
XFILLER_59_150 VGND VGND VPWR VPWR sky130_fd_sc_hd__decap_3
XFILLER_58_97 VGND VGND VPWR VPWR sky130_fd_sc_hd__fill_2
XFILLER_58_75 VGND VGND VPWR VPWR sky130_fd_sc_hd__decap_3
XFILLER_47_323 VGND VGND VPWR VPWR sky130_fd_sc_hd__decap_3
XFILLER_62_304 VGND VGND VPWR VPWR sky130_fd_sc_hd__decap_3
XFILLER_62_315 VGND VGND VPWR VPWR sky130_fd_sc_hd__decap_3
XFILLER_47_367 VGND VGND VPWR VPWR sky130_fd_sc_hd__decap_3
XFILLER_62_348 VGND VGND VPWR VPWR sky130_fd_sc_hd__decap_3
XPHY_EDGE_ROW_0_1_Left_171 VGND VGND VPWR VPWR sky130_fd_sc_hd__decap_3
XTAP_TAPCELL_ROW_11_1_203 VGND VPWR sky130_fd_sc_hd__tapvpwrvgnd_1
XTAP_TAPCELL_ROW_60_516 VGND VPWR sky130_fd_sc_hd__tapvpwrvgnd_1
XFILLER_30_212 VGND VGND VPWR VPWR sky130_fd_sc_hd__decap_3
XTAP_TAPCELL_ROW_25_270 VGND VPWR sky130_fd_sc_hd__tapvpwrvgnd_1
XFILLER_30_245 VGND VGND VPWR VPWR sky130_fd_sc_hd__decap_3
XFILLER_30_289 VGND VGND VPWR VPWR sky130_fd_sc_hd__decap_3
XFILLER_30_256 VGND VGND VPWR VPWR sky130_fd_sc_hd__decap_3
X_208_ net57 VGND VGND VPWR VPWR _003_ sky130_fd_sc_hd__inv_2
X_139_ _057_ _060_ VGND VGND VPWR VPWR genblk1\[2\].fa_inst.s sky130_fd_sc_hd__xnor2_1
XFILLER_31_3 VGND VGND VPWR VPWR sky130_fd_sc_hd__decap_3
XFILLER_38_312 VGND VGND VPWR VPWR sky130_fd_sc_hd__decap_3
XFILLER_38_301 VGND VGND VPWR VPWR sky130_fd_sc_hd__decap_3
XFILLER_38_345 VGND VGND VPWR VPWR sky130_fd_sc_hd__decap_3
XFILLER_38_389 VGND VGND VPWR VPWR sky130_fd_sc_hd__decap_3
XFILLER_0_60 VGND VGND VPWR VPWR sky130_fd_sc_hd__decap_3
XFILLER_53_337 VGND VGND VPWR VPWR sky130_fd_sc_hd__decap_3
XFILLER_53_326 VGND VGND VPWR VPWR sky130_fd_sc_hd__decap_3
XFILLER_21_212 VGND VGND VPWR VPWR sky130_fd_sc_hd__decap_3
XFILLER_61_370 VGND VGND VPWR VPWR sky130_fd_sc_hd__decap_3
XFILLER_21_245 VGND VGND VPWR VPWR sky130_fd_sc_hd__decap_3
XFILLER_21_256 VGND VGND VPWR VPWR sky130_fd_sc_hd__decap_3
XFILLER_21_278 VGND VGND VPWR VPWR sky130_fd_sc_hd__fill_2
XFILLER_0_116 VGND VGND VPWR VPWR sky130_fd_sc_hd__decap_3
XFILLER_28_12 VGND VGND VPWR VPWR sky130_fd_sc_hd__decap_3
XFILLER_29_323 VGND VGND VPWR VPWR sky130_fd_sc_hd__decap_3
XFILLER_28_45 VGND VGND VPWR VPWR sky130_fd_sc_hd__decap_3
XFILLER_56_153 VGND VGND VPWR VPWR sky130_fd_sc_hd__decap_3
XFILLER_44_304 VGND VGND VPWR VPWR sky130_fd_sc_hd__decap_3
XFILLER_29_367 VGND VGND VPWR VPWR sky130_fd_sc_hd__decap_3
XFILLER_56_197 VGND VGND VPWR VPWR sky130_fd_sc_hd__decap_3
XFILLER_56_186 VGND VGND VPWR VPWR sky130_fd_sc_hd__decap_3
XFILLER_44_348 VGND VGND VPWR VPWR sky130_fd_sc_hd__decap_3
XFILLER_44_315 VGND VGND VPWR VPWR sky130_fd_sc_hd__decap_3
XFILLER_44_44 VGND VGND VPWR VPWR sky130_fd_sc_hd__decap_3
XFILLER_44_77 VGND VGND VPWR VPWR sky130_fd_sc_hd__decap_3
XFILLER_52_392 VGND VGND VPWR VPWR sky130_fd_sc_hd__decap_3
XFILLER_44_88 VGND VGND VPWR VPWR sky130_fd_sc_hd__decap_3
XTAP_TAPCELL_ROW_22_251 VGND VPWR sky130_fd_sc_hd__tapvpwrvgnd_1
XFILLER_60_65 VGND VGND VPWR VPWR sky130_fd_sc_hd__decap_3
XFILLER_60_32 VGND VGND VPWR VPWR sky130_fd_sc_hd__decap_3
XFILLER_47_131 VGND VGND VPWR VPWR sky130_fd_sc_hd__decap_3
XFILLER_47_164 VGND VGND VPWR VPWR sky130_fd_sc_hd__decap_3
XFILLER_62_112 VGND VGND VPWR VPWR sky130_fd_sc_hd__decap_3
XFILLER_47_175 VGND VGND VPWR VPWR sky130_fd_sc_hd__decap_3
XFILLER_35_337 VGND VGND VPWR VPWR sky130_fd_sc_hd__decap_3
XFILLER_35_326 VGND VGND VPWR VPWR sky130_fd_sc_hd__decap_3
XFILLER_62_156 VGND VGND VPWR VPWR sky130_fd_sc_hd__decap_3
XFILLER_62_189 VGND VGND VPWR VPWR sky130_fd_sc_hd__decap_3
XFILLER_50_318 VGND VGND VPWR VPWR sky130_fd_sc_hd__decap_3
XFILLER_50_307 VGND VGND VPWR VPWR sky130_fd_sc_hd__fill_1
XFILLER_43_370 VGND VGND VPWR VPWR sky130_fd_sc_hd__decap_3
XFILLER_26_304 VGND VGND VPWR VPWR sky130_fd_sc_hd__decap_3
XFILLER_38_153 VGND VGND VPWR VPWR sky130_fd_sc_hd__decap_3
XFILLER_26_315 VGND VGND VPWR VPWR sky130_fd_sc_hd__decap_3
XFILLER_38_197 VGND VGND VPWR VPWR sky130_fd_sc_hd__decap_3
XFILLER_38_186 VGND VGND VPWR VPWR sky130_fd_sc_hd__decap_3
XFILLER_26_348 VGND VGND VPWR VPWR sky130_fd_sc_hd__decap_3
XFILLER_53_134 VGND VGND VPWR VPWR sky130_fd_sc_hd__decap_3
XFILLER_53_178 VGND VGND VPWR VPWR sky130_fd_sc_hd__decap_3
XFILLER_53_167 VGND VGND VPWR VPWR sky130_fd_sc_hd__fill_1
XFILLER_41_329 VGND VGND VPWR VPWR sky130_fd_sc_hd__decap_3
XFILLER_14_25 VGND VGND VPWR VPWR sky130_fd_sc_hd__decap_3
XFILLER_34_392 VGND VGND VPWR VPWR sky130_fd_sc_hd__decap_3
XPHY_EDGE_ROW_17_1_Left_123 VGND VGND VPWR VPWR sky130_fd_sc_hd__decap_3
XFILLER_30_35 VGND VGND VPWR VPWR sky130_fd_sc_hd__decap_3
XFILLER_30_24 VGND VGND VPWR VPWR sky130_fd_sc_hd__decap_3
XFILLER_30_79 VGND VGND VPWR VPWR sky130_fd_sc_hd__decap_3
XFILLER_39_66 VGND VGND VPWR VPWR sky130_fd_sc_hd__decap_3
XFILLER_39_44 VGND VGND VPWR VPWR sky130_fd_sc_hd__decap_3
XFILLER_39_99 VGND VGND VPWR VPWR sky130_fd_sc_hd__decap_3
XFILLER_29_131 VGND VGND VPWR VPWR sky130_fd_sc_hd__decap_3
XFILLER_17_337 VGND VGND VPWR VPWR sky130_fd_sc_hd__decap_3
XFILLER_55_43 VGND VGND VPWR VPWR sky130_fd_sc_hd__decap_3
XFILLER_29_175 VGND VGND VPWR VPWR sky130_fd_sc_hd__decap_3
XFILLER_29_164 VGND VGND VPWR VPWR sky130_fd_sc_hd__decap_3
XFILLER_55_87 VGND VGND VPWR VPWR sky130_fd_sc_hd__decap_3
XFILLER_55_54 VGND VGND VPWR VPWR sky130_fd_sc_hd__fill_2
XFILLER_44_156 VGND VGND VPWR VPWR sky130_fd_sc_hd__decap_3
XFILLER_25_370 VGND VGND VPWR VPWR sky130_fd_sc_hd__decap_3
XFILLER_44_189 VGND VGND VPWR VPWR sky130_fd_sc_hd__decap_3
XFILLER_32_318 VGND VGND VPWR VPWR sky130_fd_sc_hd__decap_3
XFILLER_32_307 VGND VGND VPWR VPWR sky130_fd_sc_hd__fill_1
XFILLER_40_351 VGND VGND VPWR VPWR sky130_fd_sc_hd__decap_3
XFILLER_40_395 VGND VGND VPWR VPWR sky130_fd_sc_hd__decap_3
XFILLER_35_134 VGND VGND VPWR VPWR sky130_fd_sc_hd__decap_3
XFILLER_23_329 VGND VGND VPWR VPWR sky130_fd_sc_hd__decap_3
XFILLER_50_115 VGND VGND VPWR VPWR sky130_fd_sc_hd__decap_3
XFILLER_35_178 VGND VGND VPWR VPWR sky130_fd_sc_hd__decap_3
XFILLER_35_167 VGND VGND VPWR VPWR sky130_fd_sc_hd__fill_1
XFILLER_16_381 VGND VGND VPWR VPWR sky130_fd_sc_hd__decap_3
XTAP_TAPCELL_ROW_33_324 VGND VPWR sky130_fd_sc_hd__tapvpwrvgnd_1
XFILLER_50_159 VGND VGND VPWR VPWR sky130_fd_sc_hd__decap_3
XFILLER_31_340 VGND VGND VPWR VPWR sky130_fd_sc_hd__decap_3
XFILLER_31_373 VGND VGND VPWR VPWR sky130_fd_sc_hd__decap_3
Xpmu_inst_73 VGND VGND VPWR VPWR pmu_inst_73/HI net73 sky130_fd_sc_hd__conb_1
XFILLER_58_215 VGND VGND VPWR VPWR sky130_fd_sc_hd__decap_3
XFILLER_58_248 VGND VGND VPWR VPWR sky130_fd_sc_hd__decap_3
XFILLER_58_259 VGND VGND VPWR VPWR sky130_fd_sc_hd__decap_3
XFILLER_26_112 VGND VGND VPWR VPWR sky130_fd_sc_hd__decap_3
XFILLER_26_156 VGND VGND VPWR VPWR sky130_fd_sc_hd__decap_3
XFILLER_26_189 VGND VGND VPWR VPWR sky130_fd_sc_hd__decap_3
XFILLER_25_57 VGND VGND VPWR VPWR sky130_fd_sc_hd__decap_3
XFILLER_25_79 VGND VGND VPWR VPWR sky130_fd_sc_hd__decap_3
XFILLER_41_137 VGND VGND VPWR VPWR sky130_fd_sc_hd__decap_3
XFILLER_22_351 VGND VGND VPWR VPWR sky130_fd_sc_hd__decap_3
XFILLER_22_395 VGND VGND VPWR VPWR sky130_fd_sc_hd__decap_3
XFILLER_41_12 VGND VGND VPWR VPWR sky130_fd_sc_hd__decap_3
XFILLER_41_78 VGND VGND VPWR VPWR sky130_fd_sc_hd__decap_3
XFILLER_9_3 VGND VGND VPWR VPWR sky130_fd_sc_hd__decap_3
XFILLER_49_237 VGND VGND VPWR VPWR sky130_fd_sc_hd__decap_3
XFILLER_64_218 VGND VGND VPWR VPWR sky130_fd_sc_hd__decap_3
XTAP_TAPCELL_ROW_47_427 VGND VPWR sky130_fd_sc_hd__tapvpwrvgnd_1
XFILLER_57_281 VGND VGND VPWR VPWR sky130_fd_sc_hd__fill_2
XFILLER_57_270 VGND VGND VPWR VPWR sky130_fd_sc_hd__decap_3
XFILLER_17_134 VGND VGND VPWR VPWR sky130_fd_sc_hd__decap_3
XFILLER_17_167 VGND VGND VPWR VPWR sky130_fd_sc_hd__fill_1
XFILLER_17_178 VGND VGND VPWR VPWR sky130_fd_sc_hd__fill_2
XTAP_TAPCELL_ROW_55_482 VGND VPWR sky130_fd_sc_hd__tapvpwrvgnd_1
XFILLER_32_126 VGND VGND VPWR VPWR sky130_fd_sc_hd__decap_3
XFILLER_13_340 VGND VGND VPWR VPWR sky130_fd_sc_hd__decap_3
XFILLER_13_373 VGND VGND VPWR VPWR sky130_fd_sc_hd__decap_3
XFILLER_15_90 VGND VGND VPWR VPWR sky130_fd_sc_hd__decap_3
XTAP_TAPCELL_ROW_30_305 VGND VPWR sky130_fd_sc_hd__tapvpwrvgnd_1
XFILLER_9_355 VGND VGND VPWR VPWR sky130_fd_sc_hd__decap_3
XFILLER_40_192 VGND VGND VPWR VPWR sky130_fd_sc_hd__decap_3
XFILLER_9_388 VGND VGND VPWR VPWR sky130_fd_sc_hd__decap_3
XFILLER_48_292 VGND VGND VPWR VPWR sky130_fd_sc_hd__decap_3
XFILLER_63_240 VGND VGND VPWR VPWR sky130_fd_sc_hd__decap_3
XFILLER_63_273 VGND VGND VPWR VPWR sky130_fd_sc_hd__decap_3
XFILLER_51_402 VGND VGND VPWR VPWR sky130_fd_sc_hd__decap_3
XFILLER_23_137 VGND VGND VPWR VPWR sky130_fd_sc_hd__decap_3
XFILLER_63_284 VGND VGND VPWR VPWR sky130_fd_sc_hd__decap_3
XFILLER_31_181 VGND VGND VPWR VPWR sky130_fd_sc_hd__decap_3
XFILLER_11_15 VGND VGND VPWR VPWR sky130_fd_sc_hd__decap_3
XFILLER_11_48 VGND VGND VPWR VPWR sky130_fd_sc_hd__decap_3
XPHY_EDGE_ROW_21_Left_127 VGND VGND VPWR VPWR sky130_fd_sc_hd__decap_3
XFILLER_46_218 VGND VGND VPWR VPWR sky130_fd_sc_hd__decap_3
XFILLER_39_270 VGND VGND VPWR VPWR sky130_fd_sc_hd__decap_3
XFILLER_36_12 VGND VGND VPWR VPWR sky130_fd_sc_hd__decap_3
XFILLER_39_281 VGND VGND VPWR VPWR sky130_fd_sc_hd__decap_3
XFILLER_36_45 VGND VGND VPWR VPWR sky130_fd_sc_hd__decap_3
XFILLER_54_262 VGND VGND VPWR VPWR sky130_fd_sc_hd__decap_3
XFILLER_54_251 VGND VGND VPWR VPWR sky130_fd_sc_hd__fill_1
XFILLER_36_78 VGND VGND VPWR VPWR sky130_fd_sc_hd__decap_3
XFILLER_14_115 VGND VGND VPWR VPWR sky130_fd_sc_hd__decap_3
XFILLER_54_295 VGND VGND VPWR VPWR sky130_fd_sc_hd__decap_3
XFILLER_14_159 VGND VGND VPWR VPWR sky130_fd_sc_hd__decap_3
XPHY_EDGE_ROW_30_Left_136 VGND VGND VPWR VPWR sky130_fd_sc_hd__decap_3
X_241_ net56 VGND VGND VPWR VPWR _036_ sky130_fd_sc_hd__inv_2
XFILLER_52_44 VGND VGND VPWR VPWR sky130_fd_sc_hd__decap_3
XFILLER_10_343 VGND VGND VPWR VPWR sky130_fd_sc_hd__decap_3
XFILLER_22_192 VGND VGND VPWR VPWR sky130_fd_sc_hd__decap_3
X_172_ _085_ _086_ VGND VGND VPWR VPWR _087_ sky130_fd_sc_hd__nand2_1
XFILLER_52_88 VGND VGND VPWR VPWR sky130_fd_sc_hd__decap_3
XFILLER_10_354 VGND VGND VPWR VPWR sky130_fd_sc_hd__decap_3
XFILLER_10_387 VGND VGND VPWR VPWR sky130_fd_sc_hd__decap_3
XFILLER_6_369 VGND VGND VPWR VPWR sky130_fd_sc_hd__decap_3
XTAP_TAPCELL_ROW_8_1_193 VGND VPWR sky130_fd_sc_hd__tapvpwrvgnd_1
XFILLER_28_9 VGND VGND VPWR VPWR sky130_fd_sc_hd__decap_3
XFILLER_45_240 VGND VGND VPWR VPWR sky130_fd_sc_hd__decap_3
XFILLER_33_402 VGND VGND VPWR VPWR sky130_fd_sc_hd__fill_1
XFILLER_60_221 VGND VGND VPWR VPWR sky130_fd_sc_hd__decap_3
XFILLER_45_284 VGND VGND VPWR VPWR sky130_fd_sc_hd__decap_3
XFILLER_45_273 VGND VGND VPWR VPWR sky130_fd_sc_hd__decap_3
XFILLER_60_265 VGND VGND VPWR VPWR sky130_fd_sc_hd__decap_3
XFILLER_20_129 VGND VGND VPWR VPWR sky130_fd_sc_hd__decap_3
XFILLER_60_298 VGND VGND VPWR VPWR sky130_fd_sc_hd__decap_3
XFILLER_9_152 VGND VGND VPWR VPWR sky130_fd_sc_hd__decap_3
XFILLER_61_3 VGND VGND VPWR VPWR sky130_fd_sc_hd__decap_3
XTAP_TAPCELL_ROW_12_1_205 VGND VPWR sky130_fd_sc_hd__tapvpwrvgnd_1
XFILLER_5_391 VGND VGND VPWR VPWR sky130_fd_sc_hd__decap_3
XFILLER_3_60 VGND VGND VPWR VPWR sky130_fd_sc_hd__decap_3
XFILLER_28_218 VGND VGND VPWR VPWR sky130_fd_sc_hd__decap_3
XFILLER_36_262 VGND VGND VPWR VPWR sky130_fd_sc_hd__decap_3
XFILLER_36_251 VGND VGND VPWR VPWR sky130_fd_sc_hd__fill_1
XFILLER_36_295 VGND VGND VPWR VPWR sky130_fd_sc_hd__decap_3
XFILLER_51_243 VGND VGND VPWR VPWR sky130_fd_sc_hd__decap_3
XFILLER_11_107 VGND VGND VPWR VPWR sky130_fd_sc_hd__decap_3
XFILLER_51_287 VGND VGND VPWR VPWR sky130_fd_sc_hd__decap_3
XFILLER_51_276 VGND VGND VPWR VPWR sky130_fd_sc_hd__decap_3
XPHY_EDGE_ROW_3_2_Right_89 VGND VGND VPWR VPWR sky130_fd_sc_hd__decap_3
XFILLER_22_47 VGND VGND VPWR VPWR sky130_fd_sc_hd__decap_3
XFILLER_22_69 VGND VGND VPWR VPWR sky130_fd_sc_hd__decap_3
XFILLER_3_328 VGND VGND VPWR VPWR sky130_fd_sc_hd__decap_3
XFILLER_59_343 VGND VGND VPWR VPWR sky130_fd_sc_hd__decap_3
XFILLER_59_332 VGND VGND VPWR VPWR sky130_fd_sc_hd__decap_3
XFILLER_59_376 VGND VGND VPWR VPWR sky130_fd_sc_hd__decap_3
XFILLER_47_66 VGND VGND VPWR VPWR sky130_fd_sc_hd__decap_3
XFILLER_27_240 VGND VGND VPWR VPWR sky130_fd_sc_hd__decap_3
XFILLER_47_99 VGND VGND VPWR VPWR sky130_fd_sc_hd__decap_3
XFILLER_27_273 VGND VGND VPWR VPWR sky130_fd_sc_hd__decap_3
XFILLER_27_284 VGND VGND VPWR VPWR sky130_fd_sc_hd__decap_3
XFILLER_63_10 VGND VGND VPWR VPWR sky130_fd_sc_hd__decap_3
XFILLER_42_221 VGND VGND VPWR VPWR sky130_fd_sc_hd__decap_3
XFILLER_63_43 VGND VGND VPWR VPWR sky130_fd_sc_hd__decap_3
XFILLER_63_87 VGND VGND VPWR VPWR sky130_fd_sc_hd__decap_3
XFILLER_42_265 VGND VGND VPWR VPWR sky130_fd_sc_hd__decap_3
XFILLER_8_27 VGND VGND VPWR VPWR sky130_fd_sc_hd__fill_1
XFILLER_8_38 VGND VGND VPWR VPWR sky130_fd_sc_hd__decap_3
X_224_ net56 VGND VGND VPWR VPWR _019_ sky130_fd_sc_hd__inv_2
XFILLER_42_298 VGND VGND VPWR VPWR sky130_fd_sc_hd__decap_3
XFILLER_6_100 VGND VGND VPWR VPWR sky130_fd_sc_hd__decap_3
XFILLER_10_162 VGND VGND VPWR VPWR sky130_fd_sc_hd__decap_3
XFILLER_6_133 VGND VGND VPWR VPWR sky130_fd_sc_hd__decap_3
XFILLER_6_144 VGND VGND VPWR VPWR sky130_fd_sc_hd__decap_3
X_155_ genblk1\[6\].fa_inst.b genblk1\[6\].fa_inst.a VGND VGND VPWR VPWR _073_ sky130_fd_sc_hd__or2_1
XFILLER_12_80 VGND VGND VPWR VPWR sky130_fd_sc_hd__decap_3
XFILLER_6_177 VGND VGND VPWR VPWR sky130_fd_sc_hd__decap_3
XFILLER_12_91 VGND VGND VPWR VPWR sky130_fd_sc_hd__decap_3
XFILLER_2_372 VGND VGND VPWR VPWR sky130_fd_sc_hd__decap_3
XFILLER_26_6 VGND VGND VPWR VPWR sky130_fd_sc_hd__decap_3
XTAP_TAPCELL_ROW_63_536 VGND VPWR sky130_fd_sc_hd__tapvpwrvgnd_1
XTAP_TAPCELL_ROW_28_290 VGND VPWR sky130_fd_sc_hd__tapvpwrvgnd_1
XFILLER_33_243 VGND VGND VPWR VPWR sky130_fd_sc_hd__decap_3
XFILLER_33_287 VGND VGND VPWR VPWR sky130_fd_sc_hd__decap_3
XFILLER_33_276 VGND VGND VPWR VPWR sky130_fd_sc_hd__decap_3
XFILLER_56_324 VGND VGND VPWR VPWR sky130_fd_sc_hd__decap_3
XFILLER_17_47 VGND VGND VPWR VPWR sky130_fd_sc_hd__decap_3
XFILLER_56_368 VGND VGND VPWR VPWR sky130_fd_sc_hd__decap_3
XFILLER_56_357 VGND VGND VPWR VPWR sky130_fd_sc_hd__decap_3
XFILLER_24_221 VGND VGND VPWR VPWR sky130_fd_sc_hd__decap_3
XFILLER_12_405 VGND VGND VPWR VPWR sky130_fd_sc_hd__fill_2
XFILLER_24_265 VGND VGND VPWR VPWR sky130_fd_sc_hd__decap_3
XFILLER_24_298 VGND VGND VPWR VPWR sky130_fd_sc_hd__decap_3
XTAP_TAPCELL_ROW_7_1_192 VGND VPWR sky130_fd_sc_hd__tapvpwrvgnd_1
XFILLER_3_125 VGND VGND VPWR VPWR sky130_fd_sc_hd__decap_3
XFILLER_3_169 VGND VGND VPWR VPWR sky130_fd_sc_hd__decap_3
XFILLER_3_158 VGND VGND VPWR VPWR sky130_fd_sc_hd__decap_3
XFILLER_58_21 VGND VGND VPWR VPWR sky130_fd_sc_hd__decap_3
XFILLER_58_32 VGND VGND VPWR VPWR sky130_fd_sc_hd__decap_3
XFILLER_59_162 VGND VGND VPWR VPWR sky130_fd_sc_hd__decap_3
XFILLER_47_302 VGND VGND VPWR VPWR sky130_fd_sc_hd__decap_3
XFILLER_59_184 VGND VGND VPWR VPWR sky130_fd_sc_hd__decap_3
XFILLER_47_346 VGND VGND VPWR VPWR sky130_fd_sc_hd__decap_3
XFILLER_47_335 VGND VGND VPWR VPWR sky130_fd_sc_hd__fill_1
XFILLER_47_379 VGND VGND VPWR VPWR sky130_fd_sc_hd__decap_3
XFILLER_62_327 VGND VGND VPWR VPWR sky130_fd_sc_hd__decap_3
XTAP_TAPCELL_ROW_11_1_204 VGND VPWR sky130_fd_sc_hd__tapvpwrvgnd_1
XTAP_TAPCELL_ROW_60_517 VGND VPWR sky130_fd_sc_hd__tapvpwrvgnd_1
XTAP_TAPCELL_ROW_25_271 VGND VPWR sky130_fd_sc_hd__tapvpwrvgnd_1
XFILLER_30_224 VGND VGND VPWR VPWR sky130_fd_sc_hd__decap_3
XFILLER_30_268 VGND VGND VPWR VPWR sky130_fd_sc_hd__decap_3
X_207_ net57 VGND VGND VPWR VPWR _002_ sky130_fd_sc_hd__inv_2
X_138_ _058_ _059_ VGND VGND VPWR VPWR _060_ sky130_fd_sc_hd__nand2_1
XFILLER_38_324 VGND VGND VPWR VPWR sky130_fd_sc_hd__decap_3
XFILLER_53_305 VGND VGND VPWR VPWR sky130_fd_sc_hd__decap_3
XFILLER_38_368 VGND VGND VPWR VPWR sky130_fd_sc_hd__decap_3
XFILLER_38_357 VGND VGND VPWR VPWR sky130_fd_sc_hd__decap_3
XFILLER_0_50 VGND VGND VPWR VPWR sky130_fd_sc_hd__decap_3
XFILLER_0_72 VGND VGND VPWR VPWR sky130_fd_sc_hd__decap_3
XFILLER_0_94 VGND VGND VPWR VPWR sky130_fd_sc_hd__decap_3
XFILLER_53_349 VGND VGND VPWR VPWR sky130_fd_sc_hd__decap_3
XFILLER_61_393 VGND VGND VPWR VPWR sky130_fd_sc_hd__decap_3
XFILLER_61_382 VGND VGND VPWR VPWR sky130_fd_sc_hd__decap_3
XFILLER_9_81 VGND VGND VPWR VPWR sky130_fd_sc_hd__decap_3
XFILLER_0_106 VGND VGND VPWR VPWR sky130_fd_sc_hd__decap_3
XFILLER_0_128 VGND VGND VPWR VPWR sky130_fd_sc_hd__decap_3
XFILLER_29_302 VGND VGND VPWR VPWR sky130_fd_sc_hd__decap_3
XFILLER_56_121 VGND VGND VPWR VPWR sky130_fd_sc_hd__decap_3
XFILLER_29_346 VGND VGND VPWR VPWR sky130_fd_sc_hd__decap_3
XFILLER_29_335 VGND VGND VPWR VPWR sky130_fd_sc_hd__fill_1
XFILLER_28_57 VGND VGND VPWR VPWR sky130_fd_sc_hd__decap_3
XFILLER_28_24 VGND VGND VPWR VPWR sky130_fd_sc_hd__decap_3
XFILLER_56_165 VGND VGND VPWR VPWR sky130_fd_sc_hd__decap_3
XFILLER_29_379 VGND VGND VPWR VPWR sky130_fd_sc_hd__decap_3
XFILLER_44_327 VGND VGND VPWR VPWR sky130_fd_sc_hd__decap_3
XFILLER_44_12 VGND VGND VPWR VPWR sky130_fd_sc_hd__decap_3
XFILLER_52_371 VGND VGND VPWR VPWR sky130_fd_sc_hd__decap_3
XFILLER_52_360 VGND VGND VPWR VPWR sky130_fd_sc_hd__decap_3
XFILLER_44_56 VGND VGND VPWR VPWR sky130_fd_sc_hd__decap_3
XTAP_TAPCELL_ROW_22_252 VGND VPWR sky130_fd_sc_hd__tapvpwrvgnd_1
XFILLER_60_44 VGND VGND VPWR VPWR sky130_fd_sc_hd__decap_3
XFILLER_60_88 VGND VGND VPWR VPWR sky130_fd_sc_hd__decap_3
XFILLER_60_77 VGND VGND VPWR VPWR sky130_fd_sc_hd__decap_3
XFILLER_10_9 VGND VGND VPWR VPWR sky130_fd_sc_hd__decap_3
XFILLER_47_143 VGND VGND VPWR VPWR sky130_fd_sc_hd__decap_3
XFILLER_35_305 VGND VGND VPWR VPWR sky130_fd_sc_hd__decap_3
XFILLER_47_187 VGND VGND VPWR VPWR sky130_fd_sc_hd__decap_3
XFILLER_62_124 VGND VGND VPWR VPWR sky130_fd_sc_hd__decap_3
XFILLER_35_349 VGND VGND VPWR VPWR sky130_fd_sc_hd__decap_3
XFILLER_62_168 VGND VGND VPWR VPWR sky130_fd_sc_hd__decap_3
XFILLER_43_393 VGND VGND VPWR VPWR sky130_fd_sc_hd__decap_3
XFILLER_43_382 VGND VGND VPWR VPWR sky130_fd_sc_hd__decap_3
XFILLER_38_121 VGND VGND VPWR VPWR sky130_fd_sc_hd__decap_3
XFILLER_26_327 VGND VGND VPWR VPWR sky130_fd_sc_hd__decap_3
XFILLER_53_113 VGND VGND VPWR VPWR sky130_fd_sc_hd__decap_3
XFILLER_53_102 VGND VGND VPWR VPWR sky130_fd_sc_hd__decap_3
XFILLER_38_165 VGND VGND VPWR VPWR sky130_fd_sc_hd__decap_3
XTAP_TAPCELL_ROW_36_344 VGND VPWR sky130_fd_sc_hd__tapvpwrvgnd_1
XFILLER_53_146 VGND VGND VPWR VPWR sky130_fd_sc_hd__decap_3
XFILLER_41_308 VGND VGND VPWR VPWR sky130_fd_sc_hd__decap_3
XFILLER_34_360 VGND VGND VPWR VPWR sky130_fd_sc_hd__decap_3
XFILLER_14_15 VGND VGND VPWR VPWR sky130_fd_sc_hd__decap_3
XFILLER_34_371 VGND VGND VPWR VPWR sky130_fd_sc_hd__decap_3
XFILLER_61_190 VGND VGND VPWR VPWR sky130_fd_sc_hd__decap_3
XFILLER_30_47 VGND VGND VPWR VPWR sky130_fd_sc_hd__decap_3
XFILLER_39_12 VGND VGND VPWR VPWR sky130_fd_sc_hd__decap_3
XFILLER_29_143 VGND VGND VPWR VPWR sky130_fd_sc_hd__decap_3
XFILLER_29_187 VGND VGND VPWR VPWR sky130_fd_sc_hd__decap_3
XFILLER_17_349 VGND VGND VPWR VPWR sky130_fd_sc_hd__decap_3
XFILLER_44_124 VGND VGND VPWR VPWR sky130_fd_sc_hd__decap_3
XFILLER_55_99 VGND VGND VPWR VPWR sky130_fd_sc_hd__decap_3
XFILLER_44_168 VGND VGND VPWR VPWR sky130_fd_sc_hd__decap_3
XFILLER_25_382 VGND VGND VPWR VPWR sky130_fd_sc_hd__decap_3
XFILLER_25_393 VGND VGND VPWR VPWR sky130_fd_sc_hd__decap_3
XFILLER_40_363 VGND VGND VPWR VPWR sky130_fd_sc_hd__fill_1
XFILLER_40_330 VGND VGND VPWR VPWR sky130_fd_sc_hd__decap_3
XFILLER_40_374 VGND VGND VPWR VPWR sky130_fd_sc_hd__decap_3
XFILLER_58_9 VGND VGND VPWR VPWR sky130_fd_sc_hd__decap_3
XFILLER_20_91 VGND VGND VPWR VPWR sky130_fd_sc_hd__decap_3
XFILLER_35_113 VGND VGND VPWR VPWR sky130_fd_sc_hd__decap_3
XFILLER_35_102 VGND VGND VPWR VPWR sky130_fd_sc_hd__fill_1
XFILLER_35_146 VGND VGND VPWR VPWR sky130_fd_sc_hd__decap_3
XFILLER_16_360 VGND VGND VPWR VPWR sky130_fd_sc_hd__decap_3
XFILLER_23_308 VGND VGND VPWR VPWR sky130_fd_sc_hd__decap_3
XFILLER_16_393 VGND VGND VPWR VPWR sky130_fd_sc_hd__decap_3
XTAP_TAPCELL_ROW_33_325 VGND VPWR sky130_fd_sc_hd__tapvpwrvgnd_1
XFILLER_50_127 VGND VGND VPWR VPWR sky130_fd_sc_hd__decap_3
XFILLER_43_190 VGND VGND VPWR VPWR sky130_fd_sc_hd__decap_3
XFILLER_31_352 VGND VGND VPWR VPWR sky130_fd_sc_hd__decap_3
XFILLER_31_396 VGND VGND VPWR VPWR sky130_fd_sc_hd__decap_3
XFILLER_31_385 VGND VGND VPWR VPWR sky130_fd_sc_hd__decap_3
XTAP_TAPCELL_ROW_41_380 VGND VPWR sky130_fd_sc_hd__tapvpwrvgnd_1
XFILLER_6_82 VGND VGND VPWR VPWR sky130_fd_sc_hd__fill_2
Xpmu_inst_63 VGND VGND VPWR VPWR pmu_inst_63/HI net63 sky130_fd_sc_hd__conb_1
Xpmu_inst_74 VGND VGND VPWR VPWR pmu_inst_74/HI net74 sky130_fd_sc_hd__conb_1
XFILLER_58_227 VGND VGND VPWR VPWR sky130_fd_sc_hd__decap_3
XFILLER_26_124 VGND VGND VPWR VPWR sky130_fd_sc_hd__decap_3
XFILLER_25_36 VGND VGND VPWR VPWR sky130_fd_sc_hd__decap_3
XFILLER_26_168 VGND VGND VPWR VPWR sky130_fd_sc_hd__decap_3
XFILLER_41_105 VGND VGND VPWR VPWR sky130_fd_sc_hd__decap_3
XFILLER_41_116 VGND VGND VPWR VPWR sky130_fd_sc_hd__decap_3
XFILLER_22_330 VGND VGND VPWR VPWR sky130_fd_sc_hd__decap_3
XFILLER_41_149 VGND VGND VPWR VPWR sky130_fd_sc_hd__decap_3
XFILLER_22_363 VGND VGND VPWR VPWR sky130_fd_sc_hd__fill_1
XFILLER_22_374 VGND VGND VPWR VPWR sky130_fd_sc_hd__decap_3
XFILLER_49_205 VGND VGND VPWR VPWR sky130_fd_sc_hd__decap_3
XFILLER_2_29 VGND VGND VPWR VPWR sky130_fd_sc_hd__decap_3
XFILLER_2_18 VGND VGND VPWR VPWR sky130_fd_sc_hd__decap_3
XFILLER_49_249 VGND VGND VPWR VPWR sky130_fd_sc_hd__decap_3
XFILLER_17_113 VGND VGND VPWR VPWR sky130_fd_sc_hd__decap_3
XFILLER_17_146 VGND VGND VPWR VPWR sky130_fd_sc_hd__decap_3
XTAP_TAPCELL_ROW_55_483 VGND VPWR sky130_fd_sc_hd__tapvpwrvgnd_1
XFILLER_32_138 VGND VGND VPWR VPWR sky130_fd_sc_hd__fill_2
XFILLER_13_352 VGND VGND VPWR VPWR sky130_fd_sc_hd__decap_3
XFILLER_25_190 VGND VGND VPWR VPWR sky130_fd_sc_hd__decap_3
XFILLER_13_385 VGND VGND VPWR VPWR sky130_fd_sc_hd__decap_3
XFILLER_9_334 VGND VGND VPWR VPWR sky130_fd_sc_hd__decap_3
XTAP_TAPCELL_ROW_30_306 VGND VPWR sky130_fd_sc_hd__tapvpwrvgnd_1
XFILLER_40_171 VGND VGND VPWR VPWR sky130_fd_sc_hd__decap_3
XFILLER_9_367 VGND VGND VPWR VPWR sky130_fd_sc_hd__decap_3
XFILLER_63_7 VGND VGND VPWR VPWR sky130_fd_sc_hd__decap_3
XPHY_EDGE_ROW_8_1_Right_7 VGND VGND VPWR VPWR sky130_fd_sc_hd__decap_3
XFILLER_56_6 VGND VGND VPWR VPWR sky130_fd_sc_hd__decap_3
XFILLER_31_90 VGND VGND VPWR VPWR sky130_fd_sc_hd__decap_3
XFILLER_55_208 VGND VGND VPWR VPWR sky130_fd_sc_hd__decap_3
XFILLER_48_271 VGND VGND VPWR VPWR sky130_fd_sc_hd__decap_3
XFILLER_63_252 VGND VGND VPWR VPWR sky130_fd_sc_hd__decap_3
XFILLER_23_105 VGND VGND VPWR VPWR sky130_fd_sc_hd__decap_3
XFILLER_23_116 VGND VGND VPWR VPWR sky130_fd_sc_hd__decap_3
XFILLER_63_296 VGND VGND VPWR VPWR sky130_fd_sc_hd__decap_3
XFILLER_23_149 VGND VGND VPWR VPWR sky130_fd_sc_hd__decap_3
XFILLER_31_193 VGND VGND VPWR VPWR sky130_fd_sc_hd__decap_3
XFILLER_11_27 VGND VGND VPWR VPWR sky130_fd_sc_hd__decap_3
XFILLER_54_230 VGND VGND VPWR VPWR sky130_fd_sc_hd__decap_3
XFILLER_39_293 VGND VGND VPWR VPWR sky130_fd_sc_hd__decap_3
XFILLER_36_24 VGND VGND VPWR VPWR sky130_fd_sc_hd__decap_3
XFILLER_36_57 VGND VGND VPWR VPWR sky130_fd_sc_hd__decap_3
XFILLER_14_127 VGND VGND VPWR VPWR sky130_fd_sc_hd__decap_3
XFILLER_54_274 VGND VGND VPWR VPWR sky130_fd_sc_hd__decap_3
X_240_ net56 VGND VGND VPWR VPWR _035_ sky130_fd_sc_hd__inv_2
XFILLER_22_171 VGND VGND VPWR VPWR sky130_fd_sc_hd__decap_3
X_171_ genblk1\[9\].fa_inst.b genblk1\[9\].fa_inst.a VGND VGND VPWR VPWR _086_ sky130_fd_sc_hd__nand2_1
XFILLER_52_78 VGND VGND VPWR VPWR sky130_fd_sc_hd__decap_3
XFILLER_10_366 VGND VGND VPWR VPWR sky130_fd_sc_hd__decap_3
XFILLER_10_399 VGND VGND VPWR VPWR sky130_fd_sc_hd__decap_3
XFILLER_6_337 VGND VGND VPWR VPWR sky130_fd_sc_hd__decap_3
XTAP_TAPCELL_ROW_8_1_194 VGND VPWR sky130_fd_sc_hd__tapvpwrvgnd_1
XFILLER_37_208 VGND VGND VPWR VPWR sky130_fd_sc_hd__decap_3
XFILLER_45_252 VGND VGND VPWR VPWR sky130_fd_sc_hd__decap_3
XFILLER_60_200 VGND VGND VPWR VPWR sky130_fd_sc_hd__decap_3
XFILLER_45_296 VGND VGND VPWR VPWR sky130_fd_sc_hd__decap_3
XFILLER_60_233 VGND VGND VPWR VPWR sky130_fd_sc_hd__decap_3
XFILLER_60_277 VGND VGND VPWR VPWR sky130_fd_sc_hd__decap_3
XFILLER_9_131 VGND VGND VPWR VPWR sky130_fd_sc_hd__decap_3
XFILLER_9_164 VGND VGND VPWR VPWR sky130_fd_sc_hd__decap_3
XFILLER_9_175 VGND VGND VPWR VPWR sky130_fd_sc_hd__decap_3
XFILLER_5_370 VGND VGND VPWR VPWR sky130_fd_sc_hd__decap_3
XTAP_TAPCELL_ROW_12_1_206 VGND VPWR sky130_fd_sc_hd__tapvpwrvgnd_1
XTAP_TAPCELL_ROW_20_1_230 VGND VPWR sky130_fd_sc_hd__tapvpwrvgnd_1
XFILLER_3_72 VGND VGND VPWR VPWR sky130_fd_sc_hd__decap_3
XFILLER_36_230 VGND VGND VPWR VPWR sky130_fd_sc_hd__decap_3
XFILLER_51_211 VGND VGND VPWR VPWR sky130_fd_sc_hd__decap_3
XFILLER_36_274 VGND VGND VPWR VPWR sky130_fd_sc_hd__decap_3
XFILLER_51_255 VGND VGND VPWR VPWR sky130_fd_sc_hd__decap_3
XFILLER_11_119 VGND VGND VPWR VPWR sky130_fd_sc_hd__decap_3
XFILLER_22_15 VGND VGND VPWR VPWR sky130_fd_sc_hd__decap_3
XFILLER_51_299 VGND VGND VPWR VPWR sky130_fd_sc_hd__decap_3
XFILLER_22_59 VGND VGND VPWR VPWR sky130_fd_sc_hd__fill_2
XFILLER_59_311 VGND VGND VPWR VPWR sky130_fd_sc_hd__decap_3
XFILLER_59_355 VGND VGND VPWR VPWR sky130_fd_sc_hd__decap_3
XFILLER_47_12 VGND VGND VPWR VPWR sky130_fd_sc_hd__decap_3
XFILLER_59_388 VGND VGND VPWR VPWR sky130_fd_sc_hd__decap_3
XFILLER_47_45 VGND VGND VPWR VPWR sky130_fd_sc_hd__decap_3
XFILLER_59_399 VGND VGND VPWR VPWR sky130_fd_sc_hd__decap_3
XFILLER_47_78 VGND VGND VPWR VPWR sky130_fd_sc_hd__decap_3
XFILLER_27_252 VGND VGND VPWR VPWR sky130_fd_sc_hd__decap_3
XFILLER_15_403 VGND VGND VPWR VPWR sky130_fd_sc_hd__decap_3
XFILLER_27_296 VGND VGND VPWR VPWR sky130_fd_sc_hd__decap_3
XFILLER_63_22 VGND VGND VPWR VPWR sky130_fd_sc_hd__decap_3
XFILLER_42_200 VGND VGND VPWR VPWR sky130_fd_sc_hd__decap_3
XFILLER_63_55 VGND VGND VPWR VPWR sky130_fd_sc_hd__fill_1
XFILLER_63_66 VGND VGND VPWR VPWR sky130_fd_sc_hd__decap_3
XFILLER_42_233 VGND VGND VPWR VPWR sky130_fd_sc_hd__decap_3
XFILLER_63_99 VGND VGND VPWR VPWR sky130_fd_sc_hd__decap_3
XFILLER_42_277 VGND VGND VPWR VPWR sky130_fd_sc_hd__decap_3
X_223_ net56 VGND VGND VPWR VPWR _018_ sky130_fd_sc_hd__inv_2
XFILLER_10_130 VGND VGND VPWR VPWR sky130_fd_sc_hd__decap_3
XFILLER_10_141 VGND VGND VPWR VPWR sky130_fd_sc_hd__decap_3
XFILLER_10_174 VGND VGND VPWR VPWR sky130_fd_sc_hd__decap_3
XFILLER_6_112 VGND VGND VPWR VPWR sky130_fd_sc_hd__decap_3
XPHY_EDGE_ROW_38_Right_59 VGND VGND VPWR VPWR sky130_fd_sc_hd__decap_3
X_154_ _071_ _072_ VGND VGND VPWR VPWR genblk1\[5\].fa_inst.s sky130_fd_sc_hd__xnor2_1
XFILLER_6_156 VGND VGND VPWR VPWR sky130_fd_sc_hd__decap_3
XFILLER_40_9 VGND VGND VPWR VPWR sky130_fd_sc_hd__decap_3
XFILLER_2_340 VGND VGND VPWR VPWR sky130_fd_sc_hd__decap_3
XFILLER_2_384 VGND VGND VPWR VPWR sky130_fd_sc_hd__decap_3
XFILLER_19_6 VGND VGND VPWR VPWR sky130_fd_sc_hd__decap_3
XPHY_EDGE_ROW_47_Right_68 VGND VGND VPWR VPWR sky130_fd_sc_hd__decap_3
XTAP_TAPCELL_ROW_63_537 VGND VPWR sky130_fd_sc_hd__tapvpwrvgnd_1
XFILLER_33_211 VGND VGND VPWR VPWR sky130_fd_sc_hd__decap_3
XTAP_TAPCELL_ROW_28_291 VGND VPWR sky130_fd_sc_hd__tapvpwrvgnd_1
XFILLER_33_255 VGND VGND VPWR VPWR sky130_fd_sc_hd__decap_3
XPHY_EDGE_ROW_56_Right_77 VGND VGND VPWR VPWR sky130_fd_sc_hd__decap_3
XFILLER_33_299 VGND VGND VPWR VPWR sky130_fd_sc_hd__decap_3
XPHY_EDGE_ROW_20_2_Left_41 VGND VGND VPWR VPWR sky130_fd_sc_hd__decap_3
XFILLER_56_336 VGND VGND VPWR VPWR sky130_fd_sc_hd__decap_3
XFILLER_24_200 VGND VGND VPWR VPWR sky130_fd_sc_hd__decap_3
XFILLER_64_380 VGND VGND VPWR VPWR sky130_fd_sc_hd__decap_3
XFILLER_24_233 VGND VGND VPWR VPWR sky130_fd_sc_hd__decap_3
XFILLER_24_277 VGND VGND VPWR VPWR sky130_fd_sc_hd__decap_3
XFILLER_33_36 VGND VGND VPWR VPWR sky130_fd_sc_hd__decap_3
XFILLER_3_137 VGND VGND VPWR VPWR sky130_fd_sc_hd__decap_3
XFILLER_58_44 VGND VGND VPWR VPWR sky130_fd_sc_hd__decap_3
XFILLER_59_141 VGND VGND VPWR VPWR sky130_fd_sc_hd__decap_3
XFILLER_58_88 VGND VGND VPWR VPWR sky130_fd_sc_hd__decap_3
XFILLER_58_66 VGND VGND VPWR VPWR sky130_fd_sc_hd__decap_3
XFILLER_59_196 VGND VGND VPWR VPWR sky130_fd_sc_hd__decap_3
XFILLER_47_314 VGND VGND VPWR VPWR sky130_fd_sc_hd__decap_3
XFILLER_47_358 VGND VGND VPWR VPWR sky130_fd_sc_hd__decap_3
XFILLER_62_339 VGND VGND VPWR VPWR sky130_fd_sc_hd__decap_3
XFILLER_55_391 VGND VGND VPWR VPWR sky130_fd_sc_hd__fill_1
XTAP_TAPCELL_ROW_60_518 VGND VPWR sky130_fd_sc_hd__tapvpwrvgnd_1
XFILLER_30_203 VGND VGND VPWR VPWR sky130_fd_sc_hd__decap_3
XTAP_TAPCELL_ROW_25_272 VGND VPWR sky130_fd_sc_hd__tapvpwrvgnd_1
XFILLER_30_236 VGND VGND VPWR VPWR sky130_fd_sc_hd__decap_3
X_206_ net57 VGND VGND VPWR VPWR _001_ sky130_fd_sc_hd__inv_2
X_137_ genblk1\[2\].fa_inst.b genblk1\[2\].fa_inst.a VGND VGND VPWR VPWR _059_ sky130_fd_sc_hd__nand2_1
XFILLER_17_3 VGND VGND VPWR VPWR sky130_fd_sc_hd__decap_3
XFILLER_38_336 VGND VGND VPWR VPWR sky130_fd_sc_hd__decap_3
XFILLER_53_317 VGND VGND VPWR VPWR sky130_fd_sc_hd__decap_3
XFILLER_46_380 VGND VGND VPWR VPWR sky130_fd_sc_hd__decap_3
XFILLER_21_203 VGND VGND VPWR VPWR sky130_fd_sc_hd__decap_3
XFILLER_61_361 VGND VGND VPWR VPWR sky130_fd_sc_hd__decap_3
XFILLER_21_269 VGND VGND VPWR VPWR sky130_fd_sc_hd__decap_3
XFILLER_9_60 VGND VGND VPWR VPWR sky130_fd_sc_hd__decap_3
XFILLER_9_93 VGND VGND VPWR VPWR sky130_fd_sc_hd__decap_3
XFILLER_56_100 VGND VGND VPWR VPWR sky130_fd_sc_hd__decap_3
XFILLER_29_314 VGND VGND VPWR VPWR sky130_fd_sc_hd__decap_3
XFILLER_28_36 VGND VGND VPWR VPWR sky130_fd_sc_hd__decap_3
XFILLER_56_144 VGND VGND VPWR VPWR sky130_fd_sc_hd__decap_3
XFILLER_56_133 VGND VGND VPWR VPWR sky130_fd_sc_hd__decap_3
XFILLER_29_358 VGND VGND VPWR VPWR sky130_fd_sc_hd__decap_3
XFILLER_56_177 VGND VGND VPWR VPWR sky130_fd_sc_hd__decap_3
XFILLER_44_339 VGND VGND VPWR VPWR sky130_fd_sc_hd__decap_3
XFILLER_44_35 VGND VGND VPWR VPWR sky130_fd_sc_hd__decap_3
XFILLER_44_24 VGND VGND VPWR VPWR sky130_fd_sc_hd__decap_3
XFILLER_37_391 VGND VGND VPWR VPWR sky130_fd_sc_hd__fill_1
XFILLER_44_68 VGND VGND VPWR VPWR sky130_fd_sc_hd__fill_2
XFILLER_52_383 VGND VGND VPWR VPWR sky130_fd_sc_hd__decap_3
XFILLER_60_56 VGND VGND VPWR VPWR sky130_fd_sc_hd__decap_3
XFILLER_4_402 VGND VGND VPWR VPWR sky130_fd_sc_hd__decap_3
XFILLER_47_122 VGND VGND VPWR VPWR sky130_fd_sc_hd__decap_3
XFILLER_47_111 VGND VGND VPWR VPWR sky130_fd_sc_hd__fill_1
XFILLER_47_155 VGND VGND VPWR VPWR sky130_fd_sc_hd__decap_3
XFILLER_18_80 VGND VGND VPWR VPWR sky130_fd_sc_hd__decap_3
XFILLER_62_103 VGND VGND VPWR VPWR sky130_fd_sc_hd__decap_3
XFILLER_35_317 VGND VGND VPWR VPWR sky130_fd_sc_hd__decap_3
XFILLER_18_91 VGND VGND VPWR VPWR sky130_fd_sc_hd__decap_3
XFILLER_62_147 VGND VGND VPWR VPWR sky130_fd_sc_hd__decap_3
XFILLER_62_136 VGND VGND VPWR VPWR sky130_fd_sc_hd__decap_3
XFILLER_47_199 VGND VGND VPWR VPWR sky130_fd_sc_hd__decap_3
XFILLER_28_380 VGND VGND VPWR VPWR sky130_fd_sc_hd__decap_3
XFILLER_50_309 VGND VGND VPWR VPWR sky130_fd_sc_hd__decap_3
XFILLER_43_361 VGND VGND VPWR VPWR sky130_fd_sc_hd__decap_3
XFILLER_38_100 VGND VGND VPWR VPWR sky130_fd_sc_hd__decap_3
XFILLER_38_144 VGND VGND VPWR VPWR sky130_fd_sc_hd__decap_3
XFILLER_38_133 VGND VGND VPWR VPWR sky130_fd_sc_hd__decap_3
XFILLER_38_177 VGND VGND VPWR VPWR sky130_fd_sc_hd__decap_3
XFILLER_19_391 VGND VGND VPWR VPWR sky130_fd_sc_hd__decap_3
XFILLER_26_339 VGND VGND VPWR VPWR sky130_fd_sc_hd__decap_3
XFILLER_53_125 VGND VGND VPWR VPWR sky130_fd_sc_hd__decap_3
XTAP_TAPCELL_ROW_36_345 VGND VPWR sky130_fd_sc_hd__tapvpwrvgnd_1
XFILLER_53_169 VGND VGND VPWR VPWR sky130_fd_sc_hd__decap_3
XFILLER_53_158 VGND VGND VPWR VPWR sky130_fd_sc_hd__decap_3
XFILLER_34_383 VGND VGND VPWR VPWR sky130_fd_sc_hd__decap_3
XFILLER_14_38 VGND VGND VPWR VPWR sky130_fd_sc_hd__decap_3
XFILLER_30_15 VGND VGND VPWR VPWR sky130_fd_sc_hd__decap_3
XFILLER_30_59 VGND VGND VPWR VPWR sky130_fd_sc_hd__decap_3
XFILLER_39_57 VGND VGND VPWR VPWR sky130_fd_sc_hd__decap_3
XFILLER_29_122 VGND VGND VPWR VPWR sky130_fd_sc_hd__decap_3
XFILLER_17_328 VGND VGND VPWR VPWR sky130_fd_sc_hd__decap_3
XFILLER_55_34 VGND VGND VPWR VPWR sky130_fd_sc_hd__decap_3
XFILLER_55_12 VGND VGND VPWR VPWR sky130_fd_sc_hd__fill_2
XFILLER_29_155 VGND VGND VPWR VPWR sky130_fd_sc_hd__decap_3
XFILLER_44_147 VGND VGND VPWR VPWR sky130_fd_sc_hd__decap_3
XFILLER_44_136 VGND VGND VPWR VPWR sky130_fd_sc_hd__decap_3
XFILLER_29_199 VGND VGND VPWR VPWR sky130_fd_sc_hd__decap_3
XFILLER_25_361 VGND VGND VPWR VPWR sky130_fd_sc_hd__decap_3
XFILLER_32_309 VGND VGND VPWR VPWR sky130_fd_sc_hd__decap_3
XFILLER_52_180 VGND VGND VPWR VPWR sky130_fd_sc_hd__decap_3
XFILLER_40_342 VGND VGND VPWR VPWR sky130_fd_sc_hd__decap_3
XFILLER_40_386 VGND VGND VPWR VPWR sky130_fd_sc_hd__decap_3
XFILLER_29_90 VGND VGND VPWR VPWR sky130_fd_sc_hd__decap_3
XFILLER_35_125 VGND VGND VPWR VPWR sky130_fd_sc_hd__decap_3
XFILLER_50_106 VGND VGND VPWR VPWR sky130_fd_sc_hd__decap_3
XFILLER_35_169 VGND VGND VPWR VPWR sky130_fd_sc_hd__decap_3
XFILLER_35_158 VGND VGND VPWR VPWR sky130_fd_sc_hd__decap_3
XFILLER_16_372 VGND VGND VPWR VPWR sky130_fd_sc_hd__decap_3
XTAP_TAPCELL_ROW_33_326 VGND VPWR sky130_fd_sc_hd__tapvpwrvgnd_1
XFILLER_50_139 VGND VGND VPWR VPWR sky130_fd_sc_hd__fill_1
XFILLER_31_320 VGND VGND VPWR VPWR sky130_fd_sc_hd__decap_3
XTAP_TAPCELL_ROW_9_1_196 VGND VPWR sky130_fd_sc_hd__tapvpwrvgnd_1
XFILLER_31_364 VGND VGND VPWR VPWR sky130_fd_sc_hd__decap_3
XTAP_TAPCELL_ROW_41_381 VGND VPWR sky130_fd_sc_hd__tapvpwrvgnd_1
XFILLER_6_50 VGND VGND VPWR VPWR sky130_fd_sc_hd__decap_3
XFILLER_6_94 VGND VGND VPWR VPWR sky130_fd_sc_hd__decap_3
Xpmu_inst_64 VGND VGND VPWR VPWR pmu_inst_64/HI net64 sky130_fd_sc_hd__conb_1
XFILLER_58_206 VGND VGND VPWR VPWR sky130_fd_sc_hd__decap_3
XFILLER_58_239 VGND VGND VPWR VPWR sky130_fd_sc_hd__decap_3
XFILLER_26_103 VGND VGND VPWR VPWR sky130_fd_sc_hd__decap_3
XFILLER_54_401 VGND VGND VPWR VPWR sky130_fd_sc_hd__decap_3
XFILLER_26_136 VGND VGND VPWR VPWR sky130_fd_sc_hd__decap_3
XPHY_EDGE_ROW_0_2_Left_21 VGND VGND VPWR VPWR sky130_fd_sc_hd__decap_3
XFILLER_25_15 VGND VGND VPWR VPWR sky130_fd_sc_hd__fill_1
XFILLER_26_147 VGND VGND VPWR VPWR sky130_fd_sc_hd__decap_3
XTAP_TAPCELL_ROW_13_1_208 VGND VPWR sky130_fd_sc_hd__tapvpwrvgnd_1
XFILLER_25_48 VGND VGND VPWR VPWR sky130_fd_sc_hd__decap_3
XFILLER_41_128 VGND VGND VPWR VPWR sky130_fd_sc_hd__decap_3
XFILLER_22_342 VGND VGND VPWR VPWR sky130_fd_sc_hd__decap_3
XFILLER_34_180 VGND VGND VPWR VPWR sky130_fd_sc_hd__decap_3
XFILLER_22_386 VGND VGND VPWR VPWR sky130_fd_sc_hd__decap_3
XFILLER_41_47 VGND VGND VPWR VPWR sky130_fd_sc_hd__decap_3
XFILLER_49_228 VGND VGND VPWR VPWR sky130_fd_sc_hd__decap_3
XFILLER_49_217 VGND VGND VPWR VPWR sky130_fd_sc_hd__decap_3
XFILLER_64_209 VGND VGND VPWR VPWR sky130_fd_sc_hd__decap_3
XFILLER_57_261 VGND VGND VPWR VPWR sky130_fd_sc_hd__decap_3
XFILLER_17_125 VGND VGND VPWR VPWR sky130_fd_sc_hd__decap_3
XFILLER_17_158 VGND VGND VPWR VPWR sky130_fd_sc_hd__decap_3
XFILLER_17_169 VGND VGND VPWR VPWR sky130_fd_sc_hd__decap_3
XFILLER_60_404 VGND VGND VPWR VPWR sky130_fd_sc_hd__decap_3
XFILLER_32_117 VGND VGND VPWR VPWR sky130_fd_sc_hd__decap_3
XFILLER_13_331 VGND VGND VPWR VPWR sky130_fd_sc_hd__decap_3
XFILLER_13_364 VGND VGND VPWR VPWR sky130_fd_sc_hd__decap_3
XFILLER_15_81 VGND VGND VPWR VPWR sky130_fd_sc_hd__decap_3
XTAP_TAPCELL_ROW_30_307 VGND VPWR sky130_fd_sc_hd__tapvpwrvgnd_1
XFILLER_40_150 VGND VGND VPWR VPWR sky130_fd_sc_hd__decap_3
XFILLER_13_397 VGND VGND VPWR VPWR sky130_fd_sc_hd__decap_3
XFILLER_9_346 VGND VGND VPWR VPWR sky130_fd_sc_hd__decap_3
XFILLER_40_183 VGND VGND VPWR VPWR sky130_fd_sc_hd__decap_3
XFILLER_9_379 VGND VGND VPWR VPWR sky130_fd_sc_hd__fill_2
XFILLER_49_6 VGND VGND VPWR VPWR sky130_fd_sc_hd__decap_3
XPHY_EDGE_ROW_16_1_Left_122 VGND VGND VPWR VPWR sky130_fd_sc_hd__decap_3
XFILLER_36_401 VGND VGND VPWR VPWR sky130_fd_sc_hd__decap_3
XFILLER_63_220 VGND VGND VPWR VPWR sky130_fd_sc_hd__decap_3
XFILLER_48_283 VGND VGND VPWR VPWR sky130_fd_sc_hd__decap_3
XFILLER_63_231 VGND VGND VPWR VPWR sky130_fd_sc_hd__decap_3
XFILLER_63_264 VGND VGND VPWR VPWR sky130_fd_sc_hd__decap_3
XFILLER_23_128 VGND VGND VPWR VPWR sky130_fd_sc_hd__decap_3
XFILLER_31_161 VGND VGND VPWR VPWR sky130_fd_sc_hd__decap_3
XFILLER_31_172 VGND VGND VPWR VPWR sky130_fd_sc_hd__decap_3
XFILLER_11_39 VGND VGND VPWR VPWR sky130_fd_sc_hd__decap_3
XFILLER_8_390 VGND VGND VPWR VPWR sky130_fd_sc_hd__decap_3
XFILLER_46_209 VGND VGND VPWR VPWR sky130_fd_sc_hd__decap_3
XFILLER_39_261 VGND VGND VPWR VPWR sky130_fd_sc_hd__decap_3
XFILLER_36_36 VGND VGND VPWR VPWR sky130_fd_sc_hd__decap_3
XFILLER_54_253 VGND VGND VPWR VPWR sky130_fd_sc_hd__decap_3
XFILLER_54_242 VGND VGND VPWR VPWR sky130_fd_sc_hd__decap_3
XFILLER_42_404 VGND VGND VPWR VPWR sky130_fd_sc_hd__decap_3
XFILLER_14_106 VGND VGND VPWR VPWR sky130_fd_sc_hd__decap_3
XFILLER_54_286 VGND VGND VPWR VPWR sky130_fd_sc_hd__decap_3
XFILLER_14_139 VGND VGND VPWR VPWR sky130_fd_sc_hd__fill_1
XFILLER_22_150 VGND VGND VPWR VPWR sky130_fd_sc_hd__decap_3
XFILLER_52_35 VGND VGND VPWR VPWR sky130_fd_sc_hd__decap_3
XFILLER_10_334 VGND VGND VPWR VPWR sky130_fd_sc_hd__decap_3
XFILLER_22_183 VGND VGND VPWR VPWR sky130_fd_sc_hd__decap_3
X_170_ genblk1\[9\].fa_inst.b genblk1\[9\].fa_inst.a VGND VGND VPWR VPWR _085_ sky130_fd_sc_hd__or2_1
XFILLER_10_378 VGND VGND VPWR VPWR sky130_fd_sc_hd__decap_3
XFILLER_6_349 VGND VGND VPWR VPWR sky130_fd_sc_hd__decap_3
XTAP_TAPCELL_ROW_8_1_195 VGND VPWR sky130_fd_sc_hd__tapvpwrvgnd_1
XFILLER_45_220 VGND VGND VPWR VPWR sky130_fd_sc_hd__decap_3
XFILLER_45_231 VGND VGND VPWR VPWR sky130_fd_sc_hd__decap_3
XFILLER_60_212 VGND VGND VPWR VPWR sky130_fd_sc_hd__decap_3
XFILLER_45_264 VGND VGND VPWR VPWR sky130_fd_sc_hd__decap_3
XFILLER_26_91 VGND VGND VPWR VPWR sky130_fd_sc_hd__decap_3
XFILLER_60_256 VGND VGND VPWR VPWR sky130_fd_sc_hd__decap_3
XFILLER_60_245 VGND VGND VPWR VPWR sky130_fd_sc_hd__decap_3
XFILLER_60_289 VGND VGND VPWR VPWR sky130_fd_sc_hd__decap_3
XFILLER_13_161 VGND VGND VPWR VPWR sky130_fd_sc_hd__decap_3
XFILLER_13_172 VGND VGND VPWR VPWR sky130_fd_sc_hd__decap_3
XFILLER_9_143 VGND VGND VPWR VPWR sky130_fd_sc_hd__decap_3
X_299_ clknet_2_3__leaf_clk_regs net19 _044_ VGND VGND VPWR VPWR genblk1\[11\].fa_inst.b
+ sky130_fd_sc_hd__dfrtp_1
XFILLER_5_382 VGND VGND VPWR VPWR sky130_fd_sc_hd__decap_3
XTAP_TAPCELL_ROW_12_1_207 VGND VPWR sky130_fd_sc_hd__tapvpwrvgnd_1
XFILLER_47_3 VGND VGND VPWR VPWR sky130_fd_sc_hd__decap_3
XTAP_TAPCELL_ROW_20_1_231 VGND VPWR sky130_fd_sc_hd__tapvpwrvgnd_1
XFILLER_3_84 VGND VGND VPWR VPWR sky130_fd_sc_hd__decap_3
XFILLER_28_209 VGND VGND VPWR VPWR sky130_fd_sc_hd__decap_3
XFILLER_36_253 VGND VGND VPWR VPWR sky130_fd_sc_hd__decap_3
XFILLER_36_242 VGND VGND VPWR VPWR sky130_fd_sc_hd__decap_3
XFILLER_24_404 VGND VGND VPWR VPWR sky130_fd_sc_hd__decap_3
XFILLER_36_286 VGND VGND VPWR VPWR sky130_fd_sc_hd__decap_3
XFILLER_51_234 VGND VGND VPWR VPWR sky130_fd_sc_hd__decap_3
XFILLER_51_223 VGND VGND VPWR VPWR sky130_fd_sc_hd__fill_1
XFILLER_51_267 VGND VGND VPWR VPWR sky130_fd_sc_hd__decap_3
XFILLER_22_27 VGND VGND VPWR VPWR sky130_fd_sc_hd__fill_1
XFILLER_22_38 VGND VGND VPWR VPWR sky130_fd_sc_hd__decap_3
XFILLER_0_9 VGND VGND VPWR VPWR sky130_fd_sc_hd__decap_3
XFILLER_59_323 VGND VGND VPWR VPWR sky130_fd_sc_hd__decap_3
XFILLER_59_367 VGND VGND VPWR VPWR sky130_fd_sc_hd__decap_3
XFILLER_47_24 VGND VGND VPWR VPWR sky130_fd_sc_hd__decap_3
XFILLER_47_57 VGND VGND VPWR VPWR sky130_fd_sc_hd__decap_3
XFILLER_27_220 VGND VGND VPWR VPWR sky130_fd_sc_hd__decap_3
XFILLER_27_231 VGND VGND VPWR VPWR sky130_fd_sc_hd__decap_3
XFILLER_27_264 VGND VGND VPWR VPWR sky130_fd_sc_hd__decap_3
XFILLER_42_212 VGND VGND VPWR VPWR sky130_fd_sc_hd__decap_3
XFILLER_63_34 VGND VGND VPWR VPWR sky130_fd_sc_hd__decap_3
XFILLER_42_245 VGND VGND VPWR VPWR sky130_fd_sc_hd__decap_3
XFILLER_63_78 VGND VGND VPWR VPWR sky130_fd_sc_hd__decap_3
XFILLER_42_256 VGND VGND VPWR VPWR sky130_fd_sc_hd__decap_3
XFILLER_8_18 VGND VGND VPWR VPWR sky130_fd_sc_hd__decap_3
XFILLER_8_29 VGND VGND VPWR VPWR sky130_fd_sc_hd__decap_3
X_222_ net56 VGND VGND VPWR VPWR _017_ sky130_fd_sc_hd__inv_2
XFILLER_42_289 VGND VGND VPWR VPWR sky130_fd_sc_hd__decap_3
XFILLER_10_153 VGND VGND VPWR VPWR sky130_fd_sc_hd__decap_3
XFILLER_6_124 VGND VGND VPWR VPWR sky130_fd_sc_hd__decap_3
X_153_ _065_ _068_ _066_ VGND VGND VPWR VPWR _072_ sky130_fd_sc_hd__a21bo_1
XFILLER_12_71 VGND VGND VPWR VPWR sky130_fd_sc_hd__decap_3
XFILLER_6_168 VGND VGND VPWR VPWR sky130_fd_sc_hd__decap_3
XFILLER_33_9 VGND VGND VPWR VPWR sky130_fd_sc_hd__decap_3
XFILLER_2_363 VGND VGND VPWR VPWR sky130_fd_sc_hd__decap_3
XFILLER_2_352 VGND VGND VPWR VPWR sky130_fd_sc_hd__fill_1
XFILLER_2_396 VGND VGND VPWR VPWR sky130_fd_sc_hd__decap_3
XTAP_TAPCELL_ROW_28_292 VGND VPWR sky130_fd_sc_hd__tapvpwrvgnd_1
XTAP_TAPCELL_ROW_63_538 VGND VPWR sky130_fd_sc_hd__tapvpwrvgnd_1
XFILLER_33_234 VGND VGND VPWR VPWR sky130_fd_sc_hd__decap_3
XFILLER_33_223 VGND VGND VPWR VPWR sky130_fd_sc_hd__fill_1
XFILLER_33_267 VGND VGND VPWR VPWR sky130_fd_sc_hd__decap_3
XFILLER_56_304 VGND VGND VPWR VPWR sky130_fd_sc_hd__decap_3
XFILLER_56_315 VGND VGND VPWR VPWR sky130_fd_sc_hd__decap_3
XFILLER_17_38 VGND VGND VPWR VPWR sky130_fd_sc_hd__decap_3
XFILLER_56_348 VGND VGND VPWR VPWR sky130_fd_sc_hd__decap_3
XFILLER_24_212 VGND VGND VPWR VPWR sky130_fd_sc_hd__decap_3
XFILLER_24_245 VGND VGND VPWR VPWR sky130_fd_sc_hd__decap_3
XFILLER_24_256 VGND VGND VPWR VPWR sky130_fd_sc_hd__decap_3
XFILLER_33_15 VGND VGND VPWR VPWR sky130_fd_sc_hd__fill_1
XFILLER_24_289 VGND VGND VPWR VPWR sky130_fd_sc_hd__decap_3
XFILLER_33_48 VGND VGND VPWR VPWR sky130_fd_sc_hd__decap_3
XFILLER_3_116 VGND VGND VPWR VPWR sky130_fd_sc_hd__decap_3
XFILLER_3_149 VGND VGND VPWR VPWR sky130_fd_sc_hd__decap_3
XFILLER_58_12 VGND VGND VPWR VPWR sky130_fd_sc_hd__decap_3
XFILLER_59_120 VGND VGND VPWR VPWR sky130_fd_sc_hd__decap_3
XFILLER_59_153 VGND VGND VPWR VPWR sky130_fd_sc_hd__decap_3
XFILLER_58_78 VGND VGND VPWR VPWR sky130_fd_sc_hd__decap_3
XFILLER_59_175 VGND VGND VPWR VPWR sky130_fd_sc_hd__decap_3
XFILLER_47_337 VGND VGND VPWR VPWR sky130_fd_sc_hd__decap_3
XFILLER_47_326 VGND VGND VPWR VPWR sky130_fd_sc_hd__decap_3
XFILLER_62_307 VGND VGND VPWR VPWR sky130_fd_sc_hd__fill_1
XFILLER_62_318 VGND VGND VPWR VPWR sky130_fd_sc_hd__decap_3
XPHY_EDGE_ROW_27_Left_133 VGND VGND VPWR VPWR sky130_fd_sc_hd__decap_3
XFILLER_55_370 VGND VGND VPWR VPWR sky130_fd_sc_hd__decap_3
XTAP_TAPCELL_ROW_25_273 VGND VPWR sky130_fd_sc_hd__tapvpwrvgnd_1
XFILLER_30_215 VGND VGND VPWR VPWR sky130_fd_sc_hd__decap_3
XFILLER_30_259 VGND VGND VPWR VPWR sky130_fd_sc_hd__decap_3
XFILLER_30_248 VGND VGND VPWR VPWR sky130_fd_sc_hd__decap_3
XFILLER_7_400 VGND VGND VPWR VPWR sky130_fd_sc_hd__decap_3
X_205_ _110_ _112_ VGND VGND VPWR VPWR genblk1\[15\].fa_inst.s sky130_fd_sc_hd__xnor2_1
XPHY_EDGE_ROW_36_Left_142 VGND VGND VPWR VPWR sky130_fd_sc_hd__decap_3
X_136_ genblk1\[2\].fa_inst.b genblk1\[2\].fa_inst.a VGND VGND VPWR VPWR _058_ sky130_fd_sc_hd__or2_1
XFILLER_31_6 VGND VGND VPWR VPWR sky130_fd_sc_hd__decap_3
XFILLER_2_171 VGND VGND VPWR VPWR sky130_fd_sc_hd__decap_3
XPHY_EDGE_ROW_2_2_Right_88 VGND VGND VPWR VPWR sky130_fd_sc_hd__decap_3
XFILLER_38_304 VGND VGND VPWR VPWR sky130_fd_sc_hd__decap_3
XFILLER_38_315 VGND VGND VPWR VPWR sky130_fd_sc_hd__decap_3
XPHY_EDGE_ROW_45_Left_151 VGND VGND VPWR VPWR sky130_fd_sc_hd__decap_3
XFILLER_38_348 VGND VGND VPWR VPWR sky130_fd_sc_hd__decap_3
XFILLER_0_41 VGND VGND VPWR VPWR sky130_fd_sc_hd__decap_3
XFILLER_53_329 VGND VGND VPWR VPWR sky130_fd_sc_hd__decap_3
XFILLER_0_63 VGND VGND VPWR VPWR sky130_fd_sc_hd__decap_3
XFILLER_0_85 VGND VGND VPWR VPWR sky130_fd_sc_hd__decap_3
XFILLER_46_392 VGND VGND VPWR VPWR sky130_fd_sc_hd__decap_3
XFILLER_61_340 VGND VGND VPWR VPWR sky130_fd_sc_hd__decap_3
XFILLER_21_215 VGND VGND VPWR VPWR sky130_fd_sc_hd__decap_3
XFILLER_61_373 VGND VGND VPWR VPWR sky130_fd_sc_hd__decap_3
XFILLER_21_248 VGND VGND VPWR VPWR sky130_fd_sc_hd__decap_3
XFILLER_21_259 VGND VGND VPWR VPWR sky130_fd_sc_hd__decap_3
XFILLER_9_72 VGND VGND VPWR VPWR sky130_fd_sc_hd__decap_3
XPHY_EDGE_ROW_54_Left_160 VGND VGND VPWR VPWR sky130_fd_sc_hd__decap_3
XFILLER_0_119 VGND VGND VPWR VPWR sky130_fd_sc_hd__decap_3
XFILLER_56_112 VGND VGND VPWR VPWR sky130_fd_sc_hd__decap_3
XFILLER_29_337 VGND VGND VPWR VPWR sky130_fd_sc_hd__decap_3
XFILLER_29_326 VGND VGND VPWR VPWR sky130_fd_sc_hd__decap_3
XFILLER_28_48 VGND VGND VPWR VPWR sky130_fd_sc_hd__decap_3
XFILLER_28_15 VGND VGND VPWR VPWR sky130_fd_sc_hd__decap_3
XFILLER_56_156 VGND VGND VPWR VPWR sky130_fd_sc_hd__decap_3
XTAP_TAPCELL_ROW_39_365 VGND VPWR sky130_fd_sc_hd__tapvpwrvgnd_1
XFILLER_56_189 VGND VGND VPWR VPWR sky130_fd_sc_hd__decap_3
XFILLER_44_318 VGND VGND VPWR VPWR sky130_fd_sc_hd__decap_3
XFILLER_44_307 VGND VGND VPWR VPWR sky130_fd_sc_hd__fill_1
XFILLER_37_370 VGND VGND VPWR VPWR sky130_fd_sc_hd__decap_3
XFILLER_52_351 VGND VGND VPWR VPWR sky130_fd_sc_hd__decap_3
XFILLER_44_47 VGND VGND VPWR VPWR sky130_fd_sc_hd__decap_3
XFILLER_52_395 VGND VGND VPWR VPWR sky130_fd_sc_hd__decap_3
XFILLER_60_35 VGND VGND VPWR VPWR sky130_fd_sc_hd__decap_3
XFILLER_60_68 VGND VGND VPWR VPWR sky130_fd_sc_hd__decap_3
XFILLER_47_134 VGND VGND VPWR VPWR sky130_fd_sc_hd__decap_3
XFILLER_47_178 VGND VGND VPWR VPWR sky130_fd_sc_hd__decap_3
XFILLER_47_167 VGND VGND VPWR VPWR sky130_fd_sc_hd__fill_1
XFILLER_35_329 VGND VGND VPWR VPWR sky130_fd_sc_hd__decap_3
XFILLER_62_115 VGND VGND VPWR VPWR sky130_fd_sc_hd__decap_3
XFILLER_28_392 VGND VGND VPWR VPWR sky130_fd_sc_hd__decap_3
XFILLER_62_159 VGND VGND VPWR VPWR sky130_fd_sc_hd__decap_3
XFILLER_43_340 VGND VGND VPWR VPWR sky130_fd_sc_hd__decap_3
XFILLER_43_373 VGND VGND VPWR VPWR sky130_fd_sc_hd__decap_3
XFILLER_34_91 VGND VGND VPWR VPWR sky130_fd_sc_hd__decap_3
XFILLER_34_80 VGND VGND VPWR VPWR sky130_fd_sc_hd__decap_3
XFILLER_38_112 VGND VGND VPWR VPWR sky130_fd_sc_hd__decap_3
XFILLER_26_307 VGND VGND VPWR VPWR sky130_fd_sc_hd__fill_1
XFILLER_26_318 VGND VGND VPWR VPWR sky130_fd_sc_hd__decap_3
XFILLER_38_156 VGND VGND VPWR VPWR sky130_fd_sc_hd__decap_3
XFILLER_19_370 VGND VGND VPWR VPWR sky130_fd_sc_hd__decap_3
XFILLER_53_137 VGND VGND VPWR VPWR sky130_fd_sc_hd__decap_3
XFILLER_38_189 VGND VGND VPWR VPWR sky130_fd_sc_hd__decap_3
XTAP_TAPCELL_ROW_36_346 VGND VPWR sky130_fd_sc_hd__tapvpwrvgnd_1
XFILLER_34_351 VGND VGND VPWR VPWR sky130_fd_sc_hd__decap_3
XFILLER_34_395 VGND VGND VPWR VPWR sky130_fd_sc_hd__decap_3
XFILLER_61_181 VGND VGND VPWR VPWR sky130_fd_sc_hd__decap_3
XFILLER_30_38 VGND VGND VPWR VPWR sky130_fd_sc_hd__decap_3
XFILLER_30_27 VGND VGND VPWR VPWR sky130_fd_sc_hd__fill_1
XFILLER_39_47 VGND VGND VPWR VPWR sky130_fd_sc_hd__decap_3
XFILLER_39_69 VGND VGND VPWR VPWR sky130_fd_sc_hd__fill_1
XFILLER_29_134 VGND VGND VPWR VPWR sky130_fd_sc_hd__decap_3
XFILLER_29_178 VGND VGND VPWR VPWR sky130_fd_sc_hd__decap_3
XFILLER_29_167 VGND VGND VPWR VPWR sky130_fd_sc_hd__fill_1
XFILLER_55_46 VGND VGND VPWR VPWR sky130_fd_sc_hd__decap_3
XFILLER_44_115 VGND VGND VPWR VPWR sky130_fd_sc_hd__decap_3
XFILLER_25_340 VGND VGND VPWR VPWR sky130_fd_sc_hd__decap_3
XFILLER_44_159 VGND VGND VPWR VPWR sky130_fd_sc_hd__decap_3
XFILLER_25_373 VGND VGND VPWR VPWR sky130_fd_sc_hd__decap_3
XFILLER_52_192 VGND VGND VPWR VPWR sky130_fd_sc_hd__decap_3
XFILLER_40_321 VGND VGND VPWR VPWR sky130_fd_sc_hd__decap_3
XFILLER_40_365 VGND VGND VPWR VPWR sky130_fd_sc_hd__decap_3
XFILLER_40_354 VGND VGND VPWR VPWR sky130_fd_sc_hd__decap_3
XFILLER_40_398 VGND VGND VPWR VPWR sky130_fd_sc_hd__decap_3
XFILLER_20_82 VGND VGND VPWR VPWR sky130_fd_sc_hd__fill_2
XFILLER_63_402 VGND VGND VPWR VPWR sky130_fd_sc_hd__decap_3
XFILLER_35_137 VGND VGND VPWR VPWR sky130_fd_sc_hd__decap_3
XFILLER_16_340 VGND VGND VPWR VPWR sky130_fd_sc_hd__decap_3
XFILLER_16_384 VGND VGND VPWR VPWR sky130_fd_sc_hd__decap_3
XTAP_TAPCELL_ROW_33_327 VGND VPWR sky130_fd_sc_hd__tapvpwrvgnd_1
XFILLER_50_118 VGND VGND VPWR VPWR sky130_fd_sc_hd__decap_3
XFILLER_43_181 VGND VGND VPWR VPWR sky130_fd_sc_hd__decap_3
XFILLER_31_343 VGND VGND VPWR VPWR sky130_fd_sc_hd__decap_3
XFILLER_31_332 VGND VGND VPWR VPWR sky130_fd_sc_hd__decap_3
XTAP_TAPCELL_ROW_9_1_197 VGND VPWR sky130_fd_sc_hd__tapvpwrvgnd_1
XFILLER_31_376 VGND VGND VPWR VPWR sky130_fd_sc_hd__decap_3
XTAP_TAPCELL_ROW_41_382 VGND VPWR sky130_fd_sc_hd__tapvpwrvgnd_1
XFILLER_6_62 VGND VGND VPWR VPWR sky130_fd_sc_hd__decap_3
Xpmu_inst_65 VGND VGND VPWR VPWR pmu_inst_65/HI net65 sky130_fd_sc_hd__conb_1
XFILLER_58_218 VGND VGND VPWR VPWR sky130_fd_sc_hd__decap_3
XFILLER_26_115 VGND VGND VPWR VPWR sky130_fd_sc_hd__decap_3
XFILLER_26_159 VGND VGND VPWR VPWR sky130_fd_sc_hd__decap_3
XPHY_EDGE_ROW_15_2_Left_36 VGND VGND VPWR VPWR sky130_fd_sc_hd__decap_3
XTAP_TAPCELL_ROW_13_1_209 VGND VPWR sky130_fd_sc_hd__tapvpwrvgnd_1
XFILLER_22_321 VGND VGND VPWR VPWR sky130_fd_sc_hd__decap_3
XFILLER_34_192 VGND VGND VPWR VPWR sky130_fd_sc_hd__decap_3
XFILLER_22_354 VGND VGND VPWR VPWR sky130_fd_sc_hd__decap_3
XFILLER_22_365 VGND VGND VPWR VPWR sky130_fd_sc_hd__decap_3
XFILLER_22_398 VGND VGND VPWR VPWR sky130_fd_sc_hd__decap_3
XFILLER_41_15 VGND VGND VPWR VPWR sky130_fd_sc_hd__decap_3
XFILLER_9_6 VGND VGND VPWR VPWR sky130_fd_sc_hd__fill_2
XFILLER_57_240 VGND VGND VPWR VPWR sky130_fd_sc_hd__decap_3
XFILLER_45_402 VGND VGND VPWR VPWR sky130_fd_sc_hd__fill_1
XFILLER_17_137 VGND VGND VPWR VPWR sky130_fd_sc_hd__decap_3
XFILLER_57_273 VGND VGND VPWR VPWR sky130_fd_sc_hd__decap_3
XFILLER_32_129 VGND VGND VPWR VPWR sky130_fd_sc_hd__decap_3
XFILLER_13_343 VGND VGND VPWR VPWR sky130_fd_sc_hd__decap_3
XFILLER_25_181 VGND VGND VPWR VPWR sky130_fd_sc_hd__decap_3
XFILLER_13_376 VGND VGND VPWR VPWR sky130_fd_sc_hd__decap_3
XFILLER_15_60 VGND VGND VPWR VPWR sky130_fd_sc_hd__decap_3
XFILLER_15_93 VGND VGND VPWR VPWR sky130_fd_sc_hd__decap_3
XTAP_TAPCELL_ROW_30_308 VGND VPWR sky130_fd_sc_hd__tapvpwrvgnd_1
XFILLER_40_162 VGND VGND VPWR VPWR sky130_fd_sc_hd__decap_3
XFILLER_9_358 VGND VGND VPWR VPWR sky130_fd_sc_hd__decap_3
XFILLER_40_195 VGND VGND VPWR VPWR sky130_fd_sc_hd__fill_1
XFILLER_31_81 VGND VGND VPWR VPWR sky130_fd_sc_hd__decap_3
XFILLER_48_262 VGND VGND VPWR VPWR sky130_fd_sc_hd__decap_3
XFILLER_48_251 VGND VGND VPWR VPWR sky130_fd_sc_hd__fill_1
XFILLER_48_295 VGND VGND VPWR VPWR sky130_fd_sc_hd__decap_3
XFILLER_63_243 VGND VGND VPWR VPWR sky130_fd_sc_hd__decap_3
XFILLER_63_276 VGND VGND VPWR VPWR sky130_fd_sc_hd__decap_3
XFILLER_63_287 VGND VGND VPWR VPWR sky130_fd_sc_hd__decap_3
XFILLER_51_405 VGND VGND VPWR VPWR sky130_fd_sc_hd__fill_2
XFILLER_31_140 VGND VGND VPWR VPWR sky130_fd_sc_hd__decap_3
XFILLER_31_184 VGND VGND VPWR VPWR sky130_fd_sc_hd__decap_3
XFILLER_11_18 VGND VGND VPWR VPWR sky130_fd_sc_hd__decap_3
XFILLER_27_402 VGND VGND VPWR VPWR sky130_fd_sc_hd__decap_3
XFILLER_39_240 VGND VGND VPWR VPWR sky130_fd_sc_hd__decap_3
XFILLER_54_221 VGND VGND VPWR VPWR sky130_fd_sc_hd__decap_3
XFILLER_39_284 VGND VGND VPWR VPWR sky130_fd_sc_hd__decap_3
XFILLER_39_273 VGND VGND VPWR VPWR sky130_fd_sc_hd__decap_3
XFILLER_36_15 VGND VGND VPWR VPWR sky130_fd_sc_hd__decap_3
XFILLER_36_48 VGND VGND VPWR VPWR sky130_fd_sc_hd__decap_3
XFILLER_14_118 VGND VGND VPWR VPWR sky130_fd_sc_hd__decap_3
XFILLER_54_265 VGND VGND VPWR VPWR sky130_fd_sc_hd__decap_3
XFILLER_54_298 VGND VGND VPWR VPWR sky130_fd_sc_hd__decap_3
XFILLER_52_47 VGND VGND VPWR VPWR sky130_fd_sc_hd__decap_3
XFILLER_22_162 VGND VGND VPWR VPWR sky130_fd_sc_hd__decap_3
XFILLER_10_346 VGND VGND VPWR VPWR sky130_fd_sc_hd__decap_3
XFILLER_10_357 VGND VGND VPWR VPWR sky130_fd_sc_hd__decap_3
XFILLER_22_195 VGND VGND VPWR VPWR sky130_fd_sc_hd__fill_1
XFILLER_6_328 VGND VGND VPWR VPWR sky130_fd_sc_hd__decap_3
XFILLER_7_3 VGND VGND VPWR VPWR sky130_fd_sc_hd__decap_3
XFILLER_18_402 VGND VGND VPWR VPWR sky130_fd_sc_hd__decap_3
XFILLER_45_243 VGND VGND VPWR VPWR sky130_fd_sc_hd__decap_3
XFILLER_45_287 VGND VGND VPWR VPWR sky130_fd_sc_hd__decap_3
XFILLER_45_276 VGND VGND VPWR VPWR sky130_fd_sc_hd__decap_3
XFILLER_26_81 VGND VGND VPWR VPWR sky130_fd_sc_hd__decap_3
XFILLER_60_224 VGND VGND VPWR VPWR sky130_fd_sc_hd__decap_3
XFILLER_13_140 VGND VGND VPWR VPWR sky130_fd_sc_hd__decap_3
XFILLER_60_268 VGND VGND VPWR VPWR sky130_fd_sc_hd__decap_3
XFILLER_9_111 VGND VGND VPWR VPWR sky130_fd_sc_hd__fill_1
XFILLER_9_122 VGND VGND VPWR VPWR sky130_fd_sc_hd__decap_3
XFILLER_9_155 VGND VGND VPWR VPWR sky130_fd_sc_hd__decap_3
XFILLER_42_80 VGND VGND VPWR VPWR sky130_fd_sc_hd__decap_3
X_298_ clknet_2_2__leaf_clk_regs net18 _043_ VGND VGND VPWR VPWR genblk1\[10\].fa_inst.b
+ sky130_fd_sc_hd__dfrtp_1
XFILLER_42_91 VGND VGND VPWR VPWR sky130_fd_sc_hd__decap_3
XFILLER_61_6 VGND VGND VPWR VPWR sky130_fd_sc_hd__decap_3
XFILLER_5_361 VGND VGND VPWR VPWR sky130_fd_sc_hd__decap_3
XFILLER_5_394 VGND VGND VPWR VPWR sky130_fd_sc_hd__decap_3
XFILLER_3_63 VGND VGND VPWR VPWR sky130_fd_sc_hd__decap_3
XFILLER_36_221 VGND VGND VPWR VPWR sky130_fd_sc_hd__decap_3
XFILLER_51_202 VGND VGND VPWR VPWR sky130_fd_sc_hd__decap_3
XFILLER_36_265 VGND VGND VPWR VPWR sky130_fd_sc_hd__decap_3
XFILLER_51_246 VGND VGND VPWR VPWR sky130_fd_sc_hd__decap_3
XFILLER_36_298 VGND VGND VPWR VPWR sky130_fd_sc_hd__decap_3
XFILLER_51_279 VGND VGND VPWR VPWR sky130_fd_sc_hd__fill_1
XFILLER_59_302 VGND VGND VPWR VPWR sky130_fd_sc_hd__decap_3
XFILLER_59_346 VGND VGND VPWR VPWR sky130_fd_sc_hd__decap_3
XFILLER_59_335 VGND VGND VPWR VPWR sky130_fd_sc_hd__fill_1
XFILLER_59_379 VGND VGND VPWR VPWR sky130_fd_sc_hd__decap_3
XFILLER_47_36 VGND VGND VPWR VPWR sky130_fd_sc_hd__decap_3
XFILLER_47_69 VGND VGND VPWR VPWR sky130_fd_sc_hd__decap_3
XFILLER_27_243 VGND VGND VPWR VPWR sky130_fd_sc_hd__decap_3
XFILLER_27_276 VGND VGND VPWR VPWR sky130_fd_sc_hd__decap_3
XFILLER_63_13 VGND VGND VPWR VPWR sky130_fd_sc_hd__decap_3
XFILLER_27_287 VGND VGND VPWR VPWR sky130_fd_sc_hd__decap_3
XFILLER_63_46 VGND VGND VPWR VPWR sky130_fd_sc_hd__decap_3
XFILLER_63_57 VGND VGND VPWR VPWR sky130_fd_sc_hd__decap_3
XFILLER_42_224 VGND VGND VPWR VPWR sky130_fd_sc_hd__decap_3
XFILLER_42_268 VGND VGND VPWR VPWR sky130_fd_sc_hd__decap_3
X_221_ net62 VGND VGND VPWR VPWR _016_ sky130_fd_sc_hd__inv_2
XFILLER_10_121 VGND VGND VPWR VPWR sky130_fd_sc_hd__decap_3
X_152_ _069_ _070_ VGND VGND VPWR VPWR _071_ sky130_fd_sc_hd__nand2_1
XFILLER_10_165 VGND VGND VPWR VPWR sky130_fd_sc_hd__decap_3
XFILLER_6_103 VGND VGND VPWR VPWR sky130_fd_sc_hd__decap_3
XFILLER_12_50 VGND VGND VPWR VPWR sky130_fd_sc_hd__decap_3
XFILLER_6_136 VGND VGND VPWR VPWR sky130_fd_sc_hd__decap_3
XFILLER_6_147 VGND VGND VPWR VPWR sky130_fd_sc_hd__decap_3
XFILLER_12_83 VGND VGND VPWR VPWR sky130_fd_sc_hd__fill_1
XFILLER_12_94 VGND VGND VPWR VPWR sky130_fd_sc_hd__decap_3
XFILLER_2_331 VGND VGND VPWR VPWR sky130_fd_sc_hd__decap_3
XFILLER_2_375 VGND VGND VPWR VPWR sky130_fd_sc_hd__decap_3
XFILLER_26_9 VGND VGND VPWR VPWR sky130_fd_sc_hd__decap_3
XFILLER_37_80 VGND VGND VPWR VPWR sky130_fd_sc_hd__decap_3
XFILLER_33_202 VGND VGND VPWR VPWR sky130_fd_sc_hd__decap_3
XTAP_TAPCELL_ROW_63_539 VGND VPWR sky130_fd_sc_hd__tapvpwrvgnd_1
XTAP_TAPCELL_ROW_28_293 VGND VPWR sky130_fd_sc_hd__tapvpwrvgnd_1
XFILLER_33_279 VGND VGND VPWR VPWR sky130_fd_sc_hd__fill_1
XFILLER_33_246 VGND VGND VPWR VPWR sky130_fd_sc_hd__decap_3
XFILLER_53_90 VGND VGND VPWR VPWR sky130_fd_sc_hd__decap_3
XFILLER_41_290 VGND VGND VPWR VPWR sky130_fd_sc_hd__decap_3
XFILLER_56_327 VGND VGND VPWR VPWR sky130_fd_sc_hd__decap_3
XFILLER_64_371 VGND VGND VPWR VPWR sky130_fd_sc_hd__decap_3
XFILLER_24_224 VGND VGND VPWR VPWR sky130_fd_sc_hd__decap_3
XFILLER_64_393 VGND VGND VPWR VPWR sky130_fd_sc_hd__decap_3
XFILLER_24_268 VGND VGND VPWR VPWR sky130_fd_sc_hd__decap_3
XFILLER_3_128 VGND VGND VPWR VPWR sky130_fd_sc_hd__decap_3
XFILLER_58_35 VGND VGND VPWR VPWR sky130_fd_sc_hd__decap_3
XFILLER_58_24 VGND VGND VPWR VPWR sky130_fd_sc_hd__decap_3
XFILLER_59_132 VGND VGND VPWR VPWR sky130_fd_sc_hd__decap_3
XFILLER_59_187 VGND VGND VPWR VPWR sky130_fd_sc_hd__decap_3
XFILLER_59_165 VGND VGND VPWR VPWR sky130_fd_sc_hd__decap_3
XFILLER_47_305 VGND VGND VPWR VPWR sky130_fd_sc_hd__decap_3
XFILLER_47_349 VGND VGND VPWR VPWR sky130_fd_sc_hd__decap_3
XFILLER_55_393 VGND VGND VPWR VPWR sky130_fd_sc_hd__decap_3
XFILLER_55_382 VGND VGND VPWR VPWR sky130_fd_sc_hd__decap_3
XFILLER_30_227 VGND VGND VPWR VPWR sky130_fd_sc_hd__decap_3
XFILLER_23_290 VGND VGND VPWR VPWR sky130_fd_sc_hd__decap_3
X_204_ _110_ _111_ _109_ VGND VGND VPWR VPWR cout_next sky130_fd_sc_hd__o21bai_4
XFILLER_23_60 VGND VGND VPWR VPWR sky130_fd_sc_hd__decap_3
X_135_ _053_ _054_ _055_ VGND VGND VPWR VPWR _057_ sky130_fd_sc_hd__a21bo_1
XFILLER_2_150 VGND VGND VPWR VPWR sky130_fd_sc_hd__decap_3
XFILLER_24_6 VGND VGND VPWR VPWR sky130_fd_sc_hd__decap_3
XFILLER_38_327 VGND VGND VPWR VPWR sky130_fd_sc_hd__decap_3
XFILLER_0_53 VGND VGND VPWR VPWR sky130_fd_sc_hd__decap_3
XFILLER_53_308 VGND VGND VPWR VPWR sky130_fd_sc_hd__decap_3
XFILLER_46_360 VGND VGND VPWR VPWR sky130_fd_sc_hd__decap_3
XFILLER_0_75 VGND VGND VPWR VPWR sky130_fd_sc_hd__decap_3
XFILLER_46_371 VGND VGND VPWR VPWR sky130_fd_sc_hd__decap_3
XFILLER_0_97 VGND VGND VPWR VPWR sky130_fd_sc_hd__decap_3
XFILLER_61_352 VGND VGND VPWR VPWR sky130_fd_sc_hd__decap_3
XFILLER_61_396 VGND VGND VPWR VPWR sky130_fd_sc_hd__decap_3
XFILLER_61_385 VGND VGND VPWR VPWR sky130_fd_sc_hd__decap_3
XFILLER_9_40 VGND VGND VPWR VPWR sky130_fd_sc_hd__decap_3
XFILLER_9_84 VGND VGND VPWR VPWR sky130_fd_sc_hd__decap_3
XFILLER_0_109 VGND VGND VPWR VPWR sky130_fd_sc_hd__decap_3
XFILLER_29_305 VGND VGND VPWR VPWR sky130_fd_sc_hd__decap_3
XFILLER_28_27 VGND VGND VPWR VPWR sky130_fd_sc_hd__fill_1
XFILLER_56_124 VGND VGND VPWR VPWR sky130_fd_sc_hd__decap_3
XFILLER_29_349 VGND VGND VPWR VPWR sky130_fd_sc_hd__decap_3
XTAP_TAPCELL_ROW_39_366 VGND VPWR sky130_fd_sc_hd__tapvpwrvgnd_1
XFILLER_56_168 VGND VGND VPWR VPWR sky130_fd_sc_hd__decap_3
XFILLER_44_15 VGND VGND VPWR VPWR sky130_fd_sc_hd__decap_3
XFILLER_37_393 VGND VGND VPWR VPWR sky130_fd_sc_hd__decap_3
XFILLER_37_382 VGND VGND VPWR VPWR sky130_fd_sc_hd__decap_3
XFILLER_64_190 VGND VGND VPWR VPWR sky130_fd_sc_hd__decap_3
XFILLER_52_330 VGND VGND VPWR VPWR sky130_fd_sc_hd__decap_3
XFILLER_44_59 VGND VGND VPWR VPWR sky130_fd_sc_hd__decap_3
XFILLER_52_374 VGND VGND VPWR VPWR sky130_fd_sc_hd__decap_3
XFILLER_52_363 VGND VGND VPWR VPWR sky130_fd_sc_hd__fill_1
XFILLER_60_47 VGND VGND VPWR VPWR sky130_fd_sc_hd__decap_3
XFILLER_47_113 VGND VGND VPWR VPWR sky130_fd_sc_hd__decap_3
XFILLER_47_102 VGND VGND VPWR VPWR sky130_fd_sc_hd__decap_3
XFILLER_47_146 VGND VGND VPWR VPWR sky130_fd_sc_hd__decap_3
XFILLER_18_71 VGND VGND VPWR VPWR sky130_fd_sc_hd__decap_3
XFILLER_35_308 VGND VGND VPWR VPWR sky130_fd_sc_hd__decap_3
XFILLER_28_360 VGND VGND VPWR VPWR sky130_fd_sc_hd__decap_3
XFILLER_62_127 VGND VGND VPWR VPWR sky130_fd_sc_hd__decap_3
XFILLER_28_371 VGND VGND VPWR VPWR sky130_fd_sc_hd__decap_3
XFILLER_55_190 VGND VGND VPWR VPWR sky130_fd_sc_hd__decap_3
XFILLER_43_352 VGND VGND VPWR VPWR sky130_fd_sc_hd__decap_3
XFILLER_43_385 VGND VGND VPWR VPWR sky130_fd_sc_hd__decap_3
XFILLER_43_396 VGND VGND VPWR VPWR sky130_fd_sc_hd__decap_3
XFILLER_50_91 VGND VGND VPWR VPWR sky130_fd_sc_hd__decap_3
XFILLER_50_80 VGND VGND VPWR VPWR sky130_fd_sc_hd__decap_3
XFILLER_38_124 VGND VGND VPWR VPWR sky130_fd_sc_hd__decap_3
XFILLER_53_105 VGND VGND VPWR VPWR sky130_fd_sc_hd__decap_3
XFILLER_38_168 VGND VGND VPWR VPWR sky130_fd_sc_hd__decap_3
XFILLER_19_382 VGND VGND VPWR VPWR sky130_fd_sc_hd__decap_3
XFILLER_53_116 VGND VGND VPWR VPWR sky130_fd_sc_hd__decap_3
XTAP_TAPCELL_ROW_36_347 VGND VPWR sky130_fd_sc_hd__tapvpwrvgnd_1
XFILLER_53_149 VGND VGND VPWR VPWR sky130_fd_sc_hd__decap_3
XFILLER_34_330 VGND VGND VPWR VPWR sky130_fd_sc_hd__decap_3
XFILLER_14_18 VGND VGND VPWR VPWR sky130_fd_sc_hd__decap_3
XFILLER_34_374 VGND VGND VPWR VPWR sky130_fd_sc_hd__decap_3
XFILLER_34_363 VGND VGND VPWR VPWR sky130_fd_sc_hd__fill_1
XFILLER_14_29 VGND VGND VPWR VPWR sky130_fd_sc_hd__decap_3
XFILLER_61_193 VGND VGND VPWR VPWR sky130_fd_sc_hd__decap_3
XPHY_EDGE_ROW_3_1_Right_2 VGND VGND VPWR VPWR sky130_fd_sc_hd__decap_3
XFILLER_39_15 VGND VGND VPWR VPWR sky130_fd_sc_hd__decap_3
XFILLER_29_113 VGND VGND VPWR VPWR sky130_fd_sc_hd__decap_3
XFILLER_29_146 VGND VGND VPWR VPWR sky130_fd_sc_hd__decap_3
XFILLER_44_127 VGND VGND VPWR VPWR sky130_fd_sc_hd__decap_3
XFILLER_25_352 VGND VGND VPWR VPWR sky130_fd_sc_hd__decap_3
XFILLER_37_190 VGND VGND VPWR VPWR sky130_fd_sc_hd__decap_3
XFILLER_25_385 VGND VGND VPWR VPWR sky130_fd_sc_hd__decap_3
XFILLER_52_171 VGND VGND VPWR VPWR sky130_fd_sc_hd__decap_3
XFILLER_25_396 VGND VGND VPWR VPWR sky130_fd_sc_hd__decap_3
XFILLER_40_333 VGND VGND VPWR VPWR sky130_fd_sc_hd__decap_3
XFILLER_40_377 VGND VGND VPWR VPWR sky130_fd_sc_hd__decap_3
XFILLER_20_50 VGND VGND VPWR VPWR sky130_fd_sc_hd__decap_3
XFILLER_20_94 VGND VGND VPWR VPWR sky130_fd_sc_hd__fill_2
XFILLER_29_81 VGND VGND VPWR VPWR sky130_fd_sc_hd__decap_3
XFILLER_35_116 VGND VGND VPWR VPWR sky130_fd_sc_hd__decap_3
XFILLER_35_149 VGND VGND VPWR VPWR sky130_fd_sc_hd__decap_3
XFILLER_16_352 VGND VGND VPWR VPWR sky130_fd_sc_hd__fill_1
XFILLER_16_363 VGND VGND VPWR VPWR sky130_fd_sc_hd__decap_3
XFILLER_45_91 VGND VGND VPWR VPWR sky130_fd_sc_hd__decap_3
XFILLER_16_396 VGND VGND VPWR VPWR sky130_fd_sc_hd__decap_3
XTAP_TAPCELL_ROW_33_328 VGND VPWR sky130_fd_sc_hd__tapvpwrvgnd_1
XFILLER_43_193 VGND VGND VPWR VPWR sky130_fd_sc_hd__decap_3
XFILLER_31_311 VGND VGND VPWR VPWR sky130_fd_sc_hd__decap_3
XFILLER_31_355 VGND VGND VPWR VPWR sky130_fd_sc_hd__decap_3
XTAP_TAPCELL_ROW_41_383 VGND VPWR sky130_fd_sc_hd__tapvpwrvgnd_1
XTAP_TAPCELL_ROW_9_1_198 VGND VPWR sky130_fd_sc_hd__tapvpwrvgnd_1
XFILLER_31_399 VGND VGND VPWR VPWR sky130_fd_sc_hd__decap_3
XFILLER_31_388 VGND VGND VPWR VPWR sky130_fd_sc_hd__decap_3
XFILLER_61_90 VGND VGND VPWR VPWR sky130_fd_sc_hd__decap_3
XANTENNA_1 net42 VGND VGND VPWR VPWR sky130_fd_sc_hd__diode_2
XFILLER_6_41 VGND VGND VPWR VPWR sky130_fd_sc_hd__decap_3
XFILLER_6_85 VGND VGND VPWR VPWR sky130_fd_sc_hd__decap_3
Xpmu_inst_66 VGND VGND VPWR VPWR pmu_inst_66/HI net66 sky130_fd_sc_hd__conb_1
XFILLER_26_127 VGND VGND VPWR VPWR sky130_fd_sc_hd__decap_3
XFILLER_25_39 VGND VGND VPWR VPWR sky130_fd_sc_hd__decap_3
XFILLER_41_119 VGND VGND VPWR VPWR sky130_fd_sc_hd__decap_3
XFILLER_41_108 VGND VGND VPWR VPWR sky130_fd_sc_hd__decap_3
XFILLER_22_333 VGND VGND VPWR VPWR sky130_fd_sc_hd__decap_3
XFILLER_34_171 VGND VGND VPWR VPWR sky130_fd_sc_hd__decap_3
XFILLER_22_377 VGND VGND VPWR VPWR sky130_fd_sc_hd__decap_3
XFILLER_49_208 VGND VGND VPWR VPWR sky130_fd_sc_hd__decap_3
XFILLER_57_252 VGND VGND VPWR VPWR sky130_fd_sc_hd__decap_3
XFILLER_17_116 VGND VGND VPWR VPWR sky130_fd_sc_hd__decap_3
XFILLER_17_149 VGND VGND VPWR VPWR sky130_fd_sc_hd__decap_3
XFILLER_25_193 VGND VGND VPWR VPWR sky130_fd_sc_hd__decap_3
XFILLER_13_355 VGND VGND VPWR VPWR sky130_fd_sc_hd__decap_3
XFILLER_15_72 VGND VGND VPWR VPWR sky130_fd_sc_hd__decap_3
XFILLER_40_141 VGND VGND VPWR VPWR sky130_fd_sc_hd__decap_3
XFILLER_40_130 VGND VGND VPWR VPWR sky130_fd_sc_hd__decap_3
XFILLER_13_388 VGND VGND VPWR VPWR sky130_fd_sc_hd__decap_3
XFILLER_9_337 VGND VGND VPWR VPWR sky130_fd_sc_hd__decap_3
XFILLER_40_174 VGND VGND VPWR VPWR sky130_fd_sc_hd__decap_3
XFILLER_31_60 VGND VGND VPWR VPWR sky130_fd_sc_hd__decap_3
XFILLER_56_9 VGND VGND VPWR VPWR sky130_fd_sc_hd__decap_3
XFILLER_31_93 VGND VGND VPWR VPWR sky130_fd_sc_hd__decap_3
XFILLER_48_230 VGND VGND VPWR VPWR sky130_fd_sc_hd__decap_3
XFILLER_63_211 VGND VGND VPWR VPWR sky130_fd_sc_hd__decap_3
XFILLER_48_274 VGND VGND VPWR VPWR sky130_fd_sc_hd__decap_3
XFILLER_63_255 VGND VGND VPWR VPWR sky130_fd_sc_hd__decap_3
XTAP_TAPCELL_ROW_46_420 VGND VPWR sky130_fd_sc_hd__tapvpwrvgnd_1
XFILLER_23_108 VGND VGND VPWR VPWR sky130_fd_sc_hd__decap_3
XFILLER_23_119 VGND VGND VPWR VPWR sky130_fd_sc_hd__decap_3
XFILLER_16_171 VGND VGND VPWR VPWR sky130_fd_sc_hd__decap_3
XFILLER_63_299 VGND VGND VPWR VPWR sky130_fd_sc_hd__decap_3
XFILLER_31_152 VGND VGND VPWR VPWR sky130_fd_sc_hd__decap_3
XFILLER_31_196 VGND VGND VPWR VPWR sky130_fd_sc_hd__decap_3
XFILLER_8_381 VGND VGND VPWR VPWR sky130_fd_sc_hd__decap_3
XFILLER_39_252 VGND VGND VPWR VPWR sky130_fd_sc_hd__decap_3
XFILLER_54_200 VGND VGND VPWR VPWR sky130_fd_sc_hd__decap_3
XFILLER_36_27 VGND VGND VPWR VPWR sky130_fd_sc_hd__fill_1
XFILLER_54_233 VGND VGND VPWR VPWR sky130_fd_sc_hd__decap_3
XFILLER_39_296 VGND VGND VPWR VPWR sky130_fd_sc_hd__decap_3
XFILLER_54_277 VGND VGND VPWR VPWR sky130_fd_sc_hd__decap_3
XFILLER_22_130 VGND VGND VPWR VPWR sky130_fd_sc_hd__decap_3
XFILLER_22_141 VGND VGND VPWR VPWR sky130_fd_sc_hd__decap_3
XTAP_TAPCELL_ROW_52_456 VGND VPWR sky130_fd_sc_hd__tapvpwrvgnd_1
XFILLER_22_174 VGND VGND VPWR VPWR sky130_fd_sc_hd__decap_3
XFILLER_52_59 VGND VGND VPWR VPWR sky130_fd_sc_hd__decap_3
XFILLER_10_369 VGND VGND VPWR VPWR sky130_fd_sc_hd__decap_3
XFILLER_45_211 VGND VGND VPWR VPWR sky130_fd_sc_hd__decap_3
XFILLER_60_203 VGND VGND VPWR VPWR sky130_fd_sc_hd__decap_3
XFILLER_45_255 VGND VGND VPWR VPWR sky130_fd_sc_hd__decap_3
XFILLER_60_236 VGND VGND VPWR VPWR sky130_fd_sc_hd__decap_3
XFILLER_45_299 VGND VGND VPWR VPWR sky130_fd_sc_hd__decap_3
XFILLER_13_152 VGND VGND VPWR VPWR sky130_fd_sc_hd__decap_3
XFILLER_9_134 VGND VGND VPWR VPWR sky130_fd_sc_hd__decap_3
XFILLER_9_167 VGND VGND VPWR VPWR sky130_fd_sc_hd__fill_1
X_297_ clknet_2_2__leaf_clk_regs net32 _042_ VGND VGND VPWR VPWR genblk1\[9\].fa_inst.b
+ sky130_fd_sc_hd__dfrtp_1
XFILLER_9_178 VGND VGND VPWR VPWR sky130_fd_sc_hd__fill_2
XFILLER_5_340 VGND VGND VPWR VPWR sky130_fd_sc_hd__decap_3
XFILLER_5_373 VGND VGND VPWR VPWR sky130_fd_sc_hd__decap_3
XFILLER_54_6 VGND VGND VPWR VPWR sky130_fd_sc_hd__decap_3
XFILLER_3_75 VGND VGND VPWR VPWR sky130_fd_sc_hd__decap_3
XFILLER_36_200 VGND VGND VPWR VPWR sky130_fd_sc_hd__decap_3
XFILLER_36_233 VGND VGND VPWR VPWR sky130_fd_sc_hd__decap_3
XFILLER_36_277 VGND VGND VPWR VPWR sky130_fd_sc_hd__decap_3
XFILLER_51_225 VGND VGND VPWR VPWR sky130_fd_sc_hd__decap_3
XFILLER_51_214 VGND VGND VPWR VPWR sky130_fd_sc_hd__decap_3
XFILLER_51_258 VGND VGND VPWR VPWR sky130_fd_sc_hd__decap_3
XFILLER_22_18 VGND VGND VPWR VPWR sky130_fd_sc_hd__decap_3
XFILLER_59_314 VGND VGND VPWR VPWR sky130_fd_sc_hd__decap_3
XFILLER_59_358 VGND VGND VPWR VPWR sky130_fd_sc_hd__decap_3
XFILLER_47_15 VGND VGND VPWR VPWR sky130_fd_sc_hd__decap_3
XFILLER_47_48 VGND VGND VPWR VPWR sky130_fd_sc_hd__decap_3
XFILLER_27_211 VGND VGND VPWR VPWR sky130_fd_sc_hd__decap_3
XTAP_TAPCELL_ROW_4_1_181 VGND VPWR sky130_fd_sc_hd__tapvpwrvgnd_1
XFILLER_15_406 VGND VGND VPWR VPWR sky130_fd_sc_hd__fill_1
XFILLER_27_255 VGND VGND VPWR VPWR sky130_fd_sc_hd__decap_3
XFILLER_42_203 VGND VGND VPWR VPWR sky130_fd_sc_hd__decap_3
XFILLER_27_299 VGND VGND VPWR VPWR sky130_fd_sc_hd__decap_3
XFILLER_63_25 VGND VGND VPWR VPWR sky130_fd_sc_hd__decap_3
XFILLER_42_236 VGND VGND VPWR VPWR sky130_fd_sc_hd__decap_3
XFILLER_63_69 VGND VGND VPWR VPWR sky130_fd_sc_hd__decap_3
XFILLER_10_100 VGND VGND VPWR VPWR sky130_fd_sc_hd__decap_3
X_220_ net61 VGND VGND VPWR VPWR _015_ sky130_fd_sc_hd__inv_2
XFILLER_10_133 VGND VGND VPWR VPWR sky130_fd_sc_hd__decap_3
X_151_ genblk1\[5\].fa_inst.b genblk1\[5\].fa_inst.a VGND VGND VPWR VPWR _070_ sky130_fd_sc_hd__nand2_1
XFILLER_50_280 VGND VGND VPWR VPWR sky130_fd_sc_hd__decap_3
XFILLER_10_144 VGND VGND VPWR VPWR sky130_fd_sc_hd__decap_3
XFILLER_10_177 VGND VGND VPWR VPWR sky130_fd_sc_hd__decap_3
XFILLER_6_115 VGND VGND VPWR VPWR sky130_fd_sc_hd__decap_3
XPHY_EDGE_ROW_15_1_Left_121 VGND VGND VPWR VPWR sky130_fd_sc_hd__decap_3
XFILLER_12_62 VGND VGND VPWR VPWR sky130_fd_sc_hd__decap_3
XFILLER_6_159 VGND VGND VPWR VPWR sky130_fd_sc_hd__decap_3
XFILLER_2_354 VGND VGND VPWR VPWR sky130_fd_sc_hd__decap_3
XFILLER_2_343 VGND VGND VPWR VPWR sky130_fd_sc_hd__decap_3
XFILLER_2_387 VGND VGND VPWR VPWR sky130_fd_sc_hd__decap_3
XFILLER_19_9 VGND VGND VPWR VPWR sky130_fd_sc_hd__decap_3
XFILLER_58_380 VGND VGND VPWR VPWR sky130_fd_sc_hd__decap_3
XFILLER_37_92 VGND VGND VPWR VPWR sky130_fd_sc_hd__decap_3
XFILLER_33_225 VGND VGND VPWR VPWR sky130_fd_sc_hd__decap_3
XFILLER_33_214 VGND VGND VPWR VPWR sky130_fd_sc_hd__decap_3
XTAP_TAPCELL_ROW_28_294 VGND VPWR sky130_fd_sc_hd__tapvpwrvgnd_1
XFILLER_33_258 VGND VGND VPWR VPWR sky130_fd_sc_hd__decap_3
XPHY_EDGE_ROW_25_Right_46 VGND VGND VPWR VPWR sky130_fd_sc_hd__decap_3
XPHY_EDGE_ROW_34_Right_55 VGND VGND VPWR VPWR sky130_fd_sc_hd__decap_3
XFILLER_56_339 VGND VGND VPWR VPWR sky130_fd_sc_hd__decap_3
XFILLER_49_391 VGND VGND VPWR VPWR sky130_fd_sc_hd__fill_1
XFILLER_64_361 VGND VGND VPWR VPWR sky130_fd_sc_hd__decap_3
XFILLER_24_203 VGND VGND VPWR VPWR sky130_fd_sc_hd__decap_3
XFILLER_24_236 VGND VGND VPWR VPWR sky130_fd_sc_hd__decap_3
XFILLER_64_383 VGND VGND VPWR VPWR sky130_fd_sc_hd__decap_3
XFILLER_33_39 VGND VGND VPWR VPWR sky130_fd_sc_hd__decap_3
XFILLER_32_280 VGND VGND VPWR VPWR sky130_fd_sc_hd__decap_3
XPHY_EDGE_ROW_43_Right_64 VGND VGND VPWR VPWR sky130_fd_sc_hd__decap_3
XFILLER_59_111 VGND VGND VPWR VPWR sky130_fd_sc_hd__fill_1
XFILLER_58_47 VGND VGND VPWR VPWR sky130_fd_sc_hd__decap_3
XFILLER_59_144 VGND VGND VPWR VPWR sky130_fd_sc_hd__decap_3
XFILLER_58_69 VGND VGND VPWR VPWR sky130_fd_sc_hd__decap_3
XPHY_EDGE_ROW_52_Right_73 VGND VGND VPWR VPWR sky130_fd_sc_hd__decap_3
XFILLER_47_317 VGND VGND VPWR VPWR sky130_fd_sc_hd__decap_3
XFILLER_59_199 VGND VGND VPWR VPWR sky130_fd_sc_hd__decap_3
XFILLER_62_309 VGND VGND VPWR VPWR sky130_fd_sc_hd__decap_3
XFILLER_55_361 VGND VGND VPWR VPWR sky130_fd_sc_hd__decap_3
XFILLER_30_206 VGND VGND VPWR VPWR sky130_fd_sc_hd__decap_3
XPHY_EDGE_ROW_61_Right_82 VGND VGND VPWR VPWR sky130_fd_sc_hd__decap_3
X_203_ _109_ _111_ VGND VGND VPWR VPWR _112_ sky130_fd_sc_hd__nor2_1
XFILLER_30_239 VGND VGND VPWR VPWR sky130_fd_sc_hd__decap_3
XFILLER_23_72 VGND VGND VPWR VPWR sky130_fd_sc_hd__decap_3
X_134_ _053_ _056_ VGND VGND VPWR VPWR genblk1\[1\].fa_inst.s sky130_fd_sc_hd__xnor2_1
XFILLER_2_162 VGND VGND VPWR VPWR sky130_fd_sc_hd__decap_3
XFILLER_17_6 VGND VGND VPWR VPWR sky130_fd_sc_hd__decap_3
XFILLER_48_91 VGND VGND VPWR VPWR sky130_fd_sc_hd__decap_3
XFILLER_48_80 VGND VGND VPWR VPWR sky130_fd_sc_hd__decap_3
XFILLER_38_339 VGND VGND VPWR VPWR sky130_fd_sc_hd__decap_3
XFILLER_0_21 VGND VGND VPWR VPWR sky130_fd_sc_hd__decap_3
XFILLER_0_32 VGND VGND VPWR VPWR sky130_fd_sc_hd__decap_3
XFILLER_61_320 VGND VGND VPWR VPWR sky130_fd_sc_hd__decap_3
XFILLER_46_383 VGND VGND VPWR VPWR sky130_fd_sc_hd__decap_3
XFILLER_21_206 VGND VGND VPWR VPWR sky130_fd_sc_hd__decap_3
XFILLER_61_364 VGND VGND VPWR VPWR sky130_fd_sc_hd__decap_3
XFILLER_9_52 VGND VGND VPWR VPWR sky130_fd_sc_hd__decap_3
XFILLER_9_63 VGND VGND VPWR VPWR sky130_fd_sc_hd__decap_3
XFILLER_9_96 VGND VGND VPWR VPWR sky130_fd_sc_hd__decap_3
XTAP_TAPCELL_ROW_3_1_180 VGND VPWR sky130_fd_sc_hd__tapvpwrvgnd_1
XFILLER_56_103 VGND VGND VPWR VPWR sky130_fd_sc_hd__decap_3
XFILLER_29_317 VGND VGND VPWR VPWR sky130_fd_sc_hd__decap_3
XFILLER_28_39 VGND VGND VPWR VPWR sky130_fd_sc_hd__decap_3
XFILLER_56_147 VGND VGND VPWR VPWR sky130_fd_sc_hd__decap_3
XFILLER_56_136 VGND VGND VPWR VPWR sky130_fd_sc_hd__decap_3
XTAP_TAPCELL_ROW_39_367 VGND VPWR sky130_fd_sc_hd__tapvpwrvgnd_1
XFILLER_44_309 VGND VGND VPWR VPWR sky130_fd_sc_hd__decap_3
XFILLER_37_361 VGND VGND VPWR VPWR sky130_fd_sc_hd__decap_3
XFILLER_52_342 VGND VGND VPWR VPWR sky130_fd_sc_hd__decap_3
XFILLER_44_38 VGND VGND VPWR VPWR sky130_fd_sc_hd__decap_3
XFILLER_44_27 VGND VGND VPWR VPWR sky130_fd_sc_hd__fill_1
XFILLER_52_386 VGND VGND VPWR VPWR sky130_fd_sc_hd__decap_3
XFILLER_60_59 VGND VGND VPWR VPWR sky130_fd_sc_hd__decap_3
XFILLER_4_405 VGND VGND VPWR VPWR sky130_fd_sc_hd__fill_2
XPHY_EDGE_ROW_3_1_Left_109 VGND VGND VPWR VPWR sky130_fd_sc_hd__decap_3
XFILLER_47_125 VGND VGND VPWR VPWR sky130_fd_sc_hd__decap_3
XFILLER_47_169 VGND VGND VPWR VPWR sky130_fd_sc_hd__decap_3
XFILLER_47_158 VGND VGND VPWR VPWR sky130_fd_sc_hd__decap_3
XFILLER_18_83 VGND VGND VPWR VPWR sky130_fd_sc_hd__fill_1
XFILLER_18_94 VGND VGND VPWR VPWR sky130_fd_sc_hd__decap_3
XFILLER_62_139 VGND VGND VPWR VPWR sky130_fd_sc_hd__fill_1
XFILLER_62_106 VGND VGND VPWR VPWR sky130_fd_sc_hd__decap_3
XFILLER_28_383 VGND VGND VPWR VPWR sky130_fd_sc_hd__decap_3
XFILLER_43_320 VGND VGND VPWR VPWR sky130_fd_sc_hd__decap_3
XFILLER_43_364 VGND VGND VPWR VPWR sky130_fd_sc_hd__decap_3
XFILLER_34_71 VGND VGND VPWR VPWR sky130_fd_sc_hd__decap_3
XFILLER_59_90 VGND VGND VPWR VPWR sky130_fd_sc_hd__decap_3
XFILLER_38_103 VGND VGND VPWR VPWR sky130_fd_sc_hd__decap_3
XFILLER_15_3 VGND VGND VPWR VPWR sky130_fd_sc_hd__decap_3
XFILLER_38_136 VGND VGND VPWR VPWR sky130_fd_sc_hd__decap_3
XFILLER_26_309 VGND VGND VPWR VPWR sky130_fd_sc_hd__decap_3
XFILLER_38_147 VGND VGND VPWR VPWR sky130_fd_sc_hd__decap_3
XFILLER_19_361 VGND VGND VPWR VPWR sky130_fd_sc_hd__decap_3
XFILLER_53_128 VGND VGND VPWR VPWR sky130_fd_sc_hd__decap_3
XFILLER_19_394 VGND VGND VPWR VPWR sky130_fd_sc_hd__decap_3
XTAP_TAPCELL_ROW_36_348 VGND VPWR sky130_fd_sc_hd__tapvpwrvgnd_1
XFILLER_46_180 VGND VGND VPWR VPWR sky130_fd_sc_hd__decap_3
XFILLER_34_342 VGND VGND VPWR VPWR sky130_fd_sc_hd__decap_3
XFILLER_61_161 VGND VGND VPWR VPWR sky130_fd_sc_hd__decap_3
XFILLER_34_386 VGND VGND VPWR VPWR sky130_fd_sc_hd__decap_3
XFILLER_61_172 VGND VGND VPWR VPWR sky130_fd_sc_hd__decap_3
XFILLER_30_18 VGND VGND VPWR VPWR sky130_fd_sc_hd__decap_3
XFILLER_29_125 VGND VGND VPWR VPWR sky130_fd_sc_hd__decap_3
XFILLER_29_169 VGND VGND VPWR VPWR sky130_fd_sc_hd__decap_3
XFILLER_29_158 VGND VGND VPWR VPWR sky130_fd_sc_hd__decap_3
XFILLER_55_37 VGND VGND VPWR VPWR sky130_fd_sc_hd__decap_3
XFILLER_25_320 VGND VGND VPWR VPWR sky130_fd_sc_hd__decap_3
XFILLER_44_139 VGND VGND VPWR VPWR sky130_fd_sc_hd__fill_1
XFILLER_25_364 VGND VGND VPWR VPWR sky130_fd_sc_hd__decap_3
XFILLER_52_150 VGND VGND VPWR VPWR sky130_fd_sc_hd__decap_3
XFILLER_40_301 VGND VGND VPWR VPWR sky130_fd_sc_hd__decap_3
XFILLER_52_183 VGND VGND VPWR VPWR sky130_fd_sc_hd__decap_3
XFILLER_40_312 VGND VGND VPWR VPWR sky130_fd_sc_hd__decap_3
XPHY_EDGE_ROW_1_2_Right_87 VGND VGND VPWR VPWR sky130_fd_sc_hd__decap_3
XFILLER_40_345 VGND VGND VPWR VPWR sky130_fd_sc_hd__decap_3
XFILLER_40_389 VGND VGND VPWR VPWR sky130_fd_sc_hd__decap_3
XFILLER_20_62 VGND VGND VPWR VPWR sky130_fd_sc_hd__decap_3
XFILLER_20_73 VGND VGND VPWR VPWR sky130_fd_sc_hd__decap_3
XFILLER_48_401 VGND VGND VPWR VPWR sky130_fd_sc_hd__decap_3
XFILLER_29_60 VGND VGND VPWR VPWR sky130_fd_sc_hd__decap_3
XFILLER_29_93 VGND VGND VPWR VPWR sky130_fd_sc_hd__decap_3
XFILLER_35_128 VGND VGND VPWR VPWR sky130_fd_sc_hd__decap_3
XFILLER_35_106 VGND VGND VPWR VPWR sky130_fd_sc_hd__decap_3
XFILLER_16_331 VGND VGND VPWR VPWR sky130_fd_sc_hd__decap_3
XFILLER_28_180 VGND VGND VPWR VPWR sky130_fd_sc_hd__decap_3
XFILLER_16_375 VGND VGND VPWR VPWR sky130_fd_sc_hd__decap_3
XFILLER_50_109 VGND VGND VPWR VPWR sky130_fd_sc_hd__decap_3
XFILLER_43_161 VGND VGND VPWR VPWR sky130_fd_sc_hd__decap_3
XTAP_TAPCELL_ROW_33_329 VGND VPWR sky130_fd_sc_hd__tapvpwrvgnd_1
XFILLER_43_172 VGND VGND VPWR VPWR sky130_fd_sc_hd__decap_3
XFILLER_31_323 VGND VGND VPWR VPWR sky130_fd_sc_hd__decap_3
XFILLER_31_367 VGND VGND VPWR VPWR sky130_fd_sc_hd__decap_3
XTAP_TAPCELL_ROW_41_384 VGND VPWR sky130_fd_sc_hd__tapvpwrvgnd_1
XANTENNA_2 net44 VGND VGND VPWR VPWR sky130_fd_sc_hd__diode_2
XFILLER_6_53 VGND VGND VPWR VPWR sky130_fd_sc_hd__decap_3
XFILLER_6_97 VGND VGND VPWR VPWR sky130_fd_sc_hd__decap_3
Xpmu_inst_67 VGND VGND VPWR VPWR pmu_inst_67/HI net67 sky130_fd_sc_hd__conb_1
XFILLER_58_209 VGND VGND VPWR VPWR sky130_fd_sc_hd__decap_3
XTAP_TAPCELL_ROW_49_440 VGND VPWR sky130_fd_sc_hd__tapvpwrvgnd_1
XFILLER_26_106 VGND VGND VPWR VPWR sky130_fd_sc_hd__decap_3
XFILLER_54_404 VGND VGND VPWR VPWR sky130_fd_sc_hd__decap_3
XFILLER_26_139 VGND VGND VPWR VPWR sky130_fd_sc_hd__fill_1
XFILLER_22_301 VGND VGND VPWR VPWR sky130_fd_sc_hd__decap_3
XFILLER_34_150 VGND VGND VPWR VPWR sky130_fd_sc_hd__decap_3
XFILLER_22_312 VGND VGND VPWR VPWR sky130_fd_sc_hd__decap_3
XFILLER_34_183 VGND VGND VPWR VPWR sky130_fd_sc_hd__decap_3
XFILLER_22_345 VGND VGND VPWR VPWR sky130_fd_sc_hd__decap_3
XFILLER_22_389 VGND VGND VPWR VPWR sky130_fd_sc_hd__decap_3
XFILLER_57_220 VGND VGND VPWR VPWR sky130_fd_sc_hd__decap_3
XFILLER_57_231 VGND VGND VPWR VPWR sky130_fd_sc_hd__decap_3
XFILLER_17_106 VGND VGND VPWR VPWR sky130_fd_sc_hd__decap_3
XFILLER_57_264 VGND VGND VPWR VPWR sky130_fd_sc_hd__decap_3
XFILLER_17_128 VGND VGND VPWR VPWR sky130_fd_sc_hd__decap_3
XFILLER_13_334 VGND VGND VPWR VPWR sky130_fd_sc_hd__decap_3
XFILLER_15_40 VGND VGND VPWR VPWR sky130_fd_sc_hd__decap_3
XFILLER_25_161 VGND VGND VPWR VPWR sky130_fd_sc_hd__decap_3
XFILLER_25_172 VGND VGND VPWR VPWR sky130_fd_sc_hd__decap_3
XFILLER_13_367 VGND VGND VPWR VPWR sky130_fd_sc_hd__decap_3
XFILLER_15_84 VGND VGND VPWR VPWR sky130_fd_sc_hd__decap_3
XFILLER_40_153 VGND VGND VPWR VPWR sky130_fd_sc_hd__decap_3
XFILLER_9_349 VGND VGND VPWR VPWR sky130_fd_sc_hd__decap_3
XFILLER_40_186 VGND VGND VPWR VPWR sky130_fd_sc_hd__decap_3
XFILLER_40_197 VGND VGND VPWR VPWR sky130_fd_sc_hd__decap_3
XFILLER_31_50 VGND VGND VPWR VPWR sky130_fd_sc_hd__decap_3
XFILLER_31_72 VGND VGND VPWR VPWR sky130_fd_sc_hd__decap_3
Xoutput50 net50 VGND VGND VPWR VPWR s[5] sky130_fd_sc_hd__buf_2
XFILLER_49_9 VGND VGND VPWR VPWR sky130_fd_sc_hd__decap_3
XFILLER_48_253 VGND VGND VPWR VPWR sky130_fd_sc_hd__decap_3
XFILLER_48_242 VGND VGND VPWR VPWR sky130_fd_sc_hd__decap_3
XFILLER_48_286 VGND VGND VPWR VPWR sky130_fd_sc_hd__decap_3
XFILLER_36_404 VGND VGND VPWR VPWR sky130_fd_sc_hd__decap_3
XFILLER_63_223 VGND VGND VPWR VPWR sky130_fd_sc_hd__fill_1
XFILLER_63_234 VGND VGND VPWR VPWR sky130_fd_sc_hd__decap_3
XFILLER_56_91 VGND VGND VPWR VPWR sky130_fd_sc_hd__decap_3
XFILLER_16_150 VGND VGND VPWR VPWR sky130_fd_sc_hd__decap_3
XFILLER_63_267 VGND VGND VPWR VPWR sky130_fd_sc_hd__decap_3
XFILLER_31_131 VGND VGND VPWR VPWR sky130_fd_sc_hd__decap_3
XFILLER_31_175 VGND VGND VPWR VPWR sky130_fd_sc_hd__decap_3
XFILLER_31_164 VGND VGND VPWR VPWR sky130_fd_sc_hd__decap_3
XFILLER_8_360 VGND VGND VPWR VPWR sky130_fd_sc_hd__decap_3
XFILLER_8_393 VGND VGND VPWR VPWR sky130_fd_sc_hd__decap_3
XFILLER_39_231 VGND VGND VPWR VPWR sky130_fd_sc_hd__decap_3
XFILLER_39_220 VGND VGND VPWR VPWR sky130_fd_sc_hd__decap_3
XFILLER_54_212 VGND VGND VPWR VPWR sky130_fd_sc_hd__decap_3
XFILLER_39_264 VGND VGND VPWR VPWR sky130_fd_sc_hd__decap_3
XFILLER_54_245 VGND VGND VPWR VPWR sky130_fd_sc_hd__decap_3
XFILLER_36_39 VGND VGND VPWR VPWR sky130_fd_sc_hd__decap_3
XFILLER_14_109 VGND VGND VPWR VPWR sky130_fd_sc_hd__decap_3
XFILLER_54_256 VGND VGND VPWR VPWR sky130_fd_sc_hd__decap_3
XFILLER_54_289 VGND VGND VPWR VPWR sky130_fd_sc_hd__decap_3
XTAP_TAPCELL_ROW_52_457 VGND VPWR sky130_fd_sc_hd__tapvpwrvgnd_1
XFILLER_52_38 VGND VGND VPWR VPWR sky130_fd_sc_hd__decap_3
XFILLER_22_153 VGND VGND VPWR VPWR sky130_fd_sc_hd__decap_3
XFILLER_10_337 VGND VGND VPWR VPWR sky130_fd_sc_hd__decap_3
XFILLER_22_186 VGND VGND VPWR VPWR sky130_fd_sc_hd__decap_3
XFILLER_22_197 VGND VGND VPWR VPWR sky130_fd_sc_hd__decap_3
XFILLER_45_234 VGND VGND VPWR VPWR sky130_fd_sc_hd__decap_3
XFILLER_45_223 VGND VGND VPWR VPWR sky130_fd_sc_hd__fill_1
XFILLER_45_267 VGND VGND VPWR VPWR sky130_fd_sc_hd__decap_3
XFILLER_26_72 VGND VGND VPWR VPWR sky130_fd_sc_hd__decap_3
XFILLER_60_215 VGND VGND VPWR VPWR sky130_fd_sc_hd__decap_3
XFILLER_13_131 VGND VGND VPWR VPWR sky130_fd_sc_hd__decap_3
XFILLER_26_94 VGND VGND VPWR VPWR sky130_fd_sc_hd__decap_3
XFILLER_60_259 VGND VGND VPWR VPWR sky130_fd_sc_hd__decap_3
XFILLER_60_248 VGND VGND VPWR VPWR sky130_fd_sc_hd__decap_3
XFILLER_13_164 VGND VGND VPWR VPWR sky130_fd_sc_hd__decap_3
XFILLER_13_175 VGND VGND VPWR VPWR sky130_fd_sc_hd__decap_3
XFILLER_9_102 VGND VGND VPWR VPWR sky130_fd_sc_hd__decap_3
XFILLER_9_146 VGND VGND VPWR VPWR sky130_fd_sc_hd__decap_3
X_296_ clknet_2_2__leaf_clk_regs net31 _041_ VGND VGND VPWR VPWR genblk1\[8\].fa_inst.b
+ sky130_fd_sc_hd__dfrtp_1
XFILLER_42_71 VGND VGND VPWR VPWR sky130_fd_sc_hd__decap_3
XFILLER_5_352 VGND VGND VPWR VPWR sky130_fd_sc_hd__decap_3
XFILLER_5_385 VGND VGND VPWR VPWR sky130_fd_sc_hd__decap_3
XFILLER_47_6 VGND VGND VPWR VPWR sky130_fd_sc_hd__decap_3
XFILLER_3_87 VGND VGND VPWR VPWR sky130_fd_sc_hd__decap_3
XFILLER_36_212 VGND VGND VPWR VPWR sky130_fd_sc_hd__decap_3
XFILLER_36_256 VGND VGND VPWR VPWR sky130_fd_sc_hd__decap_3
XFILLER_36_245 VGND VGND VPWR VPWR sky130_fd_sc_hd__decap_3
XFILLER_51_237 VGND VGND VPWR VPWR sky130_fd_sc_hd__decap_3
XFILLER_36_289 VGND VGND VPWR VPWR sky130_fd_sc_hd__decap_3
XFILLER_59_337 VGND VGND VPWR VPWR sky130_fd_sc_hd__decap_3
XFILLER_59_326 VGND VGND VPWR VPWR sky130_fd_sc_hd__decap_3
XFILLER_47_27 VGND VGND VPWR VPWR sky130_fd_sc_hd__decap_3
XFILLER_27_223 VGND VGND VPWR VPWR sky130_fd_sc_hd__fill_1
XFILLER_27_234 VGND VGND VPWR VPWR sky130_fd_sc_hd__decap_3
XTAP_TAPCELL_ROW_4_1_182 VGND VPWR sky130_fd_sc_hd__tapvpwrvgnd_1
XFILLER_27_267 VGND VGND VPWR VPWR sky130_fd_sc_hd__decap_3
XFILLER_63_37 VGND VGND VPWR VPWR sky130_fd_sc_hd__decap_3
XFILLER_42_215 VGND VGND VPWR VPWR sky130_fd_sc_hd__decap_3
XFILLER_42_259 VGND VGND VPWR VPWR sky130_fd_sc_hd__decap_3
XFILLER_42_248 VGND VGND VPWR VPWR sky130_fd_sc_hd__decap_3
XFILLER_10_112 VGND VGND VPWR VPWR sky130_fd_sc_hd__decap_3
X_150_ genblk1\[5\].fa_inst.b genblk1\[5\].fa_inst.a VGND VGND VPWR VPWR _069_ sky130_fd_sc_hd__or2_1
XFILLER_50_292 VGND VGND VPWR VPWR sky130_fd_sc_hd__decap_3
XFILLER_10_156 VGND VGND VPWR VPWR sky130_fd_sc_hd__decap_3
XFILLER_12_41 VGND VGND VPWR VPWR sky130_fd_sc_hd__decap_3
XFILLER_6_127 VGND VGND VPWR VPWR sky130_fd_sc_hd__decap_3
XFILLER_12_74 VGND VGND VPWR VPWR sky130_fd_sc_hd__decap_3
XFILLER_12_85 VGND VGND VPWR VPWR sky130_fd_sc_hd__decap_3
XFILLER_2_366 VGND VGND VPWR VPWR sky130_fd_sc_hd__decap_3
XFILLER_2_399 VGND VGND VPWR VPWR sky130_fd_sc_hd__decap_3
XFILLER_58_392 VGND VGND VPWR VPWR sky130_fd_sc_hd__decap_3
XFILLER_37_60 VGND VGND VPWR VPWR sky130_fd_sc_hd__decap_3
XFILLER_33_237 VGND VGND VPWR VPWR sky130_fd_sc_hd__decap_3
XFILLER_53_81 VGND VGND VPWR VPWR sky130_fd_sc_hd__decap_3
XFILLER_41_281 VGND VGND VPWR VPWR sky130_fd_sc_hd__decap_3
XFILLER_41_270 VGND VGND VPWR VPWR sky130_fd_sc_hd__decap_3
X_279_ clknet_2_1__leaf_clk_regs net14 _024_ VGND VGND VPWR VPWR genblk1\[7\].fa_inst.a
+ sky130_fd_sc_hd__dfrtp_1
XFILLER_45_3 VGND VGND VPWR VPWR sky130_fd_sc_hd__decap_3
XFILLER_56_318 VGND VGND VPWR VPWR sky130_fd_sc_hd__decap_3
XFILLER_56_307 VGND VGND VPWR VPWR sky130_fd_sc_hd__fill_1
XFILLER_49_370 VGND VGND VPWR VPWR sky130_fd_sc_hd__decap_3
XFILLER_64_340 VGND VGND VPWR VPWR sky130_fd_sc_hd__decap_3
XFILLER_24_215 VGND VGND VPWR VPWR sky130_fd_sc_hd__decap_3
XFILLER_24_248 VGND VGND VPWR VPWR sky130_fd_sc_hd__decap_3
XFILLER_24_259 VGND VGND VPWR VPWR sky130_fd_sc_hd__decap_3
XTAP_TAPCELL_ROW_62_530 VGND VPWR sky130_fd_sc_hd__tapvpwrvgnd_1
XFILLER_32_292 VGND VGND VPWR VPWR sky130_fd_sc_hd__decap_3
XFILLER_3_119 VGND VGND VPWR VPWR sky130_fd_sc_hd__decap_3
XFILLER_58_15 VGND VGND VPWR VPWR sky130_fd_sc_hd__decap_3
XFILLER_59_123 VGND VGND VPWR VPWR sky130_fd_sc_hd__decap_3
XFILLER_59_178 VGND VGND VPWR VPWR sky130_fd_sc_hd__decap_3
XFILLER_59_156 VGND VGND VPWR VPWR sky130_fd_sc_hd__decap_3
XFILLER_47_329 VGND VGND VPWR VPWR sky130_fd_sc_hd__decap_3
XFILLER_55_340 VGND VGND VPWR VPWR sky130_fd_sc_hd__decap_3
XFILLER_55_373 VGND VGND VPWR VPWR sky130_fd_sc_hd__decap_3
XFILLER_30_218 VGND VGND VPWR VPWR sky130_fd_sc_hd__decap_3
XFILLER_23_270 VGND VGND VPWR VPWR sky130_fd_sc_hd__decap_3
XFILLER_23_281 VGND VGND VPWR VPWR sky130_fd_sc_hd__decap_3
X_202_ genblk1\[15\].fa_inst.b genblk1\[15\].fa_inst.a VGND VGND VPWR VPWR _111_ sky130_fd_sc_hd__nor2_1
XFILLER_7_403 VGND VGND VPWR VPWR sky130_fd_sc_hd__decap_3
X_133_ _054_ _055_ VGND VGND VPWR VPWR _056_ sky130_fd_sc_hd__nand2_1
XFILLER_2_130 VGND VGND VPWR VPWR sky130_fd_sc_hd__decap_3
XFILLER_31_9 VGND VGND VPWR VPWR sky130_fd_sc_hd__decap_3
XFILLER_2_174 VGND VGND VPWR VPWR sky130_fd_sc_hd__decap_3
XFILLER_2_141 VGND VGND VPWR VPWR sky130_fd_sc_hd__decap_3
XFILLER_38_318 VGND VGND VPWR VPWR sky130_fd_sc_hd__decap_3
XFILLER_38_307 VGND VGND VPWR VPWR sky130_fd_sc_hd__fill_1
XFILLER_0_44 VGND VGND VPWR VPWR sky130_fd_sc_hd__decap_3
XFILLER_46_351 VGND VGND VPWR VPWR sky130_fd_sc_hd__decap_3
XFILLER_0_66 VGND VGND VPWR VPWR sky130_fd_sc_hd__decap_3
XFILLER_0_88 VGND VGND VPWR VPWR sky130_fd_sc_hd__decap_3
XFILLER_64_91 VGND VGND VPWR VPWR sky130_fd_sc_hd__decap_3
XFILLER_61_343 VGND VGND VPWR VPWR sky130_fd_sc_hd__decap_3
XFILLER_61_332 VGND VGND VPWR VPWR sky130_fd_sc_hd__decap_3
XFILLER_46_395 VGND VGND VPWR VPWR sky130_fd_sc_hd__decap_3
XFILLER_21_218 VGND VGND VPWR VPWR sky130_fd_sc_hd__decap_3
XFILLER_61_376 VGND VGND VPWR VPWR sky130_fd_sc_hd__decap_3
XFILLER_9_31 VGND VGND VPWR VPWR sky130_fd_sc_hd__decap_3
XFILLER_9_75 VGND VGND VPWR VPWR sky130_fd_sc_hd__decap_3
XFILLER_28_29 VGND VGND VPWR VPWR sky130_fd_sc_hd__fill_1
XFILLER_28_18 VGND VGND VPWR VPWR sky130_fd_sc_hd__decap_3
XFILLER_56_115 VGND VGND VPWR VPWR sky130_fd_sc_hd__decap_3
XFILLER_29_329 VGND VGND VPWR VPWR sky130_fd_sc_hd__decap_3
XTAP_TAPCELL_ROW_39_368 VGND VPWR sky130_fd_sc_hd__tapvpwrvgnd_1
XFILLER_56_159 VGND VGND VPWR VPWR sky130_fd_sc_hd__decap_3
XFILLER_37_340 VGND VGND VPWR VPWR sky130_fd_sc_hd__decap_3
XFILLER_37_373 VGND VGND VPWR VPWR sky130_fd_sc_hd__decap_3
XFILLER_64_181 VGND VGND VPWR VPWR sky130_fd_sc_hd__decap_3
XFILLER_52_321 VGND VGND VPWR VPWR sky130_fd_sc_hd__decap_3
XFILLER_52_365 VGND VGND VPWR VPWR sky130_fd_sc_hd__decap_3
XFILLER_52_354 VGND VGND VPWR VPWR sky130_fd_sc_hd__decap_3
XFILLER_52_398 VGND VGND VPWR VPWR sky130_fd_sc_hd__decap_3
XTAP_TAPCELL_ROW_22_246 VGND VPWR sky130_fd_sc_hd__tapvpwrvgnd_1
XFILLER_60_38 VGND VGND VPWR VPWR sky130_fd_sc_hd__decap_3
XFILLER_47_137 VGND VGND VPWR VPWR sky130_fd_sc_hd__decap_3
XFILLER_28_351 VGND VGND VPWR VPWR sky130_fd_sc_hd__decap_3
XFILLER_62_118 VGND VGND VPWR VPWR sky130_fd_sc_hd__decap_3
XFILLER_55_181 VGND VGND VPWR VPWR sky130_fd_sc_hd__decap_3
XFILLER_43_343 VGND VGND VPWR VPWR sky130_fd_sc_hd__decap_3
XFILLER_43_332 VGND VGND VPWR VPWR sky130_fd_sc_hd__decap_3
XFILLER_28_395 VGND VGND VPWR VPWR sky130_fd_sc_hd__decap_3
XPHY_EDGE_ROW_10_2_Left_31 VGND VGND VPWR VPWR sky130_fd_sc_hd__decap_3
XFILLER_43_376 VGND VGND VPWR VPWR sky130_fd_sc_hd__decap_3
XFILLER_34_50 VGND VGND VPWR VPWR sky130_fd_sc_hd__decap_3
XFILLER_34_94 VGND VGND VPWR VPWR sky130_fd_sc_hd__decap_3
XFILLER_34_83 VGND VGND VPWR VPWR sky130_fd_sc_hd__fill_1
XFILLER_50_71 VGND VGND VPWR VPWR sky130_fd_sc_hd__decap_3
XFILLER_38_115 VGND VGND VPWR VPWR sky130_fd_sc_hd__decap_3
XFILLER_19_340 VGND VGND VPWR VPWR sky130_fd_sc_hd__decap_3
XFILLER_38_159 VGND VGND VPWR VPWR sky130_fd_sc_hd__decap_3
XFILLER_19_373 VGND VGND VPWR VPWR sky130_fd_sc_hd__decap_3
XTAP_TAPCELL_ROW_36_349 VGND VPWR sky130_fd_sc_hd__tapvpwrvgnd_1
XFILLER_46_192 VGND VGND VPWR VPWR sky130_fd_sc_hd__decap_3
XFILLER_34_321 VGND VGND VPWR VPWR sky130_fd_sc_hd__decap_3
XFILLER_61_140 VGND VGND VPWR VPWR sky130_fd_sc_hd__decap_3
XFILLER_34_365 VGND VGND VPWR VPWR sky130_fd_sc_hd__decap_3
XFILLER_34_354 VGND VGND VPWR VPWR sky130_fd_sc_hd__decap_3
XFILLER_61_184 VGND VGND VPWR VPWR sky130_fd_sc_hd__decap_3
XFILLER_34_398 VGND VGND VPWR VPWR sky130_fd_sc_hd__decap_3
XPHY_EDGE_ROW_10_1_Right_9 VGND VGND VPWR VPWR sky130_fd_sc_hd__decap_3
XFILLER_29_137 VGND VGND VPWR VPWR sky130_fd_sc_hd__decap_3
XFILLER_44_118 VGND VGND VPWR VPWR sky130_fd_sc_hd__decap_3
XFILLER_25_332 VGND VGND VPWR VPWR sky130_fd_sc_hd__decap_3
XFILLER_25_343 VGND VGND VPWR VPWR sky130_fd_sc_hd__decap_3
XFILLER_37_181 VGND VGND VPWR VPWR sky130_fd_sc_hd__decap_3
XFILLER_25_376 VGND VGND VPWR VPWR sky130_fd_sc_hd__decap_3
XFILLER_52_162 VGND VGND VPWR VPWR sky130_fd_sc_hd__decap_3
XFILLER_52_195 VGND VGND VPWR VPWR sky130_fd_sc_hd__fill_1
XFILLER_40_324 VGND VGND VPWR VPWR sky130_fd_sc_hd__decap_3
XFILLER_40_368 VGND VGND VPWR VPWR sky130_fd_sc_hd__decap_3
XFILLER_40_357 VGND VGND VPWR VPWR sky130_fd_sc_hd__decap_3
XFILLER_20_41 VGND VGND VPWR VPWR sky130_fd_sc_hd__decap_3
XFILLER_20_85 VGND VGND VPWR VPWR sky130_fd_sc_hd__decap_3
XFILLER_29_72 VGND VGND VPWR VPWR sky130_fd_sc_hd__decap_3
XFILLER_63_405 VGND VGND VPWR VPWR sky130_fd_sc_hd__fill_2
XFILLER_28_192 VGND VGND VPWR VPWR sky130_fd_sc_hd__decap_3
XFILLER_16_343 VGND VGND VPWR VPWR sky130_fd_sc_hd__decap_3
XFILLER_16_354 VGND VGND VPWR VPWR sky130_fd_sc_hd__decap_3
XFILLER_45_82 VGND VGND VPWR VPWR sky130_fd_sc_hd__decap_3
XFILLER_43_140 VGND VGND VPWR VPWR sky130_fd_sc_hd__decap_3
XFILLER_16_387 VGND VGND VPWR VPWR sky130_fd_sc_hd__decap_3
XFILLER_43_184 VGND VGND VPWR VPWR sky130_fd_sc_hd__decap_3
XFILLER_31_335 VGND VGND VPWR VPWR sky130_fd_sc_hd__fill_1
XFILLER_31_302 VGND VGND VPWR VPWR sky130_fd_sc_hd__decap_3
XFILLER_31_346 VGND VGND VPWR VPWR sky130_fd_sc_hd__decap_3
XFILLER_31_379 VGND VGND VPWR VPWR sky130_fd_sc_hd__decap_3
XTAP_TAPCELL_ROW_41_385 VGND VPWR sky130_fd_sc_hd__tapvpwrvgnd_1
XFILLER_61_81 VGND VGND VPWR VPWR sky130_fd_sc_hd__decap_3
XANTENNA_3 net52 VGND VGND VPWR VPWR sky130_fd_sc_hd__diode_2
XFILLER_6_21 VGND VGND VPWR VPWR sky130_fd_sc_hd__decap_3
XFILLER_6_32 VGND VGND VPWR VPWR sky130_fd_sc_hd__decap_3
XFILLER_6_65 VGND VGND VPWR VPWR sky130_fd_sc_hd__fill_2
Xpmu_inst_68 VGND VGND VPWR VPWR pmu_inst_68/HI net68 sky130_fd_sc_hd__conb_1
XFILLER_39_402 VGND VGND VPWR VPWR sky130_fd_sc_hd__decap_3
XTAP_TAPCELL_ROW_49_441 VGND VPWR sky130_fd_sc_hd__tapvpwrvgnd_1
XFILLER_26_118 VGND VGND VPWR VPWR sky130_fd_sc_hd__decap_3
XFILLER_22_324 VGND VGND VPWR VPWR sky130_fd_sc_hd__decap_3
XFILLER_34_162 VGND VGND VPWR VPWR sky130_fd_sc_hd__decap_3
XFILLER_22_357 VGND VGND VPWR VPWR sky130_fd_sc_hd__decap_3
XFILLER_22_368 VGND VGND VPWR VPWR sky130_fd_sc_hd__decap_3
XFILLER_34_195 VGND VGND VPWR VPWR sky130_fd_sc_hd__fill_1
XFILLER_57_243 VGND VGND VPWR VPWR sky130_fd_sc_hd__decap_3
XFILLER_57_276 VGND VGND VPWR VPWR sky130_fd_sc_hd__decap_3
XFILLER_25_140 VGND VGND VPWR VPWR sky130_fd_sc_hd__decap_3
XFILLER_25_184 VGND VGND VPWR VPWR sky130_fd_sc_hd__decap_3
XTAP_TAPCELL_ROW_55_477 VGND VPWR sky130_fd_sc_hd__tapvpwrvgnd_1
XFILLER_13_346 VGND VGND VPWR VPWR sky130_fd_sc_hd__decap_3
XFILLER_15_52 VGND VGND VPWR VPWR sky130_fd_sc_hd__decap_3
XFILLER_15_63 VGND VGND VPWR VPWR sky130_fd_sc_hd__decap_3
XFILLER_40_121 VGND VGND VPWR VPWR sky130_fd_sc_hd__decap_3
XFILLER_13_379 VGND VGND VPWR VPWR sky130_fd_sc_hd__fill_2
XFILLER_15_96 VGND VGND VPWR VPWR sky130_fd_sc_hd__decap_3
XFILLER_9_328 VGND VGND VPWR VPWR sky130_fd_sc_hd__decap_3
XFILLER_40_165 VGND VGND VPWR VPWR sky130_fd_sc_hd__decap_3
XTAP_TAPCELL_ROW_5_1_184 VGND VPWR sky130_fd_sc_hd__tapvpwrvgnd_1
XFILLER_31_84 VGND VGND VPWR VPWR sky130_fd_sc_hd__decap_3
Xoutput40 net40 VGND VGND VPWR VPWR s[10] sky130_fd_sc_hd__buf_2
Xoutput51 net51 VGND VGND VPWR VPWR s[6] sky130_fd_sc_hd__buf_2
XFILLER_48_221 VGND VGND VPWR VPWR sky130_fd_sc_hd__decap_3
XFILLER_63_202 VGND VGND VPWR VPWR sky130_fd_sc_hd__decap_3
XFILLER_48_265 VGND VGND VPWR VPWR sky130_fd_sc_hd__decap_3
XFILLER_63_246 VGND VGND VPWR VPWR sky130_fd_sc_hd__decap_3
XFILLER_48_298 VGND VGND VPWR VPWR sky130_fd_sc_hd__decap_3
XFILLER_63_279 VGND VGND VPWR VPWR sky130_fd_sc_hd__fill_1
XFILLER_16_162 VGND VGND VPWR VPWR sky130_fd_sc_hd__decap_3
XFILLER_31_143 VGND VGND VPWR VPWR sky130_fd_sc_hd__decap_3
XFILLER_12_390 VGND VGND VPWR VPWR sky130_fd_sc_hd__decap_3
XFILLER_31_187 VGND VGND VPWR VPWR sky130_fd_sc_hd__decap_3
XFILLER_8_372 VGND VGND VPWR VPWR sky130_fd_sc_hd__decap_3
XFILLER_39_243 VGND VGND VPWR VPWR sky130_fd_sc_hd__decap_3
XFILLER_27_405 VGND VGND VPWR VPWR sky130_fd_sc_hd__fill_2
XFILLER_39_276 VGND VGND VPWR VPWR sky130_fd_sc_hd__decap_3
XFILLER_36_18 VGND VGND VPWR VPWR sky130_fd_sc_hd__decap_3
XFILLER_54_224 VGND VGND VPWR VPWR sky130_fd_sc_hd__decap_3
XFILLER_39_287 VGND VGND VPWR VPWR sky130_fd_sc_hd__decap_3
XFILLER_36_29 VGND VGND VPWR VPWR sky130_fd_sc_hd__fill_1
XFILLER_54_268 VGND VGND VPWR VPWR sky130_fd_sc_hd__decap_3
XFILLER_22_121 VGND VGND VPWR VPWR sky130_fd_sc_hd__decap_3
XTAP_TAPCELL_ROW_52_458 VGND VPWR sky130_fd_sc_hd__tapvpwrvgnd_1
XFILLER_22_165 VGND VGND VPWR VPWR sky130_fd_sc_hd__decap_3
XFILLER_10_349 VGND VGND VPWR VPWR sky130_fd_sc_hd__decap_3
XFILLER_7_6 VGND VGND VPWR VPWR sky130_fd_sc_hd__decap_3
XFILLER_18_405 VGND VGND VPWR VPWR sky130_fd_sc_hd__fill_2
XFILLER_45_202 VGND VGND VPWR VPWR sky130_fd_sc_hd__decap_3
XFILLER_45_246 VGND VGND VPWR VPWR sky130_fd_sc_hd__decap_3
XFILLER_60_227 VGND VGND VPWR VPWR sky130_fd_sc_hd__decap_3
XFILLER_45_279 VGND VGND VPWR VPWR sky130_fd_sc_hd__fill_1
XFILLER_53_290 VGND VGND VPWR VPWR sky130_fd_sc_hd__decap_3
XFILLER_13_143 VGND VGND VPWR VPWR sky130_fd_sc_hd__decap_3
XFILLER_9_125 VGND VGND VPWR VPWR sky130_fd_sc_hd__decap_3
XFILLER_9_158 VGND VGND VPWR VPWR sky130_fd_sc_hd__decap_3
X_295_ clknet_2_1__leaf_clk_regs net30 _040_ VGND VGND VPWR VPWR genblk1\[7\].fa_inst.b
+ sky130_fd_sc_hd__dfrtp_1
XFILLER_42_50 VGND VGND VPWR VPWR sky130_fd_sc_hd__decap_3
XFILLER_9_169 VGND VGND VPWR VPWR sky130_fd_sc_hd__decap_3
XFILLER_42_94 VGND VGND VPWR VPWR sky130_fd_sc_hd__fill_2
XFILLER_42_83 VGND VGND VPWR VPWR sky130_fd_sc_hd__fill_1
XFILLER_61_9 VGND VGND VPWR VPWR sky130_fd_sc_hd__decap_3
XFILLER_5_331 VGND VGND VPWR VPWR sky130_fd_sc_hd__decap_3
XFILLER_5_364 VGND VGND VPWR VPWR sky130_fd_sc_hd__decap_3
XFILLER_5_397 VGND VGND VPWR VPWR sky130_fd_sc_hd__decap_3
XFILLER_3_66 VGND VGND VPWR VPWR sky130_fd_sc_hd__decap_3
XFILLER_36_224 VGND VGND VPWR VPWR sky130_fd_sc_hd__decap_3
XFILLER_36_268 VGND VGND VPWR VPWR sky130_fd_sc_hd__decap_3
XFILLER_51_205 VGND VGND VPWR VPWR sky130_fd_sc_hd__decap_3
XFILLER_51_249 VGND VGND VPWR VPWR sky130_fd_sc_hd__decap_3
XFILLER_59_305 VGND VGND VPWR VPWR sky130_fd_sc_hd__decap_3
XFILLER_59_349 VGND VGND VPWR VPWR sky130_fd_sc_hd__decap_3
XFILLER_47_39 VGND VGND VPWR VPWR sky130_fd_sc_hd__decap_3
XFILLER_27_202 VGND VGND VPWR VPWR sky130_fd_sc_hd__decap_3
XFILLER_27_246 VGND VGND VPWR VPWR sky130_fd_sc_hd__decap_3
XTAP_TAPCELL_ROW_4_1_183 VGND VPWR sky130_fd_sc_hd__tapvpwrvgnd_1
XFILLER_27_279 VGND VGND VPWR VPWR sky130_fd_sc_hd__fill_1
XFILLER_63_16 VGND VGND VPWR VPWR sky130_fd_sc_hd__decap_3
XFILLER_63_49 VGND VGND VPWR VPWR sky130_fd_sc_hd__decap_3
XFILLER_42_227 VGND VGND VPWR VPWR sky130_fd_sc_hd__decap_3
XFILLER_35_290 VGND VGND VPWR VPWR sky130_fd_sc_hd__decap_3
XFILLER_10_124 VGND VGND VPWR VPWR sky130_fd_sc_hd__decap_3
XFILLER_50_271 VGND VGND VPWR VPWR sky130_fd_sc_hd__decap_3
XFILLER_10_168 VGND VGND VPWR VPWR sky130_fd_sc_hd__decap_3
XFILLER_6_106 VGND VGND VPWR VPWR sky130_fd_sc_hd__decap_3
XFILLER_12_53 VGND VGND VPWR VPWR sky130_fd_sc_hd__decap_3
XFILLER_6_139 VGND VGND VPWR VPWR sky130_fd_sc_hd__fill_1
XFILLER_12_97 VGND VGND VPWR VPWR sky130_fd_sc_hd__decap_3
XFILLER_5_3 VGND VGND VPWR VPWR sky130_fd_sc_hd__decap_3
XFILLER_2_334 VGND VGND VPWR VPWR sky130_fd_sc_hd__decap_3
XFILLER_2_378 VGND VGND VPWR VPWR sky130_fd_sc_hd__decap_3
XFILLER_58_360 VGND VGND VPWR VPWR sky130_fd_sc_hd__decap_3
XFILLER_58_371 VGND VGND VPWR VPWR sky130_fd_sc_hd__decap_3
XFILLER_37_83 VGND VGND VPWR VPWR sky130_fd_sc_hd__decap_3
XFILLER_33_205 VGND VGND VPWR VPWR sky130_fd_sc_hd__decap_3
XFILLER_33_249 VGND VGND VPWR VPWR sky130_fd_sc_hd__decap_3
XFILLER_53_60 VGND VGND VPWR VPWR sky130_fd_sc_hd__decap_3
XFILLER_53_93 VGND VGND VPWR VPWR sky130_fd_sc_hd__decap_3
XFILLER_41_293 VGND VGND VPWR VPWR sky130_fd_sc_hd__decap_3
X_278_ clknet_2_1__leaf_clk_regs net13 _023_ VGND VGND VPWR VPWR genblk1\[6\].fa_inst.a
+ sky130_fd_sc_hd__dfrtp_1
XFILLER_5_172 VGND VGND VPWR VPWR sky130_fd_sc_hd__decap_3
XFILLER_5_161 VGND VGND VPWR VPWR sky130_fd_sc_hd__decap_3
XFILLER_49_393 VGND VGND VPWR VPWR sky130_fd_sc_hd__decap_3
XFILLER_49_382 VGND VGND VPWR VPWR sky130_fd_sc_hd__decap_3
XFILLER_64_352 VGND VGND VPWR VPWR sky130_fd_sc_hd__decap_3
XFILLER_24_227 VGND VGND VPWR VPWR sky130_fd_sc_hd__decap_3
XFILLER_64_374 VGND VGND VPWR VPWR sky130_fd_sc_hd__decap_3
XFILLER_64_396 VGND VGND VPWR VPWR sky130_fd_sc_hd__decap_3
XTAP_TAPCELL_ROW_62_531 VGND VPWR sky130_fd_sc_hd__tapvpwrvgnd_1
XFILLER_32_271 VGND VGND VPWR VPWR sky130_fd_sc_hd__decap_3
XFILLER_59_102 VGND VGND VPWR VPWR sky130_fd_sc_hd__decap_3
XFILLER_58_38 VGND VGND VPWR VPWR sky130_fd_sc_hd__decap_3
XFILLER_58_27 VGND VGND VPWR VPWR sky130_fd_sc_hd__fill_1
XFILLER_59_135 VGND VGND VPWR VPWR sky130_fd_sc_hd__decap_3
XFILLER_47_308 VGND VGND VPWR VPWR sky130_fd_sc_hd__decap_3
XFILLER_55_352 VGND VGND VPWR VPWR sky130_fd_sc_hd__decap_3
XFILLER_55_385 VGND VGND VPWR VPWR sky130_fd_sc_hd__decap_3
XFILLER_55_396 VGND VGND VPWR VPWR sky130_fd_sc_hd__decap_3
XFILLER_11_400 VGND VGND VPWR VPWR sky130_fd_sc_hd__decap_3
X_201_ _105_ _108_ _106_ VGND VGND VPWR VPWR _110_ sky130_fd_sc_hd__a21boi_2
XFILLER_23_293 VGND VGND VPWR VPWR sky130_fd_sc_hd__decap_3
XFILLER_23_63 VGND VGND VPWR VPWR sky130_fd_sc_hd__decap_3
X_132_ genblk1\[1\].fa_inst.b genblk1\[1\].fa_inst.a VGND VGND VPWR VPWR _055_ sky130_fd_sc_hd__nand2_1
XFILLER_23_96 VGND VGND VPWR VPWR sky130_fd_sc_hd__decap_3
XFILLER_2_153 VGND VGND VPWR VPWR sky130_fd_sc_hd__decap_3
XFILLER_24_9 VGND VGND VPWR VPWR sky130_fd_sc_hd__decap_3
XFILLER_0_12 VGND VGND VPWR VPWR sky130_fd_sc_hd__decap_3
XFILLER_46_330 VGND VGND VPWR VPWR sky130_fd_sc_hd__decap_3
XFILLER_0_78 VGND VGND VPWR VPWR sky130_fd_sc_hd__decap_3
XFILLER_61_311 VGND VGND VPWR VPWR sky130_fd_sc_hd__decap_3
XFILLER_46_374 VGND VGND VPWR VPWR sky130_fd_sc_hd__decap_3
XFILLER_46_363 VGND VGND VPWR VPWR sky130_fd_sc_hd__fill_1
XFILLER_64_81 VGND VGND VPWR VPWR sky130_fd_sc_hd__decap_3
XFILLER_61_355 VGND VGND VPWR VPWR sky130_fd_sc_hd__decap_3
XFILLER_9_43 VGND VGND VPWR VPWR sky130_fd_sc_hd__decap_3
XFILLER_61_399 VGND VGND VPWR VPWR sky130_fd_sc_hd__decap_3
XFILLER_61_388 VGND VGND VPWR VPWR sky130_fd_sc_hd__decap_3
XFILLER_9_87 VGND VGND VPWR VPWR sky130_fd_sc_hd__decap_3
XFILLER_29_308 VGND VGND VPWR VPWR sky130_fd_sc_hd__decap_3
XPHY_EDGE_ROW_14_1_Left_120 VGND VGND VPWR VPWR sky130_fd_sc_hd__decap_3
XFILLER_56_127 VGND VGND VPWR VPWR sky130_fd_sc_hd__decap_3
XFILLER_49_190 VGND VGND VPWR VPWR sky130_fd_sc_hd__decap_3
XTAP_TAPCELL_ROW_39_369 VGND VPWR sky130_fd_sc_hd__tapvpwrvgnd_1
XFILLER_37_385 VGND VGND VPWR VPWR sky130_fd_sc_hd__decap_3
XFILLER_37_352 VGND VGND VPWR VPWR sky130_fd_sc_hd__decap_3
XFILLER_64_193 VGND VGND VPWR VPWR sky130_fd_sc_hd__decap_3
XFILLER_52_333 VGND VGND VPWR VPWR sky130_fd_sc_hd__decap_3
XFILLER_44_29 VGND VGND VPWR VPWR sky130_fd_sc_hd__decap_3
XFILLER_44_18 VGND VGND VPWR VPWR sky130_fd_sc_hd__decap_3
XFILLER_37_396 VGND VGND VPWR VPWR sky130_fd_sc_hd__decap_3
XFILLER_52_377 VGND VGND VPWR VPWR sky130_fd_sc_hd__decap_3
XTAP_TAPCELL_ROW_22_247 VGND VPWR sky130_fd_sc_hd__tapvpwrvgnd_1
XFILLER_47_116 VGND VGND VPWR VPWR sky130_fd_sc_hd__decap_3
XFILLER_47_105 VGND VGND VPWR VPWR sky130_fd_sc_hd__decap_3
XFILLER_18_41 VGND VGND VPWR VPWR sky130_fd_sc_hd__decap_3
XFILLER_47_149 VGND VGND VPWR VPWR sky130_fd_sc_hd__decap_3
XFILLER_28_330 VGND VGND VPWR VPWR sky130_fd_sc_hd__decap_3
XFILLER_18_74 VGND VGND VPWR VPWR sky130_fd_sc_hd__decap_3
XFILLER_18_85 VGND VGND VPWR VPWR sky130_fd_sc_hd__decap_3
XFILLER_28_374 VGND VGND VPWR VPWR sky130_fd_sc_hd__decap_3
XFILLER_28_363 VGND VGND VPWR VPWR sky130_fd_sc_hd__fill_1
XFILLER_55_193 VGND VGND VPWR VPWR sky130_fd_sc_hd__decap_3
XFILLER_43_311 VGND VGND VPWR VPWR sky130_fd_sc_hd__decap_3
XFILLER_43_355 VGND VGND VPWR VPWR sky130_fd_sc_hd__decap_3
XFILLER_43_399 VGND VGND VPWR VPWR sky130_fd_sc_hd__decap_3
XFILLER_43_388 VGND VGND VPWR VPWR sky130_fd_sc_hd__decap_3
XFILLER_34_62 VGND VGND VPWR VPWR sky130_fd_sc_hd__decap_3
XFILLER_50_50 VGND VGND VPWR VPWR sky130_fd_sc_hd__decap_3
XFILLER_50_94 VGND VGND VPWR VPWR sky130_fd_sc_hd__decap_3
XFILLER_50_83 VGND VGND VPWR VPWR sky130_fd_sc_hd__fill_1
XFILLER_22_6 VGND VGND VPWR VPWR sky130_fd_sc_hd__decap_3
XFILLER_59_81 VGND VGND VPWR VPWR sky130_fd_sc_hd__decap_3
XFILLER_38_127 VGND VGND VPWR VPWR sky130_fd_sc_hd__decap_3
XFILLER_19_352 VGND VGND VPWR VPWR sky130_fd_sc_hd__decap_3
XFILLER_53_119 VGND VGND VPWR VPWR sky130_fd_sc_hd__decap_3
XFILLER_53_108 VGND VGND VPWR VPWR sky130_fd_sc_hd__decap_3
XFILLER_19_385 VGND VGND VPWR VPWR sky130_fd_sc_hd__decap_3
XFILLER_46_171 VGND VGND VPWR VPWR sky130_fd_sc_hd__decap_3
XFILLER_34_333 VGND VGND VPWR VPWR sky130_fd_sc_hd__decap_3
XFILLER_61_152 VGND VGND VPWR VPWR sky130_fd_sc_hd__decap_3
XFILLER_34_377 VGND VGND VPWR VPWR sky130_fd_sc_hd__decap_3
XFILLER_61_196 VGND VGND VPWR VPWR sky130_fd_sc_hd__decap_3
XFILLER_29_116 VGND VGND VPWR VPWR sky130_fd_sc_hd__decap_3
XFILLER_29_149 VGND VGND VPWR VPWR sky130_fd_sc_hd__decap_3
XFILLER_25_311 VGND VGND VPWR VPWR sky130_fd_sc_hd__decap_3
XFILLER_37_193 VGND VGND VPWR VPWR sky130_fd_sc_hd__decap_3
XFILLER_25_355 VGND VGND VPWR VPWR sky130_fd_sc_hd__decap_3
XFILLER_52_141 VGND VGND VPWR VPWR sky130_fd_sc_hd__decap_3
XFILLER_25_388 VGND VGND VPWR VPWR sky130_fd_sc_hd__decap_3
XFILLER_25_399 VGND VGND VPWR VPWR sky130_fd_sc_hd__decap_3
XFILLER_52_174 VGND VGND VPWR VPWR sky130_fd_sc_hd__decap_3
XFILLER_40_336 VGND VGND VPWR VPWR sky130_fd_sc_hd__decap_3
XPHY_EDGE_ROW_33_Left_139 VGND VGND VPWR VPWR sky130_fd_sc_hd__decap_3
XFILLER_20_53 VGND VGND VPWR VPWR sky130_fd_sc_hd__decap_3
XPHY_EDGE_ROW_49_Right_70 VGND VGND VPWR VPWR sky130_fd_sc_hd__decap_3
XPHY_EDGE_ROW_42_Left_148 VGND VGND VPWR VPWR sky130_fd_sc_hd__decap_3
XFILLER_29_84 VGND VGND VPWR VPWR sky130_fd_sc_hd__decap_3
XFILLER_35_119 VGND VGND VPWR VPWR sky130_fd_sc_hd__decap_3
XFILLER_28_171 VGND VGND VPWR VPWR sky130_fd_sc_hd__decap_3
XFILLER_16_366 VGND VGND VPWR VPWR sky130_fd_sc_hd__decap_3
XFILLER_45_50 VGND VGND VPWR VPWR sky130_fd_sc_hd__decap_3
XFILLER_43_152 VGND VGND VPWR VPWR sky130_fd_sc_hd__decap_3
XFILLER_16_399 VGND VGND VPWR VPWR sky130_fd_sc_hd__decap_3
XFILLER_45_94 VGND VGND VPWR VPWR sky130_fd_sc_hd__decap_3
XFILLER_31_314 VGND VGND VPWR VPWR sky130_fd_sc_hd__decap_3
XPHY_EDGE_ROW_51_Left_157 VGND VGND VPWR VPWR sky130_fd_sc_hd__decap_3
XFILLER_43_196 VGND VGND VPWR VPWR sky130_fd_sc_hd__decap_3
XFILLER_31_358 VGND VGND VPWR VPWR sky130_fd_sc_hd__decap_3
XFILLER_61_60 VGND VGND VPWR VPWR sky130_fd_sc_hd__decap_3
XFILLER_61_93 VGND VGND VPWR VPWR sky130_fd_sc_hd__decap_3
XFILLER_6_44 VGND VGND VPWR VPWR sky130_fd_sc_hd__decap_3
XFILLER_6_88 VGND VGND VPWR VPWR sky130_fd_sc_hd__decap_3
Xpmu_inst_69 VGND VGND VPWR VPWR pmu_inst_69/HI net69 sky130_fd_sc_hd__conb_1
XPHY_EDGE_ROW_60_Left_166 VGND VGND VPWR VPWR sky130_fd_sc_hd__decap_3
XPHY_EDGE_ROW_2_1_Left_108 VGND VGND VPWR VPWR sky130_fd_sc_hd__decap_3
XFILLER_34_141 VGND VGND VPWR VPWR sky130_fd_sc_hd__decap_3
XFILLER_34_130 VGND VGND VPWR VPWR sky130_fd_sc_hd__decap_3
XPHY_EDGE_ROW_4_2_Left_25 VGND VGND VPWR VPWR sky130_fd_sc_hd__decap_3
XFILLER_34_174 VGND VGND VPWR VPWR sky130_fd_sc_hd__decap_3
XFILLER_22_336 VGND VGND VPWR VPWR sky130_fd_sc_hd__decap_3
XTAP_TAPCELL_ROW_32_320 VGND VPWR sky130_fd_sc_hd__tapvpwrvgnd_1
XFILLER_30_380 VGND VGND VPWR VPWR sky130_fd_sc_hd__decap_3
XFILLER_57_211 VGND VGND VPWR VPWR sky130_fd_sc_hd__decap_3
XFILLER_57_255 VGND VGND VPWR VPWR sky130_fd_sc_hd__decap_3
XFILLER_17_119 VGND VGND VPWR VPWR sky130_fd_sc_hd__decap_3
XFILLER_25_152 VGND VGND VPWR VPWR sky130_fd_sc_hd__decap_3
XTAP_TAPCELL_ROW_55_478 VGND VPWR sky130_fd_sc_hd__tapvpwrvgnd_1
XFILLER_13_358 VGND VGND VPWR VPWR sky130_fd_sc_hd__decap_3
XFILLER_15_75 VGND VGND VPWR VPWR sky130_fd_sc_hd__decap_3
XFILLER_25_196 VGND VGND VPWR VPWR sky130_fd_sc_hd__decap_3
XFILLER_40_144 VGND VGND VPWR VPWR sky130_fd_sc_hd__decap_3
XFILLER_40_133 VGND VGND VPWR VPWR sky130_fd_sc_hd__decap_3
XFILLER_40_177 VGND VGND VPWR VPWR sky130_fd_sc_hd__decap_3
XFILLER_21_380 VGND VGND VPWR VPWR sky130_fd_sc_hd__decap_3
XTAP_TAPCELL_ROW_5_1_185 VGND VPWR sky130_fd_sc_hd__tapvpwrvgnd_1
XFILLER_31_41 VGND VGND VPWR VPWR sky130_fd_sc_hd__decap_3
XFILLER_31_63 VGND VGND VPWR VPWR sky130_fd_sc_hd__decap_3
XFILLER_31_96 VGND VGND VPWR VPWR sky130_fd_sc_hd__decap_3
Xoutput41 net41 VGND VGND VPWR VPWR s[11] sky130_fd_sc_hd__buf_2
Xoutput52 net52 VGND VGND VPWR VPWR s[7] sky130_fd_sc_hd__buf_2
XFILLER_48_200 VGND VGND VPWR VPWR sky130_fd_sc_hd__decap_3
XFILLER_48_233 VGND VGND VPWR VPWR sky130_fd_sc_hd__decap_3
XFILLER_48_277 VGND VGND VPWR VPWR sky130_fd_sc_hd__decap_3
XFILLER_63_214 VGND VGND VPWR VPWR sky130_fd_sc_hd__decap_3
XFILLER_63_225 VGND VGND VPWR VPWR sky130_fd_sc_hd__decap_3
XFILLER_56_82 VGND VGND VPWR VPWR sky130_fd_sc_hd__fill_2
XFILLER_56_71 VGND VGND VPWR VPWR sky130_fd_sc_hd__decap_3
XFILLER_16_141 VGND VGND VPWR VPWR sky130_fd_sc_hd__decap_3
XFILLER_63_258 VGND VGND VPWR VPWR sky130_fd_sc_hd__decap_3
XFILLER_16_174 VGND VGND VPWR VPWR sky130_fd_sc_hd__decap_3
XFILLER_31_122 VGND VGND VPWR VPWR sky130_fd_sc_hd__decap_3
XFILLER_31_111 VGND VGND VPWR VPWR sky130_fd_sc_hd__fill_1
XFILLER_31_155 VGND VGND VPWR VPWR sky130_fd_sc_hd__decap_3
XFILLER_31_199 VGND VGND VPWR VPWR sky130_fd_sc_hd__decap_3
XFILLER_8_340 VGND VGND VPWR VPWR sky130_fd_sc_hd__decap_3
XFILLER_8_384 VGND VGND VPWR VPWR sky130_fd_sc_hd__decap_3
XPHY_EDGE_ROW_0_2_Right_86 VGND VGND VPWR VPWR sky130_fd_sc_hd__decap_3
.ends
