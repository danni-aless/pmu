** sch_path: /foss/designs/pmu/1-schematics/delay_chain.sch
.subckt delay_chain out in delay_sel[2] delay_sel[1] delay_sel[0]
*.PININFO in:I delay_sel[2:0]:I out:O
x1 in net1 buf20_2
x2 net1 net2 buf20_2
x3 net2 net3 buf20_2
x4 net3 net4 buf20_2
x5 net4 net5 buf20_2
x6 net5 net6 buf20_2
x8 in net1 net2 net3 delay_sel[0] delay_sel[1] VGND VNB VPB VPWR net8 sky130_fd_sc_hd__mux4_1
x9 net4 net5 net6 net7 delay_sel[0] delay_sel[1] VGND VNB VPB VPWR net9 sky130_fd_sc_hd__mux4_1
x10 net8 net9 delay_sel[2] VGND VNB VPB VPWR out sky130_fd_sc_hd__mux2_1
x7 net6 net7 buf20_1
* tap: delay_sel[2:0] --> delay_sel[1]
* tap: delay_sel[2:0] --> delay_sel[0]
* tap: delay_sel[2:0] --> delay_sel[2]
.ends

* expanding   symbol:  buf20_2.sym # of pins=2
** sym_path: /foss/designs/pmu/1-schematics/buf20_2.sym
** sch_path: /foss/designs/pmu/1-schematics/buf20_2.sch
.subckt buf20_2 in out
*.PININFO in:I out:O
x1 in VGND VNB VPB VPWR net2 sky130_fd_sc_hd__buf_1
x2 net2 VGND VNB VPB VPWR net3 sky130_fd_sc_hd__buf_1
x3 net3 VGND VNB VPB VPWR net4 sky130_fd_sc_hd__buf_1
x4 net4 VGND VNB VPB VPWR net5 sky130_fd_sc_hd__buf_1
x5 net5 VGND VNB VPB VPWR net6 sky130_fd_sc_hd__buf_1
x6 net6 VGND VNB VPB VPWR net7 sky130_fd_sc_hd__buf_1
x7 net7 VGND VNB VPB VPWR net8 sky130_fd_sc_hd__buf_1
x8 net8 VGND VNB VPB VPWR net9 sky130_fd_sc_hd__buf_1
x9 net9 VGND VNB VPB VPWR net10 sky130_fd_sc_hd__buf_1
x10 net10 VGND VNB VPB VPWR net1 sky130_fd_sc_hd__buf_1
x11 net1 VGND VNB VPB VPWR net11 sky130_fd_sc_hd__buf_1
x12 net11 VGND VNB VPB VPWR net12 sky130_fd_sc_hd__buf_1
x13 net12 VGND VNB VPB VPWR net13 sky130_fd_sc_hd__buf_1
x14 net13 VGND VNB VPB VPWR net14 sky130_fd_sc_hd__buf_1
x15 net14 VGND VNB VPB VPWR net15 sky130_fd_sc_hd__buf_1
x16 net15 VGND VNB VPB VPWR net16 sky130_fd_sc_hd__buf_1
x17 net16 VGND VNB VPB VPWR net17 sky130_fd_sc_hd__buf_1
x18 net17 VGND VNB VPB VPWR net18 sky130_fd_sc_hd__buf_1
x19 net18 VGND VNB VPB VPWR net19 sky130_fd_sc_hd__buf_1
x20 net19 VGND VNB VPB VPWR out sky130_fd_sc_hd__buf_2
.ends

* expanding   symbol:  buf20_1.sym # of pins=2
** sym_path: /foss/designs/pmu/1-schematics/buf20_1.sym
** sch_path: /foss/designs/pmu/1-schematics/buf20_1.sch
.subckt buf20_1 in out
*.PININFO in:I out:O
x1 in VGND VNB VPB VPWR net2 sky130_fd_sc_hd__buf_1
x2 net2 VGND VNB VPB VPWR net3 sky130_fd_sc_hd__buf_1
x3 net3 VGND VNB VPB VPWR net4 sky130_fd_sc_hd__buf_1
x4 net4 VGND VNB VPB VPWR net5 sky130_fd_sc_hd__buf_1
x5 net5 VGND VNB VPB VPWR net6 sky130_fd_sc_hd__buf_1
x6 net6 VGND VNB VPB VPWR net7 sky130_fd_sc_hd__buf_1
x7 net7 VGND VNB VPB VPWR net8 sky130_fd_sc_hd__buf_1
x8 net8 VGND VNB VPB VPWR net9 sky130_fd_sc_hd__buf_1
x9 net9 VGND VNB VPB VPWR net10 sky130_fd_sc_hd__buf_1
x10 net10 VGND VNB VPB VPWR net1 sky130_fd_sc_hd__buf_1
x11 net1 VGND VNB VPB VPWR net11 sky130_fd_sc_hd__buf_1
x12 net11 VGND VNB VPB VPWR net12 sky130_fd_sc_hd__buf_1
x13 net12 VGND VNB VPB VPWR net13 sky130_fd_sc_hd__buf_1
x14 net13 VGND VNB VPB VPWR net14 sky130_fd_sc_hd__buf_1
x15 net14 VGND VNB VPB VPWR net15 sky130_fd_sc_hd__buf_1
x16 net15 VGND VNB VPB VPWR net16 sky130_fd_sc_hd__buf_1
x17 net16 VGND VNB VPB VPWR net17 sky130_fd_sc_hd__buf_1
x18 net17 VGND VNB VPB VPWR net18 sky130_fd_sc_hd__buf_1
x19 net18 VGND VNB VPB VPWR net19 sky130_fd_sc_hd__buf_1
x20 net19 VGND VNB VPB VPWR out sky130_fd_sc_hd__buf_1
.ends
