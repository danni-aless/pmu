* NGSPICE file created from pmu.ext - technology: sky130A

.subckt sky130_fd_sc_hd__decap_3 VPWR VGND VPB VNB
X0 VPWR VGND VPWR VPB sky130_fd_pr__pfet_01v8_hvt ad=0.2262 pd=2.26 as=0.4524 ps=4.52 w=0.87 l=0.59
X1 VGND VPWR VGND VNB sky130_fd_pr__nfet_01v8 ad=0.143 pd=1.62 as=0.286 ps=3.24 w=0.55 l=0.59
C0 VGND VPWR 0.353f
C1 VGND VPB 0.07966f
C2 VPB VPWR 0.0625f
C3 VPWR VNB 0.46997f
C4 VGND VNB 0.42732f
C5 VPB VNB 0.33898f
.ends

.subckt sky130_fd_sc_hd__buf_1 VGND VPWR X A VPB VNB a_27_47#
X0 VPWR A a_27_47# VPB sky130_fd_pr__pfet_01v8_hvt ad=0.11455 pd=1.08 as=0.2054 ps=2.1 w=0.79 l=0.15
X1 X a_27_47# VGND VNB sky130_fd_pr__nfet_01v8 ad=0.1352 pd=1.56 as=0.0754 ps=0.81 w=0.52 l=0.15
X2 X a_27_47# VPWR VPB sky130_fd_pr__pfet_01v8_hvt ad=0.2054 pd=2.1 as=0.11455 ps=1.08 w=0.79 l=0.15
X3 VGND A a_27_47# VNB sky130_fd_pr__nfet_01v8 ad=0.0754 pd=0.81 as=0.1352 ps=1.56 w=0.52 l=0.15
C0 VPB VGND 0.00505f
C1 VGND X 0.05463f
C2 VGND VPWR 0.02897f
C3 a_27_47# VGND 0.10476f
C4 VGND A 0.01842f
C5 VPB X 0.01276f
C6 VPB VPWR 0.03549f
C7 VPWR X 0.08968f
C8 VPB a_27_47# 0.05917f
C9 a_27_47# X 0.10745f
C10 a_27_47# VPWR 0.1351f
C11 VPB A 0.05239f
C12 X A 0
C13 VPWR A 0.02154f
C14 a_27_47# A 0.18145f
C15 VGND VNB 0.20732f
C16 X VNB 0.09411f
C17 VPWR VNB 0.1754f
C18 A VNB 0.16405f
C19 VPB VNB 0.33898f
C20 a_27_47# VNB 0.20778f
.ends

.subckt sky130_fd_sc_hd__clkbuf_4 VGND VPWR A X VPB VNB a_27_47#
X0 VPWR A a_27_47# VPB sky130_fd_pr__pfet_01v8_hvt ad=0.165 pd=1.33 as=0.265 ps=2.53 w=1 l=0.15
X1 VGND a_27_47# X VNB sky130_fd_pr__nfet_01v8 ad=0.1218 pd=1.42 as=0.0588 ps=0.7 w=0.42 l=0.15
X2 VGND a_27_47# X VNB sky130_fd_pr__nfet_01v8 ad=0.0588 pd=0.7 as=0.0588 ps=0.7 w=0.42 l=0.15
X3 X a_27_47# VPWR VPB sky130_fd_pr__pfet_01v8_hvt ad=0.14 pd=1.28 as=0.14 ps=1.28 w=1 l=0.15
X4 X a_27_47# VGND VNB sky130_fd_pr__nfet_01v8 ad=0.0588 pd=0.7 as=0.0588 ps=0.7 w=0.42 l=0.15
X5 VGND A a_27_47# VNB sky130_fd_pr__nfet_01v8 ad=0.07035 pd=0.755 as=0.1113 ps=1.37 w=0.42 l=0.15
X6 VPWR a_27_47# X VPB sky130_fd_pr__pfet_01v8_hvt ad=0.3 pd=2.6 as=0.14 ps=1.28 w=1 l=0.15
X7 X a_27_47# VGND VNB sky130_fd_pr__nfet_01v8 ad=0.0588 pd=0.7 as=0.07035 ps=0.755 w=0.42 l=0.15
X8 X a_27_47# VPWR VPB sky130_fd_pr__pfet_01v8_hvt ad=0.14 pd=1.28 as=0.165 ps=1.33 w=1 l=0.15
X9 VPWR a_27_47# X VPB sky130_fd_pr__pfet_01v8_hvt ad=0.14 pd=1.28 as=0.14 ps=1.28 w=1 l=0.15
C0 VPB VGND 0.00583f
C1 VGND X 0.21559f
C2 VGND VPWR 0.05704f
C3 a_27_47# VGND 0.14848f
C4 VGND A 0.04309f
C5 VPB X 0.01216f
C6 VPB VPWR 0.06317f
C7 VPWR X 0.31697f
C8 VPB a_27_47# 0.13876f
C9 a_27_47# X 0.3277f
C10 a_27_47# VPWR 0.21924f
C11 VPB A 0.03214f
C12 X A 0.01395f
C13 VPWR A 0.02195f
C14 a_27_47# A 0.19501f
C15 VGND VNB 0.35771f
C16 X VNB 0.06701f
C17 VPWR VNB 0.30765f
C18 A VNB 0.14764f
C19 VPB VNB 0.60476f
C20 a_27_47# VNB 0.54298f
.ends

.subckt sky130_fd_sc_hd__dfrtp_2 VGND VPWR VPB VNB CLK D RESET_B Q a_1462_47# a_543_47#
+ a_651_413# a_193_47# a_805_47# a_448_47# a_639_47# a_1283_21# a_761_289# a_1108_47#
+ a_1217_47# a_1270_413# a_27_47#
X0 a_805_47# a_761_289# a_639_47# VNB sky130_fd_pr__nfet_01v8 ad=0.0441 pd=0.63 as=0.1401 ps=1.1 w=0.42 l=0.15
X1 a_1217_47# a_27_47# a_1108_47# VNB sky130_fd_pr__special_nfet_01v8 ad=0.0669 pd=0.75 as=0.0711 ps=0.755 w=0.36 l=0.15
X2 VGND a_1283_21# Q VNB sky130_fd_pr__nfet_01v8 ad=0.169 pd=1.82 as=0.08775 ps=0.92 w=0.65 l=0.15
X3 a_1283_21# a_1108_47# a_1462_47# VNB sky130_fd_pr__nfet_01v8 ad=0.1092 pd=1.36 as=0.06405 ps=0.725 w=0.42 l=0.15
X4 a_651_413# a_27_47# a_543_47# VPB sky130_fd_pr__pfet_01v8_hvt ad=0.1155 pd=0.97 as=0.07245 ps=0.765 w=0.42 l=0.15
X5 VPWR a_1283_21# Q VPB sky130_fd_pr__pfet_01v8_hvt ad=0.26 pd=2.52 as=0.135 ps=1.27 w=1 l=0.15
X6 a_1108_47# a_193_47# a_761_289# VNB sky130_fd_pr__special_nfet_01v8 ad=0.0711 pd=0.755 as=0.0999 ps=0.985 w=0.36 l=0.15
X7 VGND RESET_B a_805_47# VNB sky130_fd_pr__nfet_01v8 ad=0.1346 pd=1.15 as=0.0441 ps=0.63 w=0.42 l=0.15
X8 Q a_1283_21# VPWR VPB sky130_fd_pr__pfet_01v8_hvt ad=0.135 pd=1.27 as=0.3012 ps=2.66 w=1 l=0.15
X9 VPWR CLK a_27_47# VPB sky130_fd_pr__pfet_01v8_hvt ad=0.0864 pd=0.91 as=0.1664 ps=1.8 w=0.64 l=0.15
X10 a_448_47# D VPWR VPB sky130_fd_pr__pfet_01v8_hvt ad=0.0651 pd=0.73 as=0.1092 ps=1.36 w=0.42 l=0.15
X11 a_761_289# a_543_47# VGND VNB sky130_fd_pr__nfet_01v8 ad=0.0999 pd=0.985 as=0.1346 ps=1.15 w=0.64 l=0.15
X12 a_193_47# a_27_47# VGND VNB sky130_fd_pr__nfet_01v8 ad=0.1092 pd=1.36 as=0.0567 ps=0.69 w=0.42 l=0.15
X13 a_1108_47# a_27_47# a_761_289# VPB sky130_fd_pr__pfet_01v8_hvt ad=0.0588 pd=0.7 as=0.12915 ps=1.185 w=0.42 l=0.15
X14 a_1462_47# RESET_B VGND VNB sky130_fd_pr__nfet_01v8 ad=0.06405 pd=0.725 as=0.12495 ps=1.015 w=0.42 l=0.15
X15 a_543_47# a_27_47# a_448_47# VNB sky130_fd_pr__special_nfet_01v8 ad=0.0594 pd=0.69 as=0.066 ps=0.745 w=0.36 l=0.15
X16 a_543_47# a_193_47# a_448_47# VPB sky130_fd_pr__pfet_01v8_hvt ad=0.07245 pd=0.765 as=0.0651 ps=0.73 w=0.42 l=0.15
X17 a_448_47# D VGND VNB sky130_fd_pr__nfet_01v8 ad=0.066 pd=0.745 as=0.2205 ps=1.89 w=0.42 l=0.15
X18 VPWR a_1283_21# a_1270_413# VPB sky130_fd_pr__pfet_01v8_hvt ad=0.0819 pd=0.81 as=0.0567 ps=0.69 w=0.42 l=0.15
X19 VPWR a_1108_47# a_1283_21# VPB sky130_fd_pr__pfet_01v8_hvt ad=0.1134 pd=1.38 as=0.0567 ps=0.69 w=0.42 l=0.15
X20 a_1270_413# a_193_47# a_1108_47# VPB sky130_fd_pr__pfet_01v8_hvt ad=0.0567 pd=0.69 as=0.0588 ps=0.7 w=0.42 l=0.15
X21 a_193_47# a_27_47# VPWR VPB sky130_fd_pr__pfet_01v8_hvt ad=0.1664 pd=1.8 as=0.0864 ps=0.91 w=0.64 l=0.15
X22 a_1283_21# RESET_B VPWR VPB sky130_fd_pr__pfet_01v8_hvt ad=0.0567 pd=0.69 as=0.0819 ps=0.81 w=0.42 l=0.15
X23 VPWR a_761_289# a_651_413# VPB sky130_fd_pr__pfet_01v8_hvt ad=0.07035 pd=0.755 as=0.1155 ps=0.97 w=0.42 l=0.15
X24 Q a_1283_21# VGND VNB sky130_fd_pr__nfet_01v8 ad=0.08775 pd=0.92 as=0.2087 ps=2.02 w=0.65 l=0.15
X25 a_639_47# a_193_47# a_543_47# VNB sky130_fd_pr__special_nfet_01v8 ad=0.1401 pd=1.1 as=0.0594 ps=0.69 w=0.36 l=0.15
X26 VGND a_1283_21# a_1217_47# VNB sky130_fd_pr__nfet_01v8 ad=0.12495 pd=1.015 as=0.0669 ps=0.75 w=0.42 l=0.15
X27 a_651_413# RESET_B VPWR VPB sky130_fd_pr__pfet_01v8_hvt ad=0.1092 pd=1.36 as=0.07035 ps=0.755 w=0.42 l=0.15
X28 VGND CLK a_27_47# VNB sky130_fd_pr__nfet_01v8 ad=0.0567 pd=0.69 as=0.1092 ps=1.36 w=0.42 l=0.15
X29 a_761_289# a_543_47# VPWR VPB sky130_fd_pr__pfet_01v8_hvt ad=0.12915 pd=1.185 as=0.2184 ps=2.2 w=0.84 l=0.15
C0 a_1283_21# VPWR 0.22975f
C1 VPWR a_651_413# 0.12856f
C2 a_805_47# a_761_289# 0
C3 VPB a_27_47# 0.26188f
C4 RESET_B Q 0
C5 VPB a_543_47# 0.09579f
C6 CLK a_27_47# 0.2336f
C7 a_27_47# VPWR 0.1523f
C8 VPWR a_543_47# 0.10029f
C9 VGND Q 0.10966f
C10 a_761_289# RESET_B 0.16611f
C11 a_1217_47# a_761_289# 0
C12 RESET_B a_1108_47# 0.2366f
C13 a_1217_47# a_1108_47# 0.00742f
C14 RESET_B a_1283_21# 0.27892f
C15 D a_27_47# 0.13285f
C16 a_761_289# VGND 0.07338f
C17 RESET_B a_651_413# 0.0122f
C18 D a_543_47# 0
C19 a_1108_47# VGND 0.14813f
C20 a_805_47# a_543_47# 0.00171f
C21 a_27_47# a_448_47# 0.09313f
C22 a_1283_21# VGND 0.25943f
C23 a_448_47# a_543_47# 0.04983f
C24 a_193_47# a_1270_413# 0
C25 RESET_B a_27_47# 0.29634f
C26 a_1217_47# a_27_47# 0
C27 a_1108_47# Q 0
C28 RESET_B a_543_47# 0.15327f
C29 a_1283_21# Q 0.0963f
C30 a_27_47# VGND 0.25397f
C31 VGND a_543_47# 0.12293f
C32 VPB a_193_47# 0.17091f
C33 a_448_47# a_639_47# 0
C34 CLK a_193_47# 0
C35 a_761_289# a_1108_47# 0.05116f
C36 a_193_47# VPWR 0.39596f
C37 a_1283_21# a_1108_47# 0.23366f
C38 a_761_289# a_651_413# 0.09774f
C39 a_27_47# Q 0
C40 RESET_B a_639_47# 0
C41 VGND a_639_47# 0.00863f
C42 D a_193_47# 0.21795f
C43 a_761_289# a_27_47# 0.07009f
C44 a_27_47# a_1108_47# 0.10236f
C45 a_193_47# a_448_47# 0.06418f
C46 VPWR a_1270_413# 0
C47 a_27_47# a_1283_21# 0.04359f
C48 a_761_289# a_543_47# 0.20964f
C49 a_1108_47# a_543_47# 0
C50 a_27_47# a_651_413# 0
C51 a_543_47# a_651_413# 0.05722f
C52 RESET_B a_193_47# 0.0269f
C53 a_1217_47# a_193_47# 0
C54 a_1462_47# RESET_B 0.00288f
C55 VPB CLK 0.06934f
C56 a_193_47# VGND 0.06306f
C57 VPB VPWR 0.2337f
C58 a_761_289# a_639_47# 0
C59 CLK VPWR 0.01741f
C60 a_27_47# a_543_47# 0.11535f
C61 a_1462_47# VGND 0.00221f
C62 RESET_B a_1270_413# 0
C63 VPB D 0.13757f
C64 a_193_47# Q 0
C65 VPB a_448_47# 0.01414f
C66 D VPWR 0.08119f
C67 a_27_47# a_639_47# 0.00188f
C68 a_448_47# VPWR 0.06814f
C69 a_761_289# a_193_47# 0.18639f
C70 a_543_47# a_639_47# 0.01379f
C71 a_193_47# a_1108_47# 0.12532f
C72 VPB RESET_B 0.13848f
C73 a_193_47# a_1283_21# 0.04251f
C74 CLK RESET_B 0
C75 a_193_47# a_651_413# 0.03462f
C76 a_1462_47# a_1283_21# 0.0074f
C77 RESET_B VPWR 0.06519f
C78 VPB VGND 0.01215f
C79 D a_448_47# 0.15563f
C80 CLK VGND 0.01721f
C81 VPWR VGND 0.07191f
C82 a_761_289# a_1270_413# 0
C83 a_1108_47# a_1270_413# 0.00645f
C84 a_27_47# a_193_47# 0.90645f
C85 D RESET_B 0
C86 a_805_47# RESET_B 0.00316f
C87 a_193_47# a_543_47# 0.2298f
C88 VPB Q 0.00555f
C89 RESET_B a_448_47# 0
C90 D VGND 0.05161f
C91 a_805_47# VGND 0.00579f
C92 VPWR Q 0.16936f
C93 a_448_47# VGND 0.0661f
C94 a_761_289# VPB 0.09942f
C95 VPB a_1108_47# 0.11463f
C96 a_1217_47# RESET_B 0
C97 VPB a_1283_21# 0.16811f
C98 a_761_289# VPWR 0.10497f
C99 VPB a_651_413# 0.01354f
C100 a_193_47# a_639_47# 0
C101 RESET_B VGND 0.28803f
C102 a_1108_47# VPWR 0.17379f
C103 a_1217_47# VGND 0
C104 Q VNB 0.02956f
C105 VGND VNB 1.09584f
C106 VPWR VNB 0.90228f
C107 RESET_B VNB 0.26285f
C108 D VNB 0.15989f
C109 CLK VNB 0.19525f
C110 VPB VNB 1.9337f
C111 a_651_413# VNB 0.00469f
C112 a_448_47# VNB 0.0139f
C113 a_1108_47# VNB 0.13732f
C114 a_1283_21# VNB 0.38926f
C115 a_543_47# VNB 0.15787f
C116 a_761_289# VNB 0.12085f
C117 a_193_47# VNB 0.27321f
C118 a_27_47# VNB 0.49575f
.ends

.subckt sky130_fd_sc_hd__clkbuf_16 VNB VPB VGND VPWR A X a_110_47#
X0 VPWR A a_110_47# VPB sky130_fd_pr__pfet_01v8_hvt ad=0.14 pd=1.28 as=0.14 ps=1.28 w=1 l=0.15
X1 VPWR a_110_47# X VPB sky130_fd_pr__pfet_01v8_hvt ad=0.14 pd=1.28 as=0.14 ps=1.28 w=1 l=0.15
X2 X a_110_47# VPWR VPB sky130_fd_pr__pfet_01v8_hvt ad=0.14 pd=1.28 as=0.14 ps=1.28 w=1 l=0.15
X3 X a_110_47# VPWR VPB sky130_fd_pr__pfet_01v8_hvt ad=0.14 pd=1.28 as=0.14 ps=1.28 w=1 l=0.15
X4 VPWR a_110_47# X VPB sky130_fd_pr__pfet_01v8_hvt ad=0.14 pd=1.28 as=0.14 ps=1.28 w=1 l=0.15
X5 VPWR a_110_47# X VPB sky130_fd_pr__pfet_01v8_hvt ad=0.265 pd=2.53 as=0.14 ps=1.28 w=1 l=0.15
X6 a_110_47# A VPWR VPB sky130_fd_pr__pfet_01v8_hvt ad=0.14 pd=1.28 as=0.265 ps=2.53 w=1 l=0.15
X7 a_110_47# A VGND VNB sky130_fd_pr__nfet_01v8 ad=0.0588 pd=0.7 as=0.0588 ps=0.7 w=0.42 l=0.15
X8 VGND a_110_47# X VNB sky130_fd_pr__nfet_01v8 ad=0.0588 pd=0.7 as=0.0588 ps=0.7 w=0.42 l=0.15
X9 X a_110_47# VGND VNB sky130_fd_pr__nfet_01v8 ad=0.0588 pd=0.7 as=0.0588 ps=0.7 w=0.42 l=0.15
X10 VGND a_110_47# X VNB sky130_fd_pr__nfet_01v8 ad=0.0588 pd=0.7 as=0.0588 ps=0.7 w=0.42 l=0.15
X11 a_110_47# A VPWR VPB sky130_fd_pr__pfet_01v8_hvt ad=0.14 pd=1.28 as=0.14 ps=1.28 w=1 l=0.15
X12 VGND A a_110_47# VNB sky130_fd_pr__nfet_01v8 ad=0.0588 pd=0.7 as=0.0588 ps=0.7 w=0.42 l=0.15
X13 VGND a_110_47# X VNB sky130_fd_pr__nfet_01v8 ad=0.05775 pd=0.695 as=0.0588 ps=0.7 w=0.42 l=0.15
X14 VPWR a_110_47# X VPB sky130_fd_pr__pfet_01v8_hvt ad=0.14 pd=1.28 as=0.14 ps=1.28 w=1 l=0.15
X15 X a_110_47# VPWR VPB sky130_fd_pr__pfet_01v8_hvt ad=0.14 pd=1.28 as=0.14 ps=1.28 w=1 l=0.15
X16 VGND A a_110_47# VNB sky130_fd_pr__nfet_01v8 ad=0.0588 pd=0.7 as=0.0588 ps=0.7 w=0.42 l=0.15
X17 VGND a_110_47# X VNB sky130_fd_pr__nfet_01v8 ad=0.1113 pd=1.37 as=0.0588 ps=0.7 w=0.42 l=0.15
X18 VPWR a_110_47# X VPB sky130_fd_pr__pfet_01v8_hvt ad=0.1375 pd=1.275 as=0.14 ps=1.28 w=1 l=0.15
X19 VGND a_110_47# X VNB sky130_fd_pr__nfet_01v8 ad=0.0588 pd=0.7 as=0.0588 ps=0.7 w=0.42 l=0.15
X20 X a_110_47# VPWR VPB sky130_fd_pr__pfet_01v8_hvt ad=0.14 pd=1.28 as=0.1375 ps=1.275 w=1 l=0.15
X21 a_110_47# A VGND VNB sky130_fd_pr__nfet_01v8 ad=0.0588 pd=0.7 as=0.1113 ps=1.37 w=0.42 l=0.15
X22 VPWR A a_110_47# VPB sky130_fd_pr__pfet_01v8_hvt ad=0.14 pd=1.28 as=0.14 ps=1.28 w=1 l=0.15
X23 VPWR a_110_47# X VPB sky130_fd_pr__pfet_01v8_hvt ad=0.14 pd=1.28 as=0.14 ps=1.28 w=1 l=0.15
X24 VPWR a_110_47# X VPB sky130_fd_pr__pfet_01v8_hvt ad=0.14 pd=1.28 as=0.14 ps=1.28 w=1 l=0.15
X25 VGND a_110_47# X VNB sky130_fd_pr__nfet_01v8 ad=0.0588 pd=0.7 as=0.0588 ps=0.7 w=0.42 l=0.15
X26 X a_110_47# VPWR VPB sky130_fd_pr__pfet_01v8_hvt ad=0.14 pd=1.28 as=0.14 ps=1.28 w=1 l=0.15
X27 VGND a_110_47# X VNB sky130_fd_pr__nfet_01v8 ad=0.0588 pd=0.7 as=0.0588 ps=0.7 w=0.42 l=0.15
X28 VGND a_110_47# X VNB sky130_fd_pr__nfet_01v8 ad=0.0588 pd=0.7 as=0.0588 ps=0.7 w=0.42 l=0.15
X29 X a_110_47# VGND VNB sky130_fd_pr__nfet_01v8 ad=0.0588 pd=0.7 as=0.0588 ps=0.7 w=0.42 l=0.15
X30 X a_110_47# VPWR VPB sky130_fd_pr__pfet_01v8_hvt ad=0.14 pd=1.28 as=0.14 ps=1.28 w=1 l=0.15
X31 X a_110_47# VPWR VPB sky130_fd_pr__pfet_01v8_hvt ad=0.14 pd=1.28 as=0.14 ps=1.28 w=1 l=0.15
X32 X a_110_47# VGND VNB sky130_fd_pr__nfet_01v8 ad=0.0588 pd=0.7 as=0.0588 ps=0.7 w=0.42 l=0.15
X33 VPWR a_110_47# X VPB sky130_fd_pr__pfet_01v8_hvt ad=0.14 pd=1.28 as=0.14 ps=1.28 w=1 l=0.15
X34 X a_110_47# VPWR VPB sky130_fd_pr__pfet_01v8_hvt ad=0.14 pd=1.28 as=0.14 ps=1.28 w=1 l=0.15
X35 X a_110_47# VGND VNB sky130_fd_pr__nfet_01v8 ad=0.0588 pd=0.7 as=0.0588 ps=0.7 w=0.42 l=0.15
X36 X a_110_47# VGND VNB sky130_fd_pr__nfet_01v8 ad=0.0588 pd=0.7 as=0.0588 ps=0.7 w=0.42 l=0.15
X37 X a_110_47# VGND VNB sky130_fd_pr__nfet_01v8 ad=0.0588 pd=0.7 as=0.0588 ps=0.7 w=0.42 l=0.15
X38 X a_110_47# VGND VNB sky130_fd_pr__nfet_01v8 ad=0.0588 pd=0.7 as=0.0588 ps=0.7 w=0.42 l=0.15
X39 X a_110_47# VGND VNB sky130_fd_pr__nfet_01v8 ad=0.0588 pd=0.7 as=0.05775 ps=0.695 w=0.42 l=0.15
C0 A VGND 0.11535f
C1 X VGND 0.97688f
C2 a_110_47# VPWR 0.66998f
C3 a_110_47# VPB 0.52756f
C4 VPB VPWR 0.18386f
C5 a_110_47# A 0.30658f
C6 A VPWR 0.11164f
C7 a_110_47# X 1.62234f
C8 VPWR X 1.36494f
C9 VPB A 0.1334f
C10 a_110_47# VGND 0.51239f
C11 VPB X 0.03148f
C12 VPWR VGND 0.18736f
C13 VPB VGND 0.01139f
C14 A X 0.00292f
C15 VGND VNB 1.01442f
C16 X VNB 0.11058f
C17 VPWR VNB 0.83479f
C18 A VNB 0.49473f
C19 VPB VNB 1.84511f
C20 a_110_47# VNB 1.73295f
.ends

.subckt sky130_fd_sc_hd__buf_2 VPWR VGND X A VPB VNB a_27_47#
X0 VPWR a_27_47# X VPB sky130_fd_pr__pfet_01v8_hvt ad=0.265 pd=2.53 as=0.135 ps=1.27 w=1 l=0.15
X1 X a_27_47# VPWR VPB sky130_fd_pr__pfet_01v8_hvt ad=0.135 pd=1.27 as=0.149 ps=1.325 w=1 l=0.15
X2 VPWR A a_27_47# VPB sky130_fd_pr__pfet_01v8_hvt ad=0.149 pd=1.325 as=0.1664 ps=1.8 w=0.64 l=0.15
X3 X a_27_47# VGND VNB sky130_fd_pr__nfet_01v8 ad=0.08775 pd=0.92 as=0.097 ps=0.975 w=0.65 l=0.15
X4 VGND a_27_47# X VNB sky130_fd_pr__nfet_01v8 ad=0.17225 pd=1.83 as=0.08775 ps=0.92 w=0.65 l=0.15
X5 VGND A a_27_47# VNB sky130_fd_pr__nfet_01v8 ad=0.097 pd=0.975 as=0.1092 ps=1.36 w=0.42 l=0.15
C0 A VGND 0.01989f
C1 X VGND 0.11126f
C2 a_27_47# VPWR 0.1533f
C3 a_27_47# VPB 0.07497f
C4 VPB VPWR 0.05279f
C5 a_27_47# A 0.15787f
C6 A VPWR 0.02211f
C7 a_27_47# X 0.14879f
C8 VPWR X 0.16899f
C9 VPB A 0.06973f
C10 a_27_47# VGND 0.12719f
C11 VPB X 0.00443f
C12 VPWR VGND 0.05175f
C13 VPB VGND 0.00642f
C14 A X 0.00306f
C15 VGND VNB 0.28418f
C16 X VNB 0.0215f
C17 VPWR VNB 0.24963f
C18 A VNB 0.18747f
C19 VPB VNB 0.42757f
C20 a_27_47# VNB 0.28447f
.ends

.subckt sky130_fd_sc_hd__inv_2 A Y VPB VNB VPWR VGND
X0 Y A VPWR VPB sky130_fd_pr__pfet_01v8_hvt ad=0.135 pd=1.27 as=0.26 ps=2.52 w=1 l=0.15
X1 VGND A Y VNB sky130_fd_pr__nfet_01v8 ad=0.169 pd=1.82 as=0.08775 ps=0.92 w=0.65 l=0.15
X2 Y A VGND VNB sky130_fd_pr__nfet_01v8 ad=0.08775 pd=0.92 as=0.169 ps=1.82 w=0.65 l=0.15
X3 VPWR A Y VPB sky130_fd_pr__pfet_01v8_hvt ad=0.26 pd=2.52 as=0.135 ps=1.27 w=1 l=0.15
C0 VPB Y 0.0061f
C1 VPB A 0.07418f
C2 A Y 0.08939f
C3 VPB VPWR 0.05206f
C4 VPWR Y 0.2091f
C5 VPB VGND 0.00649f
C6 Y VGND 0.1546f
C7 A VPWR 0.06305f
C8 A VGND 0.06375f
C9 VPWR VGND 0.04227f
C10 VGND VNB 0.26619f
C11 Y VNB 0.03316f
C12 VPWR VNB 0.24604f
C13 A VNB 0.26281f
C14 VPB VNB 0.33898f
.ends

.subckt sky130_fd_sc_hd__mux4_1 VNB VPB VGND VPWR A1 A0 S0 A3 A2 S1 X a_1290_413#
+ a_757_363# a_1478_413# a_277_47# a_750_97# a_27_413# a_923_363# a_193_47# a_834_97#
+ a_247_21# a_668_97# a_193_413# a_27_47#
X0 a_277_47# a_247_21# a_27_413# VPB sky130_fd_pr__pfet_01v8_hvt ad=0.0567 pd=0.69 as=0.1092 ps=1.36 w=0.42 l=0.15
X1 VGND S0 a_247_21# VNB sky130_fd_pr__nfet_01v8 ad=0.1092 pd=1.36 as=0.1092 ps=1.36 w=0.42 l=0.15
X2 a_834_97# a_247_21# a_750_97# VNB sky130_fd_pr__nfet_01v8 ad=0.10795 pd=1.36 as=0.0567 ps=0.69 w=0.42 l=0.15
X3 VGND A3 a_668_97# VNB sky130_fd_pr__nfet_01v8 ad=0.0567 pd=0.69 as=0.1079 ps=1.36 w=0.42 l=0.15
X4 a_1290_413# S1 VPWR VPB sky130_fd_pr__pfet_01v8_hvt ad=0.1092 pd=1.36 as=0.1092 ps=1.36 w=0.42 l=0.15
X5 a_834_97# A2 VGND VNB sky130_fd_pr__nfet_01v8 ad=0.1092 pd=1.36 as=0.0567 ps=0.69 w=0.42 l=0.15
X6 a_750_97# S0 a_757_363# VPB sky130_fd_pr__pfet_01v8_hvt ad=0.0567 pd=0.69 as=0.1079 ps=1.36 w=0.42 l=0.15
X7 a_27_47# S0 a_277_47# VNB sky130_fd_pr__nfet_01v8 ad=0.1092 pd=1.36 as=0.08523 ps=0.925 w=0.42 l=0.15
X8 X a_1478_413# VGND VNB sky130_fd_pr__nfet_01v8 ad=0.169 pd=1.82 as=0.169 ps=1.82 w=0.65 l=0.15
X9 VPWR A1 a_27_413# VPB sky130_fd_pr__pfet_01v8_hvt ad=0.0567 pd=0.69 as=0.1092 ps=1.36 w=0.42 l=0.15
X10 VPWR S0 a_247_21# VPB sky130_fd_pr__pfet_01v8_hvt ad=0.1079 pd=1.36 as=0.1083 ps=1.36 w=0.42 l=0.15
X11 X a_1478_413# VPWR VPB sky130_fd_pr__pfet_01v8_hvt ad=0.26 pd=2.52 as=0.26 ps=2.52 w=1 l=0.15
X12 a_193_47# A0 VGND VNB sky130_fd_pr__nfet_01v8 ad=0.0567 pd=0.69 as=0.0567 ps=0.69 w=0.42 l=0.15
X13 a_750_97# a_1290_413# a_1478_413# VPB sky130_fd_pr__pfet_01v8_hvt ad=0.2688 pd=2.12 as=0.09207 ps=0.99 w=0.42 l=0.15
X14 a_1478_413# S1 a_277_47# VPB sky130_fd_pr__pfet_01v8_hvt ad=0.09207 pd=0.99 as=0.1092 ps=1.36 w=0.42 l=0.15
X15 a_1290_413# S1 VGND VNB sky130_fd_pr__nfet_01v8 ad=0.1092 pd=1.36 as=0.1092 ps=1.36 w=0.42 l=0.15
X16 a_277_47# a_247_21# a_193_47# VNB sky130_fd_pr__nfet_01v8 ad=0.08523 pd=0.925 as=0.0567 ps=0.69 w=0.42 l=0.15
X17 a_750_97# S0 a_668_97# VNB sky130_fd_pr__nfet_01v8 ad=0.0567 pd=0.69 as=0.1092 ps=1.36 w=0.42 l=0.15
X18 a_923_363# a_247_21# a_750_97# VPB sky130_fd_pr__pfet_01v8_hvt ad=0.09013 pd=0.995 as=0.0567 ps=0.69 w=0.42 l=0.15
X19 a_757_363# A2 VPWR VPB sky130_fd_pr__pfet_01v8_hvt ad=0.1092 pd=1.36 as=0.0567 ps=0.69 w=0.42 l=0.15
X20 VPWR A3 a_923_363# VPB sky130_fd_pr__pfet_01v8_hvt ad=0.0567 pd=0.69 as=0.09013 ps=0.995 w=0.42 l=0.15
X21 a_277_47# a_1290_413# a_1478_413# VNB sky130_fd_pr__nfet_01v8 ad=0.1092 pd=1.36 as=0.15102 ps=1.285 w=0.42 l=0.15
X22 a_193_413# A0 VPWR VPB sky130_fd_pr__pfet_01v8_hvt ad=0.1092 pd=1.36 as=0.0567 ps=0.69 w=0.42 l=0.15
X23 a_193_413# S0 a_277_47# VPB sky130_fd_pr__pfet_01v8_hvt ad=0.1079 pd=1.36 as=0.0567 ps=0.69 w=0.42 l=0.15
X24 VGND A1 a_27_47# VNB sky130_fd_pr__nfet_01v8 ad=0.0567 pd=0.69 as=0.1092 ps=1.36 w=0.42 l=0.15
X25 a_1478_413# S1 a_750_97# VNB sky130_fd_pr__nfet_01v8 ad=0.15102 pd=1.285 as=0.1092 ps=1.36 w=0.42 l=0.15
C0 a_1478_413# a_750_97# 0.1456f
C1 VPWR VGND 0.05896f
C2 S0 a_247_21# 0.39319f
C3 a_668_97# S0 0.03f
C4 VGND S1 0.04087f
C5 A0 a_750_97# 0
C6 a_27_413# VGND 0.00189f
C7 a_247_21# A2 0.00145f
C8 a_277_47# a_750_97# 0.26678f
C9 VGND a_193_413# 0
C10 a_247_21# a_27_47# 0.0457f
C11 a_757_363# a_750_97# 0.13413f
C12 a_1290_413# a_834_97# 0.01242f
C13 A1 VPB 0.0741f
C14 S0 A0 0.00186f
C15 S0 a_277_47# 0.03381f
C16 VGND X 0.05939f
C17 a_277_47# A2 0.01375f
C18 A0 a_27_47# 0.04574f
C19 VGND a_247_21# 0.09412f
C20 a_668_97# VGND 0.22352f
C21 S0 a_757_363# 0.03305f
C22 a_277_47# a_27_47# 0.08551f
C23 A3 a_834_97# 0.03609f
C24 A2 a_757_363# 0.03541f
C25 VPB a_834_97# 0.00426f
C26 VGND a_1478_413# 0.18885f
C27 VPWR A1 0.01712f
C28 A1 a_27_413# 0.0413f
C29 a_1290_413# A3 0
C30 A1 a_193_413# 0
C31 VGND A0 0.01709f
C32 a_1290_413# VPB 0.14223f
C33 VGND a_277_47# 0.41112f
C34 S0 a_750_97# 0.09449f
C35 VPWR a_834_97# 0
C36 A2 a_750_97# 0.01619f
C37 S1 a_834_97# 0.00189f
C38 VPB A3 0.07252f
C39 A1 a_247_21# 0
C40 VPWR a_1290_413# 0.0823f
C41 a_923_363# a_834_97# 0
C42 a_1290_413# S1 0.15612f
C43 S0 a_27_47# 0.01792f
C44 a_1290_413# a_923_363# 0
C45 VGND a_750_97# 0.05676f
C46 VPWR A3 0.012f
C47 a_247_21# a_834_97# 0.02707f
C48 A3 S1 0
C49 A1 A0 0.14123f
C50 VPWR a_193_47# 0
C51 a_668_97# a_834_97# 0.05583f
C52 VPWR VPB 0.22689f
C53 VPB S1 0.21534f
C54 A1 a_277_47# 0.00101f
C55 a_27_413# VPB 0.02285f
C56 a_1290_413# X 0.00208f
C57 a_193_413# VPB 0.01733f
C58 A3 a_923_363# 0
C59 S0 VGND 0.06675f
C60 a_1290_413# a_247_21# 0.00705f
C61 a_668_97# a_1290_413# 0
C62 VGND A2 0.0122f
C63 a_1290_413# a_1478_413# 0.10432f
C64 VGND a_27_47# 0.22952f
C65 a_277_47# a_834_97# 0.04391f
C66 VPWR S1 0.0409f
C67 VPB X 0.01181f
C68 VPWR a_27_413# 0.08385f
C69 a_247_21# A3 0.07395f
C70 a_668_97# A3 0.0033f
C71 VPWR a_193_413# 0.18442f
C72 a_757_363# a_834_97# 0.01352f
C73 a_247_21# VPB 0.22297f
C74 a_668_97# VPB 0.00146f
C75 a_27_413# a_193_413# 0.05551f
C76 a_1290_413# a_277_47# 0.33858f
C77 A1 a_750_97# 0
C78 VPWR a_923_363# 0.00225f
C79 a_1478_413# VPB 0.07712f
C80 a_1290_413# a_757_363# 0.0098f
C81 VPWR X 0.05937f
C82 S1 X 0
C83 A0 a_193_47# 0
C84 A0 VPB 0.08019f
C85 a_277_47# A3 0.0121f
C86 a_277_47# a_193_47# 0
C87 VPWR a_247_21# 0.15063f
C88 a_668_97# VPWR 0.00181f
C89 a_277_47# VPB 0.03677f
C90 a_750_97# a_834_97# 0.0296f
C91 a_247_21# S1 0
C92 a_27_413# a_247_21# 0.00549f
C93 VPWR a_1478_413# 0.21151f
C94 A3 a_757_363# 0.03224f
C95 a_193_413# a_247_21# 0.09132f
C96 a_1478_413# S1 0.00517f
C97 A1 a_27_47# 0.03909f
C98 VPB a_757_363# 0.0237f
C99 a_1290_413# a_750_97# 0.17579f
C100 S0 a_834_97# 0
C101 VPWR A0 0.01747f
C102 a_27_413# A0 0.04892f
C103 A2 a_834_97# 0.04394f
C104 VPWR a_277_47# 0.05706f
C105 a_277_47# S1 0.06116f
C106 a_247_21# X 0
C107 a_27_413# a_277_47# 0.05408f
C108 a_193_413# A0 0.00145f
C109 A1 VGND 0.01705f
C110 A3 a_750_97# 0.03406f
C111 a_193_413# a_277_47# 0.0594f
C112 a_1478_413# X 0.12698f
C113 a_668_97# a_247_21# 0.01881f
C114 VPWR a_757_363# 0.24812f
C115 VPB a_750_97# 0.05933f
C116 a_757_363# S1 0.00151f
C117 a_1290_413# A2 0.00165f
C118 a_247_21# a_1478_413# 0
C119 a_923_363# a_757_363# 0.00988f
C120 S0 A3 0.00317f
C121 a_277_47# X 0
C122 VGND a_834_97# 0.09477f
C123 S0 VPB 0.31074f
C124 a_247_21# A0 0.07359f
C125 A2 A3 0.15492f
C126 a_247_21# a_277_47# 0.35203f
C127 a_668_97# a_277_47# 0.02235f
C128 A2 VPB 0.07872f
C129 VPWR a_750_97# 0.22609f
C130 a_750_97# S1 0.06323f
C131 A3 a_27_47# 0
C132 a_27_413# a_750_97# 0
C133 a_27_47# a_193_47# 0.00648f
C134 VPB a_27_47# 0.00324f
C135 a_1290_413# VGND 0.06373f
C136 a_277_47# a_1478_413# 0.09435f
C137 a_193_413# a_750_97# 0
C138 a_247_21# a_757_363# 0.02645f
C139 a_923_363# a_750_97# 0.00222f
C140 VPWR S0 0.0687f
C141 a_277_47# A0 0.05427f
C142 S0 a_27_413# 0
C143 VPWR A2 0.0129f
C144 VGND A3 0.01161f
C145 A2 S1 0.06853f
C146 a_750_97# X 0
C147 VGND a_193_47# 0.00175f
C148 S0 a_193_413# 0.01772f
C149 VGND VPB 0.01387f
C150 VPWR a_27_47# 0.0018f
C151 a_27_413# a_27_47# 0.00987f
C152 a_247_21# a_750_97# 0.12371f
C153 a_277_47# a_757_363# 0
C154 a_668_97# a_750_97# 0.04662f
C155 VGND VNB 1.07507f
C156 X VNB 0.09236f
C157 S1 VNB 0.32062f
C158 A2 VNB 0.11249f
C159 A3 VNB 0.11926f
C160 S0 VNB 0.46486f
C161 VPWR VNB 0.86887f
C162 A0 VNB 0.10257f
C163 A1 VNB 0.17585f
C164 VPB VNB 1.9337f
C165 a_834_97# VNB 0.02499f
C166 a_668_97# VNB 0.02039f
C167 a_27_47# VNB 0.04207f
C168 a_1478_413# VNB 0.16413f
C169 a_1290_413# VNB 0.2199f
C170 a_750_97# VNB 0.04192f
C171 a_757_363# VNB 0.00666f
C172 a_277_47# VNB 0.07984f
C173 a_247_21# VNB 0.34344f
C174 a_193_413# VNB 0.00373f
C175 a_27_413# VNB 0.02865f
.ends

.subckt sky130_fd_sc_hd__o21a_2 VNB VPB VGND VPWR X B1 A2 A1 a_384_47# a_470_297#
+ a_79_21#
X0 VPWR A1 a_470_297# VPB sky130_fd_pr__pfet_01v8_hvt ad=0.265 pd=2.53 as=0.16 ps=1.32 w=1 l=0.15
X1 a_79_21# B1 VPWR VPB sky130_fd_pr__pfet_01v8_hvt ad=0.14 pd=1.28 as=0.4 ps=1.8 w=1 l=0.15
X2 VGND a_79_21# X VNB sky130_fd_pr__nfet_01v8 ad=0.17225 pd=1.83 as=0.08937 ps=0.925 w=0.65 l=0.15
X3 VGND A2 a_384_47# VNB sky130_fd_pr__nfet_01v8 ad=0.104 pd=0.97 as=0.091 ps=0.93 w=0.65 l=0.15
X4 a_470_297# A2 a_79_21# VPB sky130_fd_pr__pfet_01v8_hvt ad=0.16 pd=1.32 as=0.14 ps=1.28 w=1 l=0.15
X5 VPWR a_79_21# X VPB sky130_fd_pr__pfet_01v8_hvt ad=0.4 pd=1.8 as=0.1375 ps=1.275 w=1 l=0.15
X6 a_384_47# B1 a_79_21# VNB sky130_fd_pr__nfet_01v8 ad=0.091 pd=0.93 as=0.17225 ps=1.83 w=0.65 l=0.15
X7 a_384_47# A1 VGND VNB sky130_fd_pr__nfet_01v8 ad=0.17225 pd=1.83 as=0.104 ps=0.97 w=0.65 l=0.15
X8 X a_79_21# VPWR VPB sky130_fd_pr__pfet_01v8_hvt ad=0.1375 pd=1.275 as=0.26 ps=2.52 w=1 l=0.15
X9 X a_79_21# VGND VNB sky130_fd_pr__nfet_01v8 ad=0.08937 pd=0.925 as=0.169 ps=1.82 w=0.65 l=0.15
C0 a_470_297# B1 0
C1 VPWR A1 0.04887f
C2 a_79_21# A2 0.04273f
C3 A2 VPB 0.03377f
C4 B1 VGND 0.01952f
C5 A1 a_384_47# 0.03864f
C6 X VGND 0.10592f
C7 A2 B1 0.09948f
C8 a_79_21# A1 0.0024f
C9 A1 VPB 0.04016f
C10 VPWR a_384_47# 0.00722f
C11 A1 B1 0
C12 a_79_21# VPWR 0.2223f
C13 VPWR VPB 0.079f
C14 a_470_297# VGND 0.00158f
C15 a_79_21# a_384_47# 0.03435f
C16 a_384_47# VPB 0
C17 VPWR B1 0.02419f
C18 a_470_297# A2 0.01159f
C19 VPWR X 0.13299f
C20 A2 VGND 0.01957f
C21 a_384_47# B1 0.00268f
C22 a_79_21# VPB 0.07954f
C23 a_79_21# B1 0.17323f
C24 VPB B1 0.03944f
C25 a_79_21# X 0.16252f
C26 A1 VGND 0.01757f
C27 X VPB 0.00507f
C28 A1 A2 0.09025f
C29 a_470_297# VPWR 0.01177f
C30 X B1 0
C31 VPWR VGND 0.07997f
C32 a_470_297# a_384_47# 0
C33 a_384_47# VGND 0.09661f
C34 VPWR A2 0.05921f
C35 a_79_21# a_470_297# 0.00478f
C36 A2 a_384_47# 0.05585f
C37 a_79_21# VGND 0.15845f
C38 VPB VGND 0.00643f
C39 VGND VNB 0.43148f
C40 X VNB 0.02758f
C41 VPWR VNB 0.38347f
C42 A1 VNB 0.15077f
C43 A2 VNB 0.10192f
C44 B1 VNB 0.1061f
C45 VPB VNB 0.69336f
C46 a_384_47# VNB 0.01898f
C47 a_79_21# VNB 0.24775f
.ends

.subckt sky130_fd_sc_hd__a221o_2 VPWR VGND VPB VNB C1 B2 B1 A1 A2 X a_193_297# a_465_47#
+ a_205_47# a_109_297# a_27_47#
X0 VPWR a_27_47# X VPB sky130_fd_pr__pfet_01v8_hvt ad=0.285 pd=2.57 as=0.135 ps=1.27 w=1 l=0.15
X1 a_465_47# A1 a_27_47# VNB sky130_fd_pr__nfet_01v8 ad=0.10725 pd=0.98 as=0.169 ps=1.82 w=0.65 l=0.15
X2 X a_27_47# VPWR VPB sky130_fd_pr__pfet_01v8_hvt ad=0.135 pd=1.27 as=0.1575 ps=1.315 w=1 l=0.15
X3 a_109_297# B1 a_193_297# VPB sky130_fd_pr__pfet_01v8_hvt ad=0.26 pd=2.52 as=0.135 ps=1.27 w=1 l=0.15
X4 a_193_297# B2 a_109_297# VPB sky130_fd_pr__pfet_01v8_hvt ad=0.135 pd=1.27 as=0.135 ps=1.27 w=1 l=0.15
X5 X a_27_47# VGND VNB sky130_fd_pr__nfet_01v8 ad=0.08775 pd=0.92 as=0.10238 ps=0.965 w=0.65 l=0.15
X6 a_205_47# B2 VGND VNB sky130_fd_pr__nfet_01v8 ad=0.06825 pd=0.86 as=0.10725 ps=0.98 w=0.65 l=0.15
X7 VPWR A2 a_193_297# VPB sky130_fd_pr__pfet_01v8_hvt ad=0.1575 pd=1.315 as=0.165 ps=1.33 w=1 l=0.15
X8 a_193_297# A1 VPWR VPB sky130_fd_pr__pfet_01v8_hvt ad=0.165 pd=1.33 as=0.26 ps=2.52 w=1 l=0.15
X9 a_27_47# B1 a_205_47# VNB sky130_fd_pr__nfet_01v8 ad=0.169 pd=1.82 as=0.06825 ps=0.86 w=0.65 l=0.15
X10 VGND a_27_47# X VNB sky130_fd_pr__nfet_01v8 ad=0.18525 pd=1.87 as=0.08775 ps=0.92 w=0.65 l=0.15
X11 a_109_297# C1 a_27_47# VPB sky130_fd_pr__pfet_01v8_hvt ad=0.135 pd=1.27 as=0.26 ps=2.52 w=1 l=0.15
X12 VGND C1 a_27_47# VNB sky130_fd_pr__nfet_01v8 ad=0.10725 pd=0.98 as=0.169 ps=1.82 w=0.65 l=0.15
X13 VGND A2 a_465_47# VNB sky130_fd_pr__nfet_01v8 ad=0.10238 pd=0.965 as=0.10725 ps=0.98 w=0.65 l=0.15
C0 VPWR a_193_297# 0.16924f
C1 a_109_297# C1 0.00739f
C2 VGND a_193_297# 0.00438f
C3 a_27_47# A1 0.09838f
C4 B1 B2 0.07843f
C5 B1 VPWR 0.00982f
C6 X a_193_297# 0.00367f
C7 B1 VGND 0.01327f
C8 a_109_297# a_193_297# 0.09272f
C9 A1 VPB 0.0343f
C10 B1 X 0
C11 B1 a_109_297# 0.00736f
C12 A1 A2 0.06924f
C13 A1 VPWR 0.01613f
C14 a_27_47# a_205_47# 0.00762f
C15 a_27_47# VPB 0.08209f
C16 A1 VGND 0.01257f
C17 A1 X 0
C18 a_465_47# A1 0
C19 a_27_47# B2 0.09593f
C20 a_27_47# A2 0.15296f
C21 A1 a_109_297# 0
C22 a_27_47# VPWR 0.11848f
C23 a_27_47# VGND 0.41486f
C24 B1 C1 0
C25 VPB B2 0.02556f
C26 A2 VPB 0.02696f
C27 VPWR a_205_47# 0
C28 VPWR VPB 0.09413f
C29 a_27_47# X 0.12862f
C30 a_465_47# a_27_47# 0.01301f
C31 VGND a_205_47# 0.00156f
C32 VPB VGND 0.01028f
C33 a_27_47# a_109_297# 0.09613f
C34 B1 a_193_297# 0.00869f
C35 X VPB 0.00423f
C36 VPWR B2 0.00842f
C37 A2 VPWR 0.02093f
C38 A1 C1 0
C39 VGND B2 0.01744f
C40 A2 VGND 0.01675f
C41 a_109_297# VPB 0.00421f
C42 VPWR VGND 0.09384f
C43 X B2 0
C44 A2 X 0.00157f
C45 VPWR X 0.17541f
C46 a_465_47# VPWR 0
C47 a_109_297# B2 0.01335f
C48 A1 a_193_297# 0.01087f
C49 X VGND 0.12187f
C50 a_27_47# C1 0.07922f
C51 a_465_47# VGND 0.00257f
C52 VPWR a_109_297# 0.15013f
C53 a_109_297# VGND 0.00284f
C54 A1 B1 0.06093f
C55 a_465_47# X 0
C56 VPB C1 0.0368f
C57 X a_109_297# 0
C58 a_27_47# a_193_297# 0.14375f
C59 C1 B2 0.07257f
C60 A2 C1 0
C61 VPB a_193_297# 0.00774f
C62 a_27_47# B1 0.11237f
C63 VPWR C1 0.01404f
C64 VGND C1 0.01975f
C65 B1 VPB 0.03208f
C66 B2 a_193_297# 0.00126f
C67 A2 a_193_297# 0.00683f
C68 X C1 0
C69 VGND VNB 0.51852f
C70 X VNB 0.02003f
C71 VPWR VNB 0.44375f
C72 A2 VNB 0.08957f
C73 A1 VNB 0.10591f
C74 B1 VNB 0.10847f
C75 B2 VNB 0.08869f
C76 C1 VNB 0.13936f
C77 VPB VNB 0.87055f
C78 a_193_297# VNB 0.0011f
C79 a_109_297# VNB 0
C80 a_27_47# VNB 0.30506f
.ends

.subckt sky130_fd_sc_hd__mux2_1 VGND VPWR VPB VNB X A1 S A0 a_505_21# a_535_374# a_439_47#
+ a_218_47# a_76_199# a_218_374#
X0 VPWR a_505_21# a_535_374# VPB sky130_fd_pr__pfet_01v8_hvt ad=0.0693 pd=0.75 as=0.0441 ps=0.63 w=0.42 l=0.15
X1 a_505_21# S VPWR VPB sky130_fd_pr__pfet_01v8_hvt ad=0.1176 pd=1.4 as=0.0693 ps=0.75 w=0.42 l=0.15
X2 a_218_374# S VPWR VPB sky130_fd_pr__pfet_01v8_hvt ad=0.07665 pd=0.785 as=0.15835 ps=1.395 w=0.42 l=0.15
X3 VGND a_505_21# a_439_47# VNB sky130_fd_pr__nfet_01v8 ad=0.1449 pd=1.11 as=0.0693 ps=0.75 w=0.42 l=0.15
X4 a_76_199# A0 a_218_374# VPB sky130_fd_pr__pfet_01v8_hvt ad=0.1932 pd=1.34 as=0.07665 ps=0.785 w=0.42 l=0.15
X5 a_505_21# S VGND VNB sky130_fd_pr__nfet_01v8 ad=0.1092 pd=1.36 as=0.1449 ps=1.11 w=0.42 l=0.15
X6 a_439_47# A0 a_76_199# VNB sky130_fd_pr__nfet_01v8 ad=0.0693 pd=0.75 as=0.09975 ps=0.895 w=0.42 l=0.15
X7 a_535_374# A1 a_76_199# VPB sky130_fd_pr__pfet_01v8_hvt ad=0.0441 pd=0.63 as=0.1932 ps=1.34 w=0.42 l=0.15
X8 a_76_199# A1 a_218_47# VNB sky130_fd_pr__nfet_01v8 ad=0.09975 pd=0.895 as=0.0693 ps=0.75 w=0.42 l=0.15
X9 a_218_47# S VGND VNB sky130_fd_pr__nfet_01v8 ad=0.0693 pd=0.75 as=0.11285 ps=1.045 w=0.42 l=0.15
X10 VPWR a_76_199# X VPB sky130_fd_pr__pfet_01v8_hvt ad=0.15835 pd=1.395 as=0.26 ps=2.52 w=1 l=0.15
X11 VGND a_76_199# X VNB sky130_fd_pr__nfet_01v8 ad=0.11285 pd=1.045 as=0.169 ps=1.82 w=0.65 l=0.15
C0 a_218_374# VGND 0
C1 VPWR VPB 0.10994f
C2 A1 S 0.08722f
C3 VPWR S 0.39244f
C4 X VGND 0.05864f
C5 A1 a_505_21# 0.09927f
C6 A0 VGND 0.04323f
C7 a_505_21# VPWR 0.08183f
C8 a_218_374# a_76_199# 0.00557f
C9 a_76_199# VGND 0.16013f
C10 a_535_374# VGND 0
C11 VPB S 0.16849f
C12 a_218_47# VGND 0.00328f
C13 X a_76_199# 0.07764f
C14 a_218_374# VPWR 0.00177f
C15 X a_218_47# 0
C16 a_505_21# VPB 0.07806f
C17 a_439_47# VGND 0.00354f
C18 A1 VGND 0.07521f
C19 a_76_199# A0 0.05444f
C20 VPWR VGND 0.08036f
C21 X VPWR 0.12783f
C22 a_505_21# S 0.19751f
C23 a_535_374# a_76_199# 0
C24 a_439_47# A0 0.00369f
C25 A1 A0 0.2668f
C26 a_218_47# a_76_199# 0.00783f
C27 VPWR A0 0.00732f
C28 VPB VGND 0.01345f
C29 A1 a_76_199# 0.18667f
C30 a_218_374# S 0.00688f
C31 VPWR a_76_199# 0.05421f
C32 a_535_374# VPWR 0
C33 X VPB 0.01205f
C34 a_218_47# VPWR 0
C35 S VGND 0.03296f
C36 A1 a_439_47# 0.00498f
C37 VPB A0 0.1066f
C38 a_439_47# VPWR 0
C39 A1 VPWR 0.01137f
C40 X S 0.00823f
C41 a_505_21# VGND 0.12387f
C42 VPB a_76_199# 0.04809f
C43 S A0 0.03411f
C44 a_505_21# A0 0.03829f
C45 a_76_199# S 0.31816f
C46 a_535_374# S 0.00526f
C47 A1 VPB 0.07208f
C48 VGND VNB 0.49866f
C49 A1 VNB 0.14042f
C50 A0 VNB 0.13429f
C51 S VNB 0.26814f
C52 VPWR VNB 0.41925f
C53 X VNB 0.09236f
C54 VPB VNB 0.87055f
C55 a_505_21# VNB 0.24676f
C56 a_76_199# VNB 0.13947f
.ends

.subckt sky130_fd_sc_hd__o21ba_2 VNB VPB VGND VPWR A2 A1 B1_N X a_478_47# a_27_93#
+ a_574_297# a_174_21#
X0 VGND B1_N a_27_93# VNB sky130_fd_pr__nfet_01v8 ad=0.097 pd=0.975 as=0.1092 ps=1.36 w=0.42 l=0.15
X1 VGND A2 a_478_47# VNB sky130_fd_pr__nfet_01v8 ad=0.08775 pd=0.92 as=0.10563 ps=0.975 w=0.65 l=0.15
X2 a_478_47# a_27_93# a_174_21# VNB sky130_fd_pr__nfet_01v8 ad=0.10563 pd=0.975 as=0.169 ps=1.82 w=0.65 l=0.15
X3 a_478_47# A1 VGND VNB sky130_fd_pr__nfet_01v8 ad=0.169 pd=1.82 as=0.08775 ps=0.92 w=0.65 l=0.15
X4 X a_174_21# VGND VNB sky130_fd_pr__nfet_01v8 ad=0.08775 pd=0.92 as=0.097 ps=0.975 w=0.65 l=0.15
X5 VPWR a_174_21# X VPB sky130_fd_pr__pfet_01v8_hvt ad=0.395 pd=1.79 as=0.135 ps=1.27 w=1 l=0.15
X6 X a_174_21# VPWR VPB sky130_fd_pr__pfet_01v8_hvt ad=0.135 pd=1.27 as=0.14575 ps=1.335 w=1 l=0.15
X7 VPWR A1 a_574_297# VPB sky130_fd_pr__pfet_01v8_hvt ad=0.28 pd=2.56 as=0.105 ps=1.21 w=1 l=0.15
X8 VGND a_174_21# X VNB sky130_fd_pr__nfet_01v8 ad=0.169 pd=1.82 as=0.08775 ps=0.92 w=0.65 l=0.15
X9 VPWR B1_N a_27_93# VPB sky130_fd_pr__pfet_01v8_hvt ad=0.14575 pd=1.335 as=0.1092 ps=1.36 w=0.42 l=0.15
X10 a_574_297# A2 a_174_21# VPB sky130_fd_pr__pfet_01v8_hvt ad=0.105 pd=1.21 as=0.165 ps=1.33 w=1 l=0.15
X11 a_174_21# a_27_93# VPWR VPB sky130_fd_pr__pfet_01v8_hvt ad=0.165 pd=1.33 as=0.395 ps=1.79 w=1 l=0.15
C0 X VPB 0.00312f
C1 a_27_93# A1 0
C2 a_174_21# X 0.10302f
C3 B1_N VPWR 0.01005f
C4 VGND B1_N 0.03497f
C5 a_174_21# VPB 0.07057f
C6 a_478_47# VPB 0
C7 B1_N a_27_93# 0.0956f
C8 A2 VPB 0.02572f
C9 X VPWR 0.01453f
C10 X VGND 0.1117f
C11 a_174_21# a_478_47# 0.04688f
C12 a_174_21# A2 0.05477f
C13 VPWR VPB 0.08928f
C14 VGND VPB 0.00775f
C15 A1 a_574_297# 0
C16 A2 a_478_47# 0.05445f
C17 a_174_21# VPWR 0.16766f
C18 a_174_21# VGND 0.15593f
C19 X a_27_93# 0.06273f
C20 VPWR a_478_47# 0.00511f
C21 A2 VPWR 0.0222f
C22 VGND a_478_47# 0.14787f
C23 VGND A2 0.0152f
C24 a_27_93# VPB 0.06917f
C25 a_174_21# a_27_93# 0.24554f
C26 VGND VPWR 0.07638f
C27 a_27_93# a_478_47# 0.00383f
C28 a_27_93# A2 0.05337f
C29 A1 VPB 0.03906f
C30 a_27_93# VPWR 0.17642f
C31 VGND a_27_93# 0.07422f
C32 a_174_21# A1 0.01787f
C33 X B1_N 0.05903f
C34 A1 a_478_47# 0.05742f
C35 A2 A1 0.08184f
C36 a_174_21# a_574_297# 0.00594f
C37 B1_N VPB 0.03863f
C38 A1 VPWR 0.05355f
C39 VGND A1 0.01629f
C40 a_574_297# a_478_47# 0.00203f
C41 a_174_21# B1_N 0.04164f
C42 A2 a_574_297# 0.0012f
C43 B1_N a_478_47# 0
C44 VPWR a_574_297# 0.00809f
C45 VGND a_574_297# 0.00166f
C46 VGND VNB 0.45343f
C47 X VNB 0.00534f
C48 B1_N VNB 0.12157f
C49 VPWR VNB 0.39541f
C50 A1 VNB 0.14585f
C51 A2 VNB 0.0899f
C52 VPB VNB 0.78196f
C53 a_478_47# VNB 0.0324f
C54 a_27_93# VNB 0.20594f
C55 a_174_21# VNB 0.21227f
.ends

.subckt sky130_fd_sc_hd__nand2b_2 VNB VPB VGND VPWR A_N Y B a_229_47# a_27_93#
X0 Y B VPWR VPB sky130_fd_pr__pfet_01v8_hvt ad=0.135 pd=1.27 as=0.335 ps=1.67 w=1 l=0.15
X1 VGND A_N a_27_93# VNB sky130_fd_pr__nfet_01v8 ad=0.194 pd=1.95 as=0.1092 ps=1.36 w=0.42 l=0.15
X2 VGND B a_229_47# VNB sky130_fd_pr__nfet_01v8 ad=0.08775 pd=0.92 as=0.08775 ps=0.92 w=0.65 l=0.15
X3 Y a_27_93# a_229_47# VNB sky130_fd_pr__nfet_01v8 ad=0.08775 pd=0.92 as=0.169 ps=1.82 w=0.65 l=0.15
X4 a_229_47# a_27_93# Y VNB sky130_fd_pr__nfet_01v8 ad=0.08775 pd=0.92 as=0.08775 ps=0.92 w=0.65 l=0.15
X5 Y a_27_93# VPWR VPB sky130_fd_pr__pfet_01v8_hvt ad=0.165 pd=1.33 as=0.1468 ps=1.34 w=1 l=0.15
X6 VPWR a_27_93# Y VPB sky130_fd_pr__pfet_01v8_hvt ad=0.335 pd=1.67 as=0.165 ps=1.33 w=1 l=0.15
X7 VPWR B Y VPB sky130_fd_pr__pfet_01v8_hvt ad=0.275 pd=2.55 as=0.135 ps=1.27 w=1 l=0.15
X8 a_229_47# B VGND VNB sky130_fd_pr__nfet_01v8 ad=0.169 pd=1.82 as=0.08775 ps=0.92 w=0.65 l=0.15
X9 VPWR A_N a_27_93# VPB sky130_fd_pr__pfet_01v8_hvt ad=0.1468 pd=1.34 as=0.1092 ps=1.36 w=0.42 l=0.15
C0 a_229_47# a_27_93# 0.05476f
C1 VPB a_229_47# 0
C2 a_229_47# B 0.12787f
C3 a_229_47# A_N 0.00146f
C4 a_229_47# VPWR 0.0046f
C5 VGND a_27_93# 0.07927f
C6 VGND VPB 0.00778f
C7 VGND B 0.03115f
C8 VGND A_N 0.04234f
C9 a_229_47# Y 0.0848f
C10 VGND VPWR 0.06699f
C11 VPB a_27_93# 0.10054f
C12 B a_27_93# 0.04811f
C13 VPB B 0.08297f
C14 A_N a_27_93# 0.12924f
C15 VPB A_N 0.0377f
C16 VPWR a_27_93# 0.09512f
C17 VPB VPWR 0.09247f
C18 B VPWR 0.07134f
C19 VPWR A_N 0.00854f
C20 VGND Y 0.01185f
C21 Y a_27_93# 0.15215f
C22 VPB Y 0.00632f
C23 VGND a_229_47# 0.30599f
C24 B Y 0.13629f
C25 A_N Y 0.00387f
C26 VPWR Y 0.36778f
C27 VGND VNB 0.41132f
C28 Y VNB 0.0094f
C29 A_N VNB 0.12449f
C30 VPWR VNB 0.37543f
C31 B VNB 0.24538f
C32 VPB VNB 0.69336f
C33 a_229_47# VNB 0.0409f
C34 a_27_93# VNB 0.28968f
.ends

.subckt sky130_fd_sc_hd__mux4_2 VNB VPB VGND VPWR S0 A2 A3 S1 A1 A0 X a_193_369# a_372_413#
+ a_1281_47# a_193_47# a_1064_47# a_1060_369# a_288_47# a_397_47# a_872_316# a_1279_413#
+ a_788_316# a_600_345# a_27_47#
X0 a_600_345# S1 VPWR VPB sky130_fd_pr__pfet_01v8_hvt ad=0.1664 pd=1.8 as=0.0864 ps=0.91 w=0.64 l=0.15
X1 a_788_316# S1 a_288_47# VNB sky130_fd_pr__nfet_01v8 ad=0.05775 pd=0.695 as=0.1092 ps=1.36 w=0.42 l=0.15
X2 VPWR A3 a_372_413# VPB sky130_fd_pr__pfet_01v8_hvt ad=0.0864 pd=0.91 as=0.1645 ps=1.33 w=0.64 l=0.15
X3 a_872_316# a_600_345# a_788_316# VNB sky130_fd_pr__nfet_01v8 ad=0.1092 pd=1.36 as=0.05775 ps=0.695 w=0.42 l=0.15
X4 VPWR S0 a_27_47# VPB sky130_fd_pr__pfet_01v8_hvt ad=0.0864 pd=0.91 as=0.1664 ps=1.8 w=0.64 l=0.15
X5 a_1279_413# S0 a_872_316# VPB sky130_fd_pr__pfet_01v8_hvt ad=0.10535 pd=0.995 as=0.0567 ps=0.69 w=0.42 l=0.15
X6 VGND a_788_316# X VNB sky130_fd_pr__nfet_01v8 ad=0.221 pd=1.98 as=0.08775 ps=0.92 w=0.65 l=0.15
X7 a_1060_369# A1 VPWR VPB sky130_fd_pr__pfet_01v8_hvt ad=0.13775 pd=1.165 as=0.1664 ps=1.8 w=0.64 l=0.15
X8 a_872_316# a_27_47# a_1060_369# VPB sky130_fd_pr__pfet_01v8_hvt ad=0.0567 pd=0.69 as=0.13775 ps=1.165 w=0.42 l=0.15
X9 a_193_47# A2 VGND VNB sky130_fd_pr__nfet_01v8 ad=0.066 pd=0.745 as=0.0567 ps=0.69 w=0.42 l=0.15
X10 a_1064_47# A1 VGND VNB sky130_fd_pr__nfet_01v8 ad=0.0786 pd=0.805 as=0.1092 ps=1.36 w=0.42 l=0.15
X11 a_1281_47# a_27_47# a_872_316# VNB sky130_fd_pr__special_nfet_01v8 ad=0.066 pd=0.745 as=0.072 ps=0.76 w=0.36 l=0.15
X12 a_872_316# S1 a_788_316# VPB sky130_fd_pr__pfet_01v8_hvt ad=0.1404 pd=1.6 as=0.0729 ps=0.81 w=0.54 l=0.15
X13 a_872_316# S0 a_1064_47# VNB sky130_fd_pr__special_nfet_01v8 ad=0.072 pd=0.76 as=0.0786 ps=0.805 w=0.36 l=0.15
X14 X a_788_316# VGND VNB sky130_fd_pr__nfet_01v8 ad=0.08775 pd=0.92 as=0.10675 ps=1.005 w=0.65 l=0.15
X15 a_788_316# a_600_345# a_288_47# VPB sky130_fd_pr__pfet_01v8_hvt ad=0.0729 pd=0.81 as=0.1404 ps=1.6 w=0.54 l=0.15
X16 a_372_413# a_27_47# a_288_47# VPB sky130_fd_pr__pfet_01v8_hvt ad=0.1645 pd=1.33 as=0.0567 ps=0.69 w=0.42 l=0.15
X17 VGND A3 a_397_47# VNB sky130_fd_pr__nfet_01v8 ad=0.0819 pd=0.81 as=0.06705 ps=0.75 w=0.42 l=0.15
X18 a_600_345# S1 VGND VNB sky130_fd_pr__nfet_01v8 ad=0.1134 pd=1.38 as=0.0819 ps=0.81 w=0.42 l=0.15
X19 a_193_369# A2 VPWR VPB sky130_fd_pr__pfet_01v8_hvt ad=0.09575 pd=0.965 as=0.0864 ps=0.91 w=0.64 l=0.15
X20 VPWR a_788_316# X VPB sky130_fd_pr__pfet_01v8_hvt ad=0.34 pd=2.68 as=0.135 ps=1.27 w=1 l=0.15
X21 a_288_47# S0 a_193_369# VPB sky130_fd_pr__pfet_01v8_hvt ad=0.0567 pd=0.69 as=0.09575 ps=0.965 w=0.42 l=0.15
X22 VGND A0 a_1281_47# VNB sky130_fd_pr__nfet_01v8 ad=0.10675 pd=1.005 as=0.066 ps=0.745 w=0.42 l=0.15
X23 a_397_47# S0 a_288_47# VNB sky130_fd_pr__special_nfet_01v8 ad=0.06705 pd=0.75 as=0.0711 ps=0.755 w=0.36 l=0.15
X24 X a_788_316# VPWR VPB sky130_fd_pr__pfet_01v8_hvt ad=0.135 pd=1.27 as=0.154 ps=1.335 w=1 l=0.15
X25 a_288_47# a_27_47# a_193_47# VNB sky130_fd_pr__special_nfet_01v8 ad=0.0711 pd=0.755 as=0.066 ps=0.745 w=0.36 l=0.15
X26 VGND S0 a_27_47# VNB sky130_fd_pr__nfet_01v8 ad=0.0567 pd=0.69 as=0.1092 ps=1.36 w=0.42 l=0.15
X27 VPWR A0 a_1279_413# VPB sky130_fd_pr__pfet_01v8_hvt ad=0.154 pd=1.335 as=0.10535 ps=0.995 w=0.64 l=0.15
C0 a_397_47# a_600_345# 0
C1 A0 X 0.00759f
C2 VPWR S1 0.05589f
C3 VPB a_288_47# 0.02906f
C4 S0 S1 0.02008f
C5 a_1279_413# VGND 0
C6 A2 a_288_47# 0.01726f
C7 VPWR S0 0.09872f
C8 a_788_316# A0 0.12948f
C9 S1 A1 0.00634f
C10 a_788_316# a_288_47# 0.17643f
C11 S1 a_872_316# 0.00638f
C12 A3 S1 0.13241f
C13 VPWR A1 0.0121f
C14 S0 A1 0.0608f
C15 VPWR a_872_316# 0.12667f
C16 a_193_369# a_288_47# 0.00332f
C17 a_27_47# a_600_345# 0.01966f
C18 VPWR A3 0.01888f
C19 S0 a_872_316# 0.07699f
C20 A3 S0 0.06363f
C21 a_788_316# a_1279_413# 0.01019f
C22 a_397_47# VGND 0.00677f
C23 A1 a_872_316# 0.1803f
C24 VPWR A0 0.01237f
C25 a_372_413# a_600_345# 0
C26 S0 A0 0.05335f
C27 S1 a_288_47# 0.03104f
C28 VPWR a_288_47# 0.30526f
C29 S0 a_288_47# 0.06956f
C30 a_27_47# a_372_413# 0.00271f
C31 a_27_47# a_193_47# 0
C32 VGND a_600_345# 0.07766f
C33 A0 a_872_316# 0.01205f
C34 A1 a_288_47# 0
C35 VPWR a_1279_413# 0.00423f
C36 a_27_47# VGND 0.09816f
C37 a_872_316# a_288_47# 0
C38 a_1279_413# S0 0
C39 A3 a_288_47# 0.06334f
C40 VPB a_600_345# 0.08659f
C41 a_27_47# a_1060_369# 0.00149f
C42 a_27_47# a_1064_47# 0
C43 a_27_47# VPB 0.17328f
C44 VGND a_193_47# 0.00481f
C45 a_1279_413# a_872_316# 0.00134f
C46 A2 a_27_47# 0.13939f
C47 a_27_47# X 0
C48 a_788_316# a_600_345# 0.02959f
C49 a_788_316# a_27_47# 0.20254f
C50 a_1279_413# A0 0
C51 A2 a_193_47# 0.00551f
C52 a_397_47# S0 0.0014f
C53 a_27_47# a_193_369# 0.00734f
C54 a_1064_47# VGND 0.00247f
C55 a_1281_47# VGND 0.0043f
C56 S1 a_600_345# 0.23476f
C57 VGND VPB 0.01357f
C58 A2 VGND 0.04995f
C59 VGND X 0.14375f
C60 VPWR a_600_345# 0.01842f
C61 S0 a_600_345# 0.03236f
C62 A3 a_397_47# 0
C63 a_27_47# S1 0.00644f
C64 VPWR a_27_47# 0.18465f
C65 a_788_316# VGND 0.09072f
C66 a_27_47# S0 1.10794f
C67 A2 VPB 0.04286f
C68 A1 a_600_345# 0.02241f
C69 X VPB 0.00515f
C70 a_872_316# a_600_345# 0.01396f
C71 A3 a_600_345# 0.00325f
C72 a_788_316# a_1060_369# 0.00342f
C73 a_788_316# a_1281_47# 0
C74 a_27_47# A1 0.01893f
C75 a_397_47# a_288_47# 0.00489f
C76 VPWR a_372_413# 0.01083f
C77 S0 a_372_413# 0
C78 a_27_47# a_872_316# 0.22381f
C79 a_788_316# VPB 0.08421f
C80 S0 a_193_47# 0.00126f
C81 A3 a_27_47# 0.0128f
C82 a_788_316# X 0.1237f
C83 S1 VGND 0.03529f
C84 VPWR VGND 0.05336f
C85 a_288_47# a_600_345# 0.18073f
C86 S0 VGND 0.23504f
C87 a_27_47# A0 0.06095f
C88 A3 a_372_413# 0.00104f
C89 VPWR a_1060_369# 0.00541f
C90 a_1064_47# S0 0
C91 a_27_47# a_288_47# 0.39481f
C92 S1 VPB 0.20632f
C93 VPWR a_1281_47# 0
C94 S1 X 0
C95 A1 VGND 0.04934f
C96 S0 a_1281_47# 0
C97 VPWR VPB 0.18178f
C98 A2 VPWR 0.01341f
C99 VGND a_872_316# 0.17016f
C100 S0 VPB 0.27433f
C101 VPWR X 0.19134f
C102 A3 VGND 0.04111f
C103 A2 S0 0.16999f
C104 S0 X 0.00119f
C105 a_872_316# a_1060_369# 0.01364f
C106 a_1064_47# a_872_316# 0.00857f
C107 a_288_47# a_372_413# 0.01579f
C108 a_788_316# S1 0.02715f
C109 a_27_47# a_1279_413# 0.00105f
C110 a_193_47# a_288_47# 0
C111 a_1281_47# a_872_316# 0.00133f
C112 A1 VPB 0.07895f
C113 VPWR a_788_316# 0.45321f
C114 A0 VGND 0.08471f
C115 a_788_316# S0 0.07731f
C116 VPB a_872_316# 0.0322f
C117 A3 VPB 0.06193f
C118 VPWR a_193_369# 0.00755f
C119 S0 a_193_369# 0.00258f
C120 VGND a_288_47# 0.09739f
C121 a_1064_47# A0 0
C122 a_1281_47# A0 0.00485f
C123 a_788_316# A1 0.00384f
C124 A0 VPB 0.05738f
C125 a_788_316# a_872_316# 0.16928f
C126 X VNB 0.02573f
C127 VGND VNB 0.96928f
C128 A0 VNB 0.12933f
C129 A1 VNB 0.14082f
C130 S1 VNB 0.29851f
C131 A3 VNB 0.118f
C132 VPWR VNB 0.79947f
C133 A2 VNB 0.1131f
C134 S0 VNB 0.48965f
C135 VPB VNB 1.66792f
C136 a_872_316# VNB 0.03249f
C137 a_600_345# VNB 0.1671f
C138 a_788_316# VNB 0.21903f
C139 a_288_47# VNB 0.02923f
C140 a_27_47# VNB 0.30392f
.ends

.subckt sky130_fd_sc_hd__xor2_2 VPWR VGND X B A VPB VNB a_470_47# a_27_297# a_470_297#
+ a_112_47#
X0 a_27_297# A VPWR VPB sky130_fd_pr__pfet_01v8_hvt ad=0.135 pd=1.27 as=0.135 ps=1.27 w=1 l=0.15
X1 a_470_47# A VGND VNB sky130_fd_pr__nfet_01v8 ad=0.08775 pd=0.92 as=0.08775 ps=0.92 w=0.65 l=0.15
X2 a_470_297# A VPWR VPB sky130_fd_pr__pfet_01v8_hvt ad=0.135 pd=1.27 as=0.135 ps=1.27 w=1 l=0.15
X3 VPWR A a_470_297# VPB sky130_fd_pr__pfet_01v8_hvt ad=0.135 pd=1.27 as=0.26 ps=2.52 w=1 l=0.15
X4 a_112_47# B VGND VNB sky130_fd_pr__nfet_01v8 ad=0.08775 pd=0.92 as=0.08775 ps=0.92 w=0.65 l=0.15
X5 a_470_47# B X VNB sky130_fd_pr__nfet_01v8 ad=0.169 pd=1.82 as=0.10563 ps=0.975 w=0.65 l=0.15
X6 VGND A a_112_47# VNB sky130_fd_pr__nfet_01v8 ad=0.08775 pd=0.92 as=0.08775 ps=0.92 w=0.65 l=0.15
X7 a_112_47# A VGND VNB sky130_fd_pr__nfet_01v8 ad=0.08775 pd=0.92 as=0.17875 ps=1.85 w=0.65 l=0.15
X8 VGND B a_112_47# VNB sky130_fd_pr__nfet_01v8 ad=0.169 pd=1.82 as=0.08775 ps=0.92 w=0.65 l=0.15
X9 VPWR A a_27_297# VPB sky130_fd_pr__pfet_01v8_hvt ad=0.135 pd=1.27 as=0.275 ps=2.55 w=1 l=0.15
X10 a_470_297# B VPWR VPB sky130_fd_pr__pfet_01v8_hvt ad=0.26 pd=2.52 as=0.1625 ps=1.325 w=1 l=0.15
X11 X a_112_47# VGND VNB sky130_fd_pr__nfet_01v8 ad=0.08775 pd=0.92 as=0.169 ps=1.82 w=0.65 l=0.15
X12 VPWR B a_470_297# VPB sky130_fd_pr__pfet_01v8_hvt ad=0.1625 pd=1.325 as=0.135 ps=1.27 w=1 l=0.15
X13 VGND a_112_47# X VNB sky130_fd_pr__nfet_01v8 ad=0.169 pd=1.82 as=0.08775 ps=0.92 w=0.65 l=0.15
X14 VGND A a_470_47# VNB sky130_fd_pr__nfet_01v8 ad=0.08775 pd=0.92 as=0.169 ps=1.82 w=0.65 l=0.15
X15 a_27_297# B a_112_47# VPB sky130_fd_pr__pfet_01v8_hvt ad=0.26 pd=2.52 as=0.135 ps=1.27 w=1 l=0.15
X16 X a_112_47# a_470_297# VPB sky130_fd_pr__pfet_01v8_hvt ad=0.135 pd=1.27 as=0.26 ps=2.52 w=1 l=0.15
X17 a_470_297# a_112_47# X VPB sky130_fd_pr__pfet_01v8_hvt ad=0.28 pd=2.56 as=0.135 ps=1.27 w=1 l=0.15
X18 X B a_470_47# VNB sky130_fd_pr__nfet_01v8 ad=0.10563 pd=0.975 as=0.08775 ps=0.92 w=0.65 l=0.15
X19 a_112_47# B a_27_297# VPB sky130_fd_pr__pfet_01v8_hvt ad=0.135 pd=1.27 as=0.135 ps=1.27 w=1 l=0.15
C0 a_112_47# a_470_297# 0.27101f
C1 B a_470_297# 0.04347f
C2 X VPB 0.0139f
C3 a_112_47# B 0.23765f
C4 X VPWR 0.01803f
C5 a_27_297# a_470_297# 0.02665f
C6 a_112_47# a_470_47# 0.01892f
C7 B a_470_47# 0.05172f
C8 X A 0
C9 a_112_47# a_27_297# 0.16061f
C10 a_27_297# B 0.03782f
C11 VGND VPB 0.00685f
C12 VGND VPWR 0.03995f
C13 VGND A 0.07341f
C14 X a_470_297# 0.11717f
C15 a_112_47# X 0.19434f
C16 X B 0.06038f
C17 X a_470_47# 0.08512f
C18 a_27_297# X 0
C19 VGND a_470_297# 0.00518f
C20 a_112_47# VGND 0.28821f
C21 VGND B 0.16844f
C22 VPB VPWR 0.12036f
C23 VGND a_470_47# 0.30483f
C24 VPB A 0.12564f
C25 a_27_297# VGND 0.0208f
C26 A VPWR 0.06229f
C27 a_470_297# VPB 0.0229f
C28 a_112_47# VPB 0.0941f
C29 VGND X 0.11113f
C30 B VPB 0.12356f
C31 a_470_297# VPWR 0.46804f
C32 a_112_47# VPWR 0.08916f
C33 B VPWR 0.13042f
C34 a_470_297# A 0.02856f
C35 a_470_47# VPB 0
C36 a_27_297# VPB 0.00985f
C37 a_112_47# A 0.38093f
C38 B A 0.31387f
C39 a_470_47# VPWR 0
C40 a_27_297# VPWR 0.34211f
C41 a_470_47# A 0.10609f
C42 a_27_297# A 0.02937f
C43 VGND VNB 0.71645f
C44 X VNB 0.07126f
C45 VPWR VNB 0.55256f
C46 B VNB 0.3851f
C47 A VNB 0.39149f
C48 VPB VNB 1.22494f
C49 a_470_47# VNB 0.01853f
C50 a_470_297# VNB 0.02289f
C51 a_27_297# VNB 0.02117f
C52 a_112_47# VNB 0.28506f
.ends

.subckt pmu VGND VPWR clk delay_sel[0] delay_sel[1] delay_sel[2] path[0] path[1] path[2]
+ path[3] path[4] path[5] path[6] path[7] path_sel[0] path_sel[1] path_sel[2] rst
+ se tdi tdo
XPHY_EDGE_ROW_0_Left_12 VPWR VGND VPWR VGND sky130_fd_sc_hd__decap_3
Xdc_inst.x4.x10 VGND VPWR dc_inst.x4.net1 dc_inst.x4.net10 VPWR VGND dc_inst.x4.x10/a_27_47#
+ sky130_fd_sc_hd__buf_1
Xdc_inst.x1.x13 VGND VPWR dc_inst.x1.net13 dc_inst.x1.net12 VPWR VGND dc_inst.x1.x13/a_27_47#
+ sky130_fd_sc_hd__buf_1
XFILLER_0_57 VPWR VGND VPWR VGND sky130_fd_sc_hd__decap_3
Xdc_inst.x6.x8 VGND VPWR dc_inst.x6.net9 dc_inst.x6.net8 VPWR VGND dc_inst.x6.x8/a_27_47#
+ sky130_fd_sc_hd__buf_1
Xdc_inst.x3.x9 VGND VPWR dc_inst.x3.net10 dc_inst.x3.net9 VPWR VGND dc_inst.x3.x9/a_27_47#
+ sky130_fd_sc_hd__buf_1
Xdc_inst.x1.x14 VGND VPWR dc_inst.x1.net14 dc_inst.x1.net13 VPWR VGND dc_inst.x1.x14/a_27_47#
+ sky130_fd_sc_hd__buf_1
Xdc_inst.x4.x11 VGND VPWR dc_inst.x4.net11 dc_inst.x4.net1 VPWR VGND dc_inst.x4.x11/a_27_47#
+ sky130_fd_sc_hd__buf_1
Xdc_inst.x6.x9 VGND VPWR dc_inst.x6.net10 dc_inst.x6.net9 VPWR VGND dc_inst.x6.x9/a_27_47#
+ sky130_fd_sc_hd__buf_1
XPHY_EDGE_ROW_6_Right_6 VPWR VGND VPWR VGND sky130_fd_sc_hd__decap_3
XFILLER_6_35 VPWR VGND VPWR VGND sky130_fd_sc_hd__decap_3
Xdc_inst.x7.x20 VGND VPWR dc_inst.net7 dc_inst.x7.net19 VPWR VGND dc_inst.x7.x20/a_27_47#
+ sky130_fd_sc_hd__buf_1
Xdc_inst.x4.x12 VGND VPWR dc_inst.x4.net12 dc_inst.x4.net11 VPWR VGND dc_inst.x4.x12/a_27_47#
+ sky130_fd_sc_hd__buf_1
Xdc_inst.x1.x15 VGND VPWR dc_inst.x1.net15 dc_inst.x1.net14 VPWR VGND dc_inst.x1.x15/a_27_47#
+ sky130_fd_sc_hd__buf_1
Xdc_inst.x7.x10 VGND VPWR dc_inst.x7.net1 dc_inst.x7.net10 VPWR VGND dc_inst.x7.x10/a_27_47#
+ sky130_fd_sc_hd__buf_1
Xdc_inst.x1.x16 VGND VPWR dc_inst.x1.net16 dc_inst.x1.net15 VPWR VGND dc_inst.x1.x16/a_27_47#
+ sky130_fd_sc_hd__buf_1
Xdc_inst.x4.x13 VGND VPWR dc_inst.x4.net13 dc_inst.x4.net12 VPWR VGND dc_inst.x4.x13/a_27_47#
+ sky130_fd_sc_hd__buf_1
XPHY_EDGE_ROW_4_Left_16 VPWR VGND VPWR VGND sky130_fd_sc_hd__decap_3
Xdc_inst.x7.x11 VGND VPWR dc_inst.x7.net11 dc_inst.x7.net1 VPWR VGND dc_inst.x7.x11/a_27_47#
+ sky130_fd_sc_hd__buf_1
Xdc_inst.x4.x14 VGND VPWR dc_inst.x4.net14 dc_inst.x4.net13 VPWR VGND dc_inst.x4.x14/a_27_47#
+ sky130_fd_sc_hd__buf_1
Xdc_inst.x1.x1 VGND VPWR dc_inst.x1.net2 dc_inst.in VPWR VGND dc_inst.x1.x1/a_27_47#
+ sky130_fd_sc_hd__buf_1
Xdc_inst.x1.x17 VGND VPWR dc_inst.x1.net17 dc_inst.x1.net16 VPWR VGND dc_inst.x1.x17/a_27_47#
+ sky130_fd_sc_hd__buf_1
Xclkload0 VGND VPWR clknet_1_1__leaf_clk clkload0/X VPWR VGND clkload0/a_27_47# sky130_fd_sc_hd__clkbuf_4
Xdc_inst.x7.x12 VGND VPWR dc_inst.x7.net12 dc_inst.x7.net11 VPWR VGND dc_inst.x7.x12/a_27_47#
+ sky130_fd_sc_hd__buf_1
Xdc_inst.x4.x1 VGND VPWR dc_inst.x4.net2 dc_inst.net3 VPWR VGND dc_inst.x4.x1/a_27_47#
+ sky130_fd_sc_hd__buf_1
Xdc_inst.x1.x18 VGND VPWR dc_inst.x1.net18 dc_inst.x1.net17 VPWR VGND dc_inst.x1.x18/a_27_47#
+ sky130_fd_sc_hd__buf_1
Xdc_inst.x4.x15 VGND VPWR dc_inst.x4.net15 dc_inst.x4.net14 VPWR VGND dc_inst.x4.x15/a_27_47#
+ sky130_fd_sc_hd__buf_1
Xdc_inst.x1.x2 VGND VPWR dc_inst.x1.net3 dc_inst.x1.net2 VPWR VGND dc_inst.x1.x2/a_27_47#
+ sky130_fd_sc_hd__buf_1
Xdc_inst.x7.x1 VGND VPWR dc_inst.x7.net2 dc_inst.net6 VPWR VGND dc_inst.x7.x1/a_27_47#
+ sky130_fd_sc_hd__buf_1
Xdc_inst.x7.x13 VGND VPWR dc_inst.x7.net13 dc_inst.x7.net12 VPWR VGND dc_inst.x7.x13/a_27_47#
+ sky130_fd_sc_hd__buf_1
Xdc_inst.x4.x2 VGND VPWR dc_inst.x4.net3 dc_inst.x4.net2 VPWR VGND dc_inst.x4.x2/a_27_47#
+ sky130_fd_sc_hd__buf_1
Xdc_inst.x4.x16 VGND VPWR dc_inst.x4.net16 dc_inst.x4.net15 VPWR VGND dc_inst.x4.x16/a_27_47#
+ sky130_fd_sc_hd__buf_1
Xdc_inst.x1.x3 VGND VPWR dc_inst.x1.net4 dc_inst.x1.net3 VPWR VGND dc_inst.x1.x3/a_27_47#
+ sky130_fd_sc_hd__buf_1
Xdc_inst.x1.x19 VGND VPWR dc_inst.x1.net19 dc_inst.x1.net18 VPWR VGND dc_inst.x1.x19/a_27_47#
+ sky130_fd_sc_hd__buf_1
Xdc_inst.x7.x2 VGND VPWR dc_inst.x7.net3 dc_inst.x7.net2 VPWR VGND dc_inst.x7.x2/a_27_47#
+ sky130_fd_sc_hd__buf_1
Xdc_inst.x7.x14 VGND VPWR dc_inst.x7.net14 dc_inst.x7.net13 VPWR VGND dc_inst.x7.x14/a_27_47#
+ sky130_fd_sc_hd__buf_1
XPHY_EDGE_ROW_1_Right_1 VPWR VGND VPWR VGND sky130_fd_sc_hd__decap_3
Xdc_inst.x4.x3 VGND VPWR dc_inst.x4.net4 dc_inst.x4.net3 VPWR VGND dc_inst.x4.x3/a_27_47#
+ sky130_fd_sc_hd__buf_1
Xdc_inst.x4.x17 VGND VPWR dc_inst.x4.net17 dc_inst.x4.net16 VPWR VGND dc_inst.x4.x17/a_27_47#
+ sky130_fd_sc_hd__buf_1
Xdc_inst.x1.x4 VGND VPWR dc_inst.x1.net5 dc_inst.x1.net4 VPWR VGND dc_inst.x1.x4/a_27_47#
+ sky130_fd_sc_hd__buf_1
XPHY_EDGE_ROW_11_Left_23 VPWR VGND VPWR VGND sky130_fd_sc_hd__decap_3
X_25_ VGND VPWR VPWR VGND clknet_1_0__leaf_clk _00_ _03_ tdo _25_/a_1462_47# _25_/a_543_47#
+ _25_/a_651_413# _25_/a_193_47# _25_/a_805_47# _25_/a_448_47# _25_/a_639_47# _25_/a_1283_21#
+ _25_/a_761_289# _25_/a_1108_47# _25_/a_1217_47# _25_/a_1270_413# _25_/a_27_47# sky130_fd_sc_hd__dfrtp_2
Xdc_inst.x7.x3 VGND VPWR dc_inst.x7.net4 dc_inst.x7.net3 VPWR VGND dc_inst.x7.x3/a_27_47#
+ sky130_fd_sc_hd__buf_1
Xclkbuf_0_clk VGND VPWR VGND VPWR clk clknet_0_clk clkbuf_0_clk/a_110_47# sky130_fd_sc_hd__clkbuf_16
Xdc_inst.x7.x15 VGND VPWR dc_inst.x7.net15 dc_inst.x7.net14 VPWR VGND dc_inst.x7.x15/a_27_47#
+ sky130_fd_sc_hd__buf_1
Xdc_inst.x4.x4 VGND VPWR dc_inst.x4.net5 dc_inst.x4.net4 VPWR VGND dc_inst.x4.x4/a_27_47#
+ sky130_fd_sc_hd__buf_1
Xdc_inst.x1.x5 VGND VPWR dc_inst.x1.net6 dc_inst.x1.net5 VPWR VGND dc_inst.x1.x5/a_27_47#
+ sky130_fd_sc_hd__buf_1
Xdc_inst.x4.x18 VGND VPWR dc_inst.x4.net18 dc_inst.x4.net17 VPWR VGND dc_inst.x4.x18/a_27_47#
+ sky130_fd_sc_hd__buf_1
X_24_ VGND VPWR VPWR VGND clknet_1_1__leaf_clk capture_d _02_ capture_q _24_/a_1462_47#
+ _24_/a_543_47# _24_/a_651_413# _24_/a_193_47# _24_/a_805_47# _24_/a_448_47# _24_/a_639_47#
+ _24_/a_1283_21# _24_/a_761_289# _24_/a_1108_47# _24_/a_1217_47# _24_/a_1270_413#
+ _24_/a_27_47# sky130_fd_sc_hd__dfrtp_2
Xdc_inst.x7.x4 VGND VPWR dc_inst.x7.net5 dc_inst.x7.net4 VPWR VGND dc_inst.x7.x4/a_27_47#
+ sky130_fd_sc_hd__buf_1
Xdc_inst.x7.x16 VGND VPWR dc_inst.x7.net16 dc_inst.x7.net15 VPWR VGND dc_inst.x7.x16/a_27_47#
+ sky130_fd_sc_hd__buf_1
Xdc_inst.x4.x19 VGND VPWR dc_inst.x4.net19 dc_inst.x4.net18 VPWR VGND dc_inst.x4.x19/a_27_47#
+ sky130_fd_sc_hd__buf_1
Xdc_inst.x4.x5 VGND VPWR dc_inst.x4.net6 dc_inst.x4.net5 VPWR VGND dc_inst.x4.x5/a_27_47#
+ sky130_fd_sc_hd__buf_1
Xdc_inst.x1.x6 VGND VPWR dc_inst.x1.net7 dc_inst.x1.net6 VPWR VGND dc_inst.x1.x6/a_27_47#
+ sky130_fd_sc_hd__buf_1
X_23_ VGND VPWR VPWR VGND clknet_1_0__leaf_clk dc_inst.in _01_ shadow_q _23_/a_1462_47#
+ _23_/a_543_47# _23_/a_651_413# _23_/a_193_47# _23_/a_805_47# _23_/a_448_47# _23_/a_639_47#
+ _23_/a_1283_21# _23_/a_761_289# _23_/a_1108_47# _23_/a_1217_47# _23_/a_1270_413#
+ _23_/a_27_47# sky130_fd_sc_hd__dfrtp_2
Xdc_inst.x7.x5 VGND VPWR dc_inst.x7.net6 dc_inst.x7.net5 VPWR VGND dc_inst.x7.x5/a_27_47#
+ sky130_fd_sc_hd__buf_1
Xdc_inst.x7.x17 VGND VPWR dc_inst.x7.net17 dc_inst.x7.net16 VPWR VGND dc_inst.x7.x17/a_27_47#
+ sky130_fd_sc_hd__buf_1
XPHY_EDGE_ROW_5_Right_5 VPWR VGND VPWR VGND sky130_fd_sc_hd__decap_3
Xdc_inst.x4.x6 VGND VPWR dc_inst.x4.net7 dc_inst.x4.net6 VPWR VGND dc_inst.x4.x6/a_27_47#
+ sky130_fd_sc_hd__buf_1
Xdc_inst.x3.x20 VPWR VGND dc_inst.net3 dc_inst.x3.net19 VPWR VGND dc_inst.x3.x20/a_27_47#
+ sky130_fd_sc_hd__buf_2
Xdc_inst.x1.x7 VGND VPWR dc_inst.x1.net8 dc_inst.x1.net7 VPWR VGND dc_inst.x1.x7/a_27_47#
+ sky130_fd_sc_hd__buf_1
X_22_ rst _03_ VPWR VGND VPWR VGND sky130_fd_sc_hd__inv_2
Xdc_inst.x7.x6 VGND VPWR dc_inst.x7.net7 dc_inst.x7.net6 VPWR VGND dc_inst.x7.x6/a_27_47#
+ sky130_fd_sc_hd__buf_1
XPHY_EDGE_ROW_11_Right_11 VPWR VGND VPWR VGND sky130_fd_sc_hd__decap_3
Xdc_inst.x3.x10 VGND VPWR dc_inst.x3.net1 dc_inst.x3.net10 VPWR VGND dc_inst.x3.x10/a_27_47#
+ sky130_fd_sc_hd__buf_1
Xdc_inst.x7.x18 VGND VPWR dc_inst.x7.net18 dc_inst.x7.net17 VPWR VGND dc_inst.x7.x18/a_27_47#
+ sky130_fd_sc_hd__buf_1
Xdc_inst.x4.x7 VGND VPWR dc_inst.x4.net8 dc_inst.x4.net7 VPWR VGND dc_inst.x4.x7/a_27_47#
+ sky130_fd_sc_hd__buf_1
Xdc_inst.x8 VGND VPWR VGND VPWR dc_inst.net1 dc_inst.in delay_sel[0] dc_inst.net3
+ dc_inst.net2 delay_sel[1] dc_inst.net8 dc_inst.x8/a_1290_413# dc_inst.x8/a_757_363#
+ dc_inst.x8/a_1478_413# dc_inst.x8/a_277_47# dc_inst.x8/a_750_97# dc_inst.x8/a_27_413#
+ dc_inst.x8/a_923_363# dc_inst.x8/a_193_47# dc_inst.x8/a_834_97# dc_inst.x8/a_247_21#
+ dc_inst.x8/a_668_97# dc_inst.x8/a_193_413# dc_inst.x8/a_27_47# sky130_fd_sc_hd__mux4_1
Xdc_inst.x1.x8 VGND VPWR dc_inst.x1.net9 dc_inst.x1.net8 VPWR VGND dc_inst.x1.x8/a_27_47#
+ sky130_fd_sc_hd__buf_1
X_21_ rst _02_ VPWR VGND VPWR VGND sky130_fd_sc_hd__inv_2
Xdc_inst.x7.x7 VGND VPWR dc_inst.x7.net8 dc_inst.x7.net7 VPWR VGND dc_inst.x7.x7/a_27_47#
+ sky130_fd_sc_hd__buf_1
XPHY_EDGE_ROW_3_Left_15 VPWR VGND VPWR VGND sky130_fd_sc_hd__decap_3
Xdc_inst.x7.x19 VGND VPWR dc_inst.x7.net19 dc_inst.x7.net18 VPWR VGND dc_inst.x7.x19/a_27_47#
+ sky130_fd_sc_hd__buf_1
Xdc_inst.x4.x8 VGND VPWR dc_inst.x4.net9 dc_inst.x4.net8 VPWR VGND dc_inst.x4.x8/a_27_47#
+ sky130_fd_sc_hd__buf_1
Xdc_inst.x3.x11 VGND VPWR dc_inst.x3.net11 dc_inst.x3.net1 VPWR VGND dc_inst.x3.x11/a_27_47#
+ sky130_fd_sc_hd__buf_1
Xdc_inst.x9 VGND VPWR VGND VPWR dc_inst.net5 dc_inst.net4 delay_sel[0] dc_inst.net7
+ dc_inst.net6 delay_sel[1] dc_inst.net9 dc_inst.x9/a_1290_413# dc_inst.x9/a_757_363#
+ dc_inst.x9/a_1478_413# dc_inst.x9/a_277_47# dc_inst.x9/a_750_97# dc_inst.x9/a_27_413#
+ dc_inst.x9/a_923_363# dc_inst.x9/a_193_47# dc_inst.x9/a_834_97# dc_inst.x9/a_247_21#
+ dc_inst.x9/a_668_97# dc_inst.x9/a_193_413# dc_inst.x9/a_27_47# sky130_fd_sc_hd__mux4_1
Xdc_inst.x1.x9 VGND VPWR dc_inst.x1.net10 dc_inst.x1.net9 VPWR VGND dc_inst.x1.x9/a_27_47#
+ sky130_fd_sc_hd__buf_1
X_20_ VGND VPWR VGND VPWR dc_inst.in _10_ _06_ _04_ _20_/a_384_47# _20_/a_470_297#
+ _20_/a_79_21# sky130_fd_sc_hd__o21a_2
Xdc_inst.x7.x8 VGND VPWR dc_inst.x7.net9 dc_inst.x7.net8 VPWR VGND dc_inst.x7.x8/a_27_47#
+ sky130_fd_sc_hd__buf_1
XFILLER_1_57 VPWR VGND VPWR VGND sky130_fd_sc_hd__decap_3
XPHY_EDGE_ROW_9_Right_9 VPWR VGND VPWR VGND sky130_fd_sc_hd__decap_3
Xdc_inst.x3.x12 VGND VPWR dc_inst.x3.net12 dc_inst.x3.net11 VPWR VGND dc_inst.x3.x12/a_27_47#
+ sky130_fd_sc_hd__buf_1
Xdc_inst.x6.x20 VPWR VGND dc_inst.net6 dc_inst.x6.net19 VPWR VGND dc_inst.x6.x20/a_27_47#
+ sky130_fd_sc_hd__buf_2
Xdc_inst.x4.x9 VGND VPWR dc_inst.x4.net10 dc_inst.x4.net9 VPWR VGND dc_inst.x4.x9/a_27_47#
+ sky130_fd_sc_hd__buf_1
Xdc_inst.x7.x9 VGND VPWR dc_inst.x7.net10 dc_inst.x7.net9 VPWR VGND dc_inst.x7.x9/a_27_47#
+ sky130_fd_sc_hd__buf_1
Xdc_inst.x3.x13 VGND VPWR dc_inst.x3.net13 dc_inst.x3.net12 VPWR VGND dc_inst.x3.x13/a_27_47#
+ sky130_fd_sc_hd__buf_1
Xdc_inst.x6.x10 VGND VPWR dc_inst.x6.net1 dc_inst.x6.net10 VPWR VGND dc_inst.x6.x10/a_27_47#
+ sky130_fd_sc_hd__buf_1
XPHY_EDGE_ROW_7_Left_19 VPWR VGND VPWR VGND sky130_fd_sc_hd__decap_3
XPHY_EDGE_ROW_0_Right_0 VPWR VGND VPWR VGND sky130_fd_sc_hd__decap_3
Xdc_inst.x6.x11 VGND VPWR dc_inst.x6.net11 dc_inst.x6.net1 VPWR VGND dc_inst.x6.x11/a_27_47#
+ sky130_fd_sc_hd__buf_1
Xdc_inst.x3.x14 VGND VPWR dc_inst.x3.net14 dc_inst.x3.net13 VPWR VGND dc_inst.x3.x14/a_27_47#
+ sky130_fd_sc_hd__buf_1
XPHY_EDGE_ROW_10_Left_22 VPWR VGND VPWR VGND sky130_fd_sc_hd__decap_3
Xdc_inst.x3.x15 VGND VPWR dc_inst.x3.net15 dc_inst.x3.net14 VPWR VGND dc_inst.x3.x15/a_27_47#
+ sky130_fd_sc_hd__buf_1
Xdc_inst.x6.x12 VGND VPWR dc_inst.x6.net12 dc_inst.x6.net11 VPWR VGND dc_inst.x6.x12/a_27_47#
+ sky130_fd_sc_hd__buf_1
Xdc_inst.x2.x1 VGND VPWR dc_inst.x2.net2 dc_inst.net1 VPWR VGND dc_inst.x2.x1/a_27_47#
+ sky130_fd_sc_hd__buf_1
Xdc_inst.x6.x13 VGND VPWR dc_inst.x6.net13 dc_inst.x6.net12 VPWR VGND dc_inst.x6.x13/a_27_47#
+ sky130_fd_sc_hd__buf_1
Xdc_inst.x3.x16 VGND VPWR dc_inst.x3.net16 dc_inst.x3.net15 VPWR VGND dc_inst.x3.x16/a_27_47#
+ sky130_fd_sc_hd__buf_1
Xdc_inst.x5.x1 VGND VPWR dc_inst.x5.net2 dc_inst.net4 VPWR VGND dc_inst.x5.x1/a_27_47#
+ sky130_fd_sc_hd__buf_1
Xdc_inst.x2.x2 VGND VPWR dc_inst.x2.net3 dc_inst.x2.net2 VPWR VGND dc_inst.x2.x2/a_27_47#
+ sky130_fd_sc_hd__buf_1
Xdc_inst.x3.x17 VGND VPWR dc_inst.x3.net17 dc_inst.x3.net16 VPWR VGND dc_inst.x3.x17/a_27_47#
+ sky130_fd_sc_hd__buf_1
XPHY_EDGE_ROW_4_Right_4 VPWR VGND VPWR VGND sky130_fd_sc_hd__decap_3
Xdc_inst.x6.x14 VGND VPWR dc_inst.x6.net14 dc_inst.x6.net13 VPWR VGND dc_inst.x6.x14/a_27_47#
+ sky130_fd_sc_hd__buf_1
Xdc_inst.x5.x2 VGND VPWR dc_inst.x5.net3 dc_inst.x5.net2 VPWR VGND dc_inst.x5.x2/a_27_47#
+ sky130_fd_sc_hd__buf_1
Xdc_inst.x2.x3 VGND VPWR dc_inst.x2.net4 dc_inst.x2.net3 VPWR VGND dc_inst.x2.x3/a_27_47#
+ sky130_fd_sc_hd__buf_1
Xdc_inst.x6.x15 VGND VPWR dc_inst.x6.net15 dc_inst.x6.net14 VPWR VGND dc_inst.x6.x15/a_27_47#
+ sky130_fd_sc_hd__buf_1
Xdc_inst.x3.x18 VGND VPWR dc_inst.x3.net18 dc_inst.x3.net17 VPWR VGND dc_inst.x3.x18/a_27_47#
+ sky130_fd_sc_hd__buf_1
Xdc_inst.x5.x3 VGND VPWR dc_inst.x5.net4 dc_inst.x5.net3 VPWR VGND dc_inst.x5.x3/a_27_47#
+ sky130_fd_sc_hd__buf_1
Xdc_inst.x2.x4 VGND VPWR dc_inst.x2.net5 dc_inst.x2.net4 VPWR VGND dc_inst.x2.x4/a_27_47#
+ sky130_fd_sc_hd__buf_1
XPHY_EDGE_ROW_2_Left_14 VPWR VGND VPWR VGND sky130_fd_sc_hd__decap_3
Xclkbuf_1_0__f_clk VGND VPWR VGND VPWR clknet_0_clk clknet_1_0__leaf_clk clkbuf_1_0__f_clk/a_110_47#
+ sky130_fd_sc_hd__clkbuf_16
Xdc_inst.x3.x19 VGND VPWR dc_inst.x3.net19 dc_inst.x3.net18 VPWR VGND dc_inst.x3.x19/a_27_47#
+ sky130_fd_sc_hd__buf_1
Xdc_inst.x6.x16 VGND VPWR dc_inst.x6.net16 dc_inst.x6.net15 VPWR VGND dc_inst.x6.x16/a_27_47#
+ sky130_fd_sc_hd__buf_1
Xdc_inst.x5.x4 VGND VPWR dc_inst.x5.net5 dc_inst.x5.net4 VPWR VGND dc_inst.x5.x4/a_27_47#
+ sky130_fd_sc_hd__buf_1
Xdc_inst.x2.x5 VGND VPWR dc_inst.x2.net6 dc_inst.x2.net5 VPWR VGND dc_inst.x2.x5/a_27_47#
+ sky130_fd_sc_hd__buf_1
XPHY_EDGE_ROW_10_Right_10 VPWR VGND VPWR VGND sky130_fd_sc_hd__decap_3
Xdc_inst.x6.x17 VGND VPWR dc_inst.x6.net17 dc_inst.x6.net16 VPWR VGND dc_inst.x6.x17/a_27_47#
+ sky130_fd_sc_hd__buf_1
Xdc_inst.x2.x20 VPWR VGND dc_inst.net2 dc_inst.x2.net19 VPWR VGND dc_inst.x2.x20/a_27_47#
+ sky130_fd_sc_hd__buf_2
Xdc_inst.x5.x5 VGND VPWR dc_inst.x5.net6 dc_inst.x5.net5 VPWR VGND dc_inst.x5.x5/a_27_47#
+ sky130_fd_sc_hd__buf_1
XPHY_EDGE_ROW_8_Right_8 VPWR VGND VPWR VGND sky130_fd_sc_hd__decap_3
XFILLER_5_31 VPWR VGND VPWR VGND sky130_fd_sc_hd__decap_3
Xdc_inst.x2.x6 VGND VPWR dc_inst.x2.net7 dc_inst.x2.net6 VPWR VGND dc_inst.x2.x6/a_27_47#
+ sky130_fd_sc_hd__buf_1
Xdc_inst.x6.x18 VGND VPWR dc_inst.x6.net18 dc_inst.x6.net17 VPWR VGND dc_inst.x6.x18/a_27_47#
+ sky130_fd_sc_hd__buf_1
Xdc_inst.x2.x10 VGND VPWR dc_inst.x2.net1 dc_inst.x2.net10 VPWR VGND dc_inst.x2.x10/a_27_47#
+ sky130_fd_sc_hd__buf_1
Xdc_inst.x5.x6 VGND VPWR dc_inst.x5.net7 dc_inst.x5.net6 VPWR VGND dc_inst.x5.x6/a_27_47#
+ sky130_fd_sc_hd__buf_1
Xdc_inst.x2.x7 VGND VPWR dc_inst.x2.net8 dc_inst.x2.net7 VPWR VGND dc_inst.x2.x7/a_27_47#
+ sky130_fd_sc_hd__buf_1
Xdc_inst.x6.x19 VGND VPWR dc_inst.x6.net19 dc_inst.x6.net18 VPWR VGND dc_inst.x6.x19/a_27_47#
+ sky130_fd_sc_hd__buf_1
XPHY_EDGE_ROW_6_Left_18 VPWR VGND VPWR VGND sky130_fd_sc_hd__decap_3
X_19_ VPWR VGND VPWR VGND path_sel[2] path_sel[1] _09_ _07_ _08_ _10_ _19_/a_193_297#
+ _19_/a_465_47# _19_/a_205_47# _19_/a_109_297# _19_/a_27_47# sky130_fd_sc_hd__a221o_2
Xdc_inst.x5.x7 VGND VPWR dc_inst.x5.net8 dc_inst.x5.net7 VPWR VGND dc_inst.x5.x7/a_27_47#
+ sky130_fd_sc_hd__buf_1
Xdc_inst.x2.x11 VGND VPWR dc_inst.x2.net11 dc_inst.x2.net1 VPWR VGND dc_inst.x2.x11/a_27_47#
+ sky130_fd_sc_hd__buf_1
XPHY_EDGE_ROW_9_Left_21 VPWR VGND VPWR VGND sky130_fd_sc_hd__decap_3
Xdc_inst.x2.x8 VGND VPWR dc_inst.x2.net9 dc_inst.x2.net8 VPWR VGND dc_inst.x2.x8/a_27_47#
+ sky130_fd_sc_hd__buf_1
Xdc_inst.x5.x20 VPWR VGND dc_inst.net5 dc_inst.x5.net19 VPWR VGND dc_inst.x5.x20/a_27_47#
+ sky130_fd_sc_hd__buf_2
Xdc_inst.x5.x8 VGND VPWR dc_inst.x5.net9 dc_inst.x5.net8 VPWR VGND dc_inst.x5.x8/a_27_47#
+ sky130_fd_sc_hd__buf_1
Xdc_inst.x2.x12 VGND VPWR dc_inst.x2.net12 dc_inst.x2.net11 VPWR VGND dc_inst.x2.x12/a_27_47#
+ sky130_fd_sc_hd__buf_1
X_18_ VGND VPWR VPWR VGND _09_ path[3] path_sel[0] path[2] _18_/a_505_21# _18_/a_535_374#
+ _18_/a_439_47# _18_/a_218_47# _18_/a_76_199# _18_/a_218_374# sky130_fd_sc_hd__mux2_1
Xdc_inst.x2.x9 VGND VPWR dc_inst.x2.net10 dc_inst.x2.net9 VPWR VGND dc_inst.x2.x9/a_27_47#
+ sky130_fd_sc_hd__buf_1
Xdc_inst.x5.x10 VGND VPWR dc_inst.x5.net1 dc_inst.x5.net10 VPWR VGND dc_inst.x5.x10/a_27_47#
+ sky130_fd_sc_hd__buf_1
Xdc_inst.x5.x9 VGND VPWR dc_inst.x5.net10 dc_inst.x5.net9 VPWR VGND dc_inst.x5.x9/a_27_47#
+ sky130_fd_sc_hd__buf_1
X_17_ VGND VPWR VGND VPWR path_sel[0] path[0] path_sel[1] _08_ _17_/a_478_47# _17_/a_27_93#
+ _17_/a_574_297# _17_/a_174_21# sky130_fd_sc_hd__o21ba_2
Xdc_inst.x2.x13 VGND VPWR dc_inst.x2.net13 dc_inst.x2.net12 VPWR VGND dc_inst.x2.x13/a_27_47#
+ sky130_fd_sc_hd__buf_1
Xdc_inst.x5.x11 VGND VPWR dc_inst.x5.net11 dc_inst.x5.net1 VPWR VGND dc_inst.x5.x11/a_27_47#
+ sky130_fd_sc_hd__buf_1
X_16_ VGND VPWR VGND VPWR path[1] _07_ path_sel[0] _16_/a_229_47# _16_/a_27_93# sky130_fd_sc_hd__nand2b_2
Xdc_inst.x2.x14 VGND VPWR dc_inst.x2.net14 dc_inst.x2.net13 VPWR VGND dc_inst.x2.x14/a_27_47#
+ sky130_fd_sc_hd__buf_1
Xclkbuf_1_1__f_clk VGND VPWR VGND VPWR clknet_0_clk clknet_1_1__leaf_clk clkbuf_1_1__f_clk/a_110_47#
+ sky130_fd_sc_hd__clkbuf_16
XPHY_EDGE_ROW_3_Right_3 VPWR VGND VPWR VGND sky130_fd_sc_hd__decap_3
X_15_ VGND VPWR VGND VPWR path_sel[0] path[6] path[7] path_sel[1] path[5] path[4]
+ _06_ _15_/a_193_369# _15_/a_372_413# _15_/a_1281_47# _15_/a_193_47# _15_/a_1064_47#
+ _15_/a_1060_369# _15_/a_288_47# _15_/a_397_47# _15_/a_872_316# _15_/a_1279_413#
+ _15_/a_788_316# _15_/a_600_345# _15_/a_27_47# sky130_fd_sc_hd__mux4_2
Xdc_inst.x2.x15 VGND VPWR dc_inst.x2.net15 dc_inst.x2.net14 VPWR VGND dc_inst.x2.x15/a_27_47#
+ sky130_fd_sc_hd__buf_1
Xdc_inst.x5.x12 VGND VPWR dc_inst.x5.net12 dc_inst.x5.net11 VPWR VGND dc_inst.x5.x12/a_27_47#
+ sky130_fd_sc_hd__buf_1
XPHY_EDGE_ROW_1_Left_13 VPWR VGND VPWR VGND sky130_fd_sc_hd__decap_3
Xdc_inst.x5.x13 VGND VPWR dc_inst.x5.net13 dc_inst.x5.net12 VPWR VGND dc_inst.x5.x13/a_27_47#
+ sky130_fd_sc_hd__buf_1
X_14_ VGND VPWR VPWR VGND _00_ tdi se _05_ _14_/a_505_21# _14_/a_535_374# _14_/a_439_47#
+ _14_/a_218_47# _14_/a_76_199# _14_/a_218_374# sky130_fd_sc_hd__mux2_1
Xdc_inst.x2.x16 VGND VPWR dc_inst.x2.net16 dc_inst.x2.net15 VPWR VGND dc_inst.x2.x16/a_27_47#
+ sky130_fd_sc_hd__buf_1
Xdc_inst.x3.x1 VGND VPWR dc_inst.x3.net2 dc_inst.net2 VPWR VGND dc_inst.x3.x1/a_27_47#
+ sky130_fd_sc_hd__buf_1
Xdc_inst.x10 VGND VPWR VPWR VGND capture_d dc_inst.net9 delay_sel[2] dc_inst.net8
+ dc_inst.x10/a_505_21# dc_inst.x10/a_535_374# dc_inst.x10/a_439_47# dc_inst.x10/a_218_47#
+ dc_inst.x10/a_76_199# dc_inst.x10/a_218_374# sky130_fd_sc_hd__mux2_1
Xdc_inst.x5.x14 VGND VPWR dc_inst.x5.net14 dc_inst.x5.net13 VPWR VGND dc_inst.x5.x14/a_27_47#
+ sky130_fd_sc_hd__buf_1
X_13_ VPWR VGND _05_ shadow_q capture_q VPWR VGND _13_/a_470_47# _13_/a_27_297# _13_/a_470_297#
+ _13_/a_112_47# sky130_fd_sc_hd__xor2_2
Xdc_inst.x6.x1 VGND VPWR dc_inst.x6.net2 dc_inst.net5 VPWR VGND dc_inst.x6.x1/a_27_47#
+ sky130_fd_sc_hd__buf_1
Xdc_inst.x2.x17 VGND VPWR dc_inst.x2.net17 dc_inst.x2.net16 VPWR VGND dc_inst.x2.x17/a_27_47#
+ sky130_fd_sc_hd__buf_1
XPHY_EDGE_ROW_7_Right_7 VPWR VGND VPWR VGND sky130_fd_sc_hd__decap_3
Xdc_inst.x3.x2 VGND VPWR dc_inst.x3.net3 dc_inst.x3.net2 VPWR VGND dc_inst.x3.x2/a_27_47#
+ sky130_fd_sc_hd__buf_1
X_12_ rst _01_ VPWR VGND VPWR VGND sky130_fd_sc_hd__inv_2
Xdc_inst.x2.x18 VGND VPWR dc_inst.x2.net18 dc_inst.x2.net17 VPWR VGND dc_inst.x2.x18/a_27_47#
+ sky130_fd_sc_hd__buf_1
Xdc_inst.x5.x15 VGND VPWR dc_inst.x5.net15 dc_inst.x5.net14 VPWR VGND dc_inst.x5.x15/a_27_47#
+ sky130_fd_sc_hd__buf_1
Xdc_inst.x6.x2 VGND VPWR dc_inst.x6.net3 dc_inst.x6.net2 VPWR VGND dc_inst.x6.x2/a_27_47#
+ sky130_fd_sc_hd__buf_1
Xdc_inst.x3.x3 VGND VPWR dc_inst.x3.net4 dc_inst.x3.net3 VPWR VGND dc_inst.x3.x3/a_27_47#
+ sky130_fd_sc_hd__buf_1
XPHY_EDGE_ROW_5_Left_17 VPWR VGND VPWR VGND sky130_fd_sc_hd__decap_3
Xdc_inst.x5.x16 VGND VPWR dc_inst.x5.net16 dc_inst.x5.net15 VPWR VGND dc_inst.x5.x16/a_27_47#
+ sky130_fd_sc_hd__buf_1
Xdc_inst.x2.x19 VGND VPWR dc_inst.x2.net19 dc_inst.x2.net18 VPWR VGND dc_inst.x2.x19/a_27_47#
+ sky130_fd_sc_hd__buf_1
X_11_ path_sel[2] _04_ VPWR VGND VPWR VGND sky130_fd_sc_hd__inv_2
XPHY_EDGE_ROW_8_Left_20 VPWR VGND VPWR VGND sky130_fd_sc_hd__decap_3
Xdc_inst.x6.x3 VGND VPWR dc_inst.x6.net4 dc_inst.x6.net3 VPWR VGND dc_inst.x6.x3/a_27_47#
+ sky130_fd_sc_hd__buf_1
Xdc_inst.x3.x4 VGND VPWR dc_inst.x3.net5 dc_inst.x3.net4 VPWR VGND dc_inst.x3.x4/a_27_47#
+ sky130_fd_sc_hd__buf_1
Xdc_inst.x1.x20 VPWR VGND dc_inst.net1 dc_inst.x1.net19 VPWR VGND dc_inst.x1.x20/a_27_47#
+ sky130_fd_sc_hd__buf_2
Xdc_inst.x5.x17 VGND VPWR dc_inst.x5.net17 dc_inst.x5.net16 VPWR VGND dc_inst.x5.x17/a_27_47#
+ sky130_fd_sc_hd__buf_1
Xdc_inst.x6.x4 VGND VPWR dc_inst.x6.net5 dc_inst.x6.net4 VPWR VGND dc_inst.x6.x4/a_27_47#
+ sky130_fd_sc_hd__buf_1
XFILLER_0_53 VPWR VGND VPWR VGND sky130_fd_sc_hd__decap_3
Xdc_inst.x3.x5 VGND VPWR dc_inst.x3.net6 dc_inst.x3.net5 VPWR VGND dc_inst.x3.x5/a_27_47#
+ sky130_fd_sc_hd__buf_1
Xdc_inst.x5.x18 VGND VPWR dc_inst.x5.net18 dc_inst.x5.net17 VPWR VGND dc_inst.x5.x18/a_27_47#
+ sky130_fd_sc_hd__buf_1
Xdc_inst.x1.x10 VGND VPWR dc_inst.x1.net1 dc_inst.x1.net10 VPWR VGND dc_inst.x1.x10/a_27_47#
+ sky130_fd_sc_hd__buf_1
Xdc_inst.x6.x5 VGND VPWR dc_inst.x6.net6 dc_inst.x6.net5 VPWR VGND dc_inst.x6.x5/a_27_47#
+ sky130_fd_sc_hd__buf_1
Xdc_inst.x3.x6 VGND VPWR dc_inst.x3.net7 dc_inst.x3.net6 VPWR VGND dc_inst.x3.x6/a_27_47#
+ sky130_fd_sc_hd__buf_1
Xdc_inst.x1.x11 VGND VPWR dc_inst.x1.net11 dc_inst.x1.net1 VPWR VGND dc_inst.x1.x11/a_27_47#
+ sky130_fd_sc_hd__buf_1
Xdc_inst.x5.x19 VGND VPWR dc_inst.x5.net19 dc_inst.x5.net18 VPWR VGND dc_inst.x5.x19/a_27_47#
+ sky130_fd_sc_hd__buf_1
Xdc_inst.x6.x6 VGND VPWR dc_inst.x6.net7 dc_inst.x6.net6 VPWR VGND dc_inst.x6.x6/a_27_47#
+ sky130_fd_sc_hd__buf_1
Xdc_inst.x3.x7 VGND VPWR dc_inst.x3.net8 dc_inst.x3.net7 VPWR VGND dc_inst.x3.x7/a_27_47#
+ sky130_fd_sc_hd__buf_1
XFILLER_6_32 VPWR VGND VPWR VGND sky130_fd_sc_hd__decap_3
XPHY_EDGE_ROW_2_Right_2 VPWR VGND VPWR VGND sky130_fd_sc_hd__decap_3
Xdc_inst.x1.x12 VGND VPWR dc_inst.x1.net12 dc_inst.x1.net11 VPWR VGND dc_inst.x1.x12/a_27_47#
+ sky130_fd_sc_hd__buf_1
Xdc_inst.x4.x20 VPWR VGND dc_inst.net4 dc_inst.x4.net19 VPWR VGND dc_inst.x4.x20/a_27_47#
+ sky130_fd_sc_hd__buf_2
Xdc_inst.x6.x7 VGND VPWR dc_inst.x6.net8 dc_inst.x6.net7 VPWR VGND dc_inst.x6.x7/a_27_47#
+ sky130_fd_sc_hd__buf_1
Xdc_inst.x3.x8 VGND VPWR dc_inst.x3.net9 dc_inst.x3.net8 VPWR VGND dc_inst.x3.x8/a_27_47#
+ sky130_fd_sc_hd__buf_1
C0 tdo _00_ 0.05476f
C1 dc_inst.x3.net7 rst 0
C2 dc_inst.x1.net1 _18_/a_76_199# 0.00214f
C3 dc_inst.x5.net6 dc_inst.x6.x14/a_27_47# 0
C4 dc_inst.x7.net4 dc_inst.x4.net3 0.00132f
C5 dc_inst.x5.net7 dc_inst.x2.net12 0
C6 dc_inst.x2.net15 path_sel[2] 0.03093f
C7 dc_inst.net2 _15_/a_872_316# 0
C8 dc_inst.x7.net4 _23_/a_1283_21# 0.00196f
C9 dc_inst.x3.x5/a_27_47# _02_ 0
C10 dc_inst.x4.x15/a_27_47# dc_inst.x4.x20/a_27_47# 0
C11 path[5] _02_ 0.00774f
C12 dc_inst.x3.net16 dc_inst.x8/a_277_47# 0
C13 dc_inst.x2.net14 dc_inst.x2.net4 0
C14 dc_inst.x5.x5/a_27_47# dc_inst.x5.x7/a_27_47# 0
C15 dc_inst.x4.x9/a_27_47# dc_inst.x4.net10 0.01506f
C16 dc_inst.x4.net2 dc_inst.x4.x3/a_27_47# 0.00297f
C17 tdo clknet_1_0__leaf_clk 0.00744f
C18 path_sel[1] _09_ 0.02114f
C19 dc_inst.x6.x12/a_27_47# dc_inst.x1.net19 0
C20 dc_inst.x1.net6 _18_/a_505_21# 0
C21 dc_inst.x4.net3 dc_inst.net1 0
C22 _15_/a_788_316# dc_inst.x3.net12 0
C23 dc_inst.x4.net6 dc_inst.x6.net16 0
C24 dc_inst.in dc_inst.x8/a_277_47# 0.01046f
C25 dc_inst.x4.net1 dc_inst.x4.net12 0
C26 dc_inst.x4.net1 dc_inst.x2.x7/a_27_47# 0
C27 dc_inst.x2.x2/a_27_47# dc_inst.x4.x7/a_27_47# 0.08729f
C28 dc_inst.x3.net6 dc_inst.x3.x13/a_27_47# 0.02951f
C29 dc_inst.x8/a_193_413# dc_inst.net9 0
C30 delay_sel[2] dc_inst.x3.net3 0
C31 dc_inst.x4.net13 dc_inst.x4.x10/a_27_47# 0
C32 dc_inst.x2.x15/a_27_47# dc_inst.x2.net12 0.00104f
C33 dc_inst.x1.net8 dc_inst.in 0.02782f
C34 dc_inst.x6.net17 dc_inst.x6.net2 0.0046f
C35 dc_inst.x9/a_668_97# dc_inst.x7.net1 0.00146f
C36 dc_inst.x1.net9 dc_inst.x1.net19 0
C37 VPWR dc_inst.x3.net16 0.32183f
C38 dc_inst.x4.net13 dc_inst.x4.net16 0.06707f
C39 path[2] _18_/a_505_21# 0.01266f
C40 dc_inst.x2.net4 dc_inst.x2.x8/a_27_47# 0
C41 _15_/a_193_47# path[7] 0
C42 dc_inst.x3.net2 dc_inst.net8 0.13313f
C43 VPWR dc_inst.x4.x15/a_27_47# -0.00738f
C44 dc_inst.x5.net7 dc_inst.x2.net13 0
C45 dc_inst.x6.x3/a_27_47# dc_inst.x6.net3 0.04974f
C46 dc_inst.x3.net12 _14_/a_505_21# 0
C47 dc_inst.net3 dc_inst.x4.net2 0.00417f
C48 dc_inst.x6.net9 dc_inst.net5 0
C49 dc_inst.x7.net9 dc_inst.x7.x14/a_27_47# 0
C50 dc_inst.x7.net19 _25_/a_1283_21# 0
C51 dc_inst.net2 dc_inst.x8/a_247_21# -0.00142f
C52 VPWR dc_inst.in 0.81369f
C53 clknet_0_clk delay_sel[1] 0
C54 dc_inst.x4.net7 dc_inst.x5.net7 0.05027f
C55 path_sel[1] dc_inst.x1.x17/a_27_47# 0
C56 dc_inst.x7.net9 dc_inst.x7.net8 0.00417f
C57 dc_inst.x2.net7 dc_inst.x4.x14/a_27_47# 0
C58 dc_inst.x2.x5/a_27_47# dc_inst.x5.x3/a_27_47# 0
C59 dc_inst.x1.x7/a_27_47# _09_ 0
C60 dc_inst.net3 dc_inst.x3.x20/a_27_47# 0.00684f
C61 dc_inst.x4.net5 dc_inst.x6.net13 0
C62 dc_inst.x6.net9 path_sel[2] 0.0057f
C63 dc_inst.x6.net19 delay_sel[1] 0.00903f
C64 dc_inst.x1.x12/a_27_47# dc_inst.x1.net12 0.00238f
C65 _06_ dc_inst.x1.net3 0
C66 VPWR _23_/a_639_47# 0.00524f
C67 dc_inst.x3.net19 delay_sel[0] 0
C68 dc_inst.x6.net14 dc_inst.x9/a_1478_413# 0
C69 dc_inst.x5.x14/a_27_47# dc_inst.x5.net13 0.04698f
C70 dc_inst.x5.net6 dc_inst.x5.net7 0.17264f
C71 dc_inst.x2.x15/a_27_47# dc_inst.x2.net13 0.01151f
C72 dc_inst.x4.x6/a_27_47# dc_inst.x4.x8/a_27_47# 0.01224f
C73 dc_inst.x6.net12 dc_inst.x6.x12/a_27_47# 0.00883f
C74 _15_/a_1281_47# dc_inst.x1.net3 0
C75 dc_inst.x2.x16/a_27_47# dc_inst.x1.net14 0
C76 dc_inst.x6.x20/a_27_47# dc_inst.x6.net16 0
C77 dc_inst.x4.net14 dc_inst.x4.net8 0
C78 dc_inst.x1.x13/a_27_47# dc_inst.x1.x14/a_27_47# 0.02448f
C79 dc_inst.x3.x16/a_27_47# delay_sel[2] 0
C80 path_sel[1] dc_inst.x5.x10/a_27_47# 0.00492f
C81 dc_inst.x6.x14/a_27_47# path_sel[2] 0.01199f
C82 dc_inst.net5 dc_inst.x6.net15 0
C83 dc_inst.x6.net17 dc_inst.x6.x1/a_27_47# 0
C84 dc_inst.x8/a_193_413# dc_inst.x9/a_750_97# 0
C85 dc_inst.x8/a_27_413# dc_inst.x9/a_1290_413# 0
C86 _24_/a_1283_21# dc_inst.x8/a_277_47# 0
C87 dc_inst.x6.net18 dc_inst.x9/a_1478_413# 0
C88 dc_inst.x2.net15 dc_inst.x1.net17 0
C89 dc_inst.x1.net7 path[7] 0
C90 dc_inst.x1.net15 dc_inst.x1.net14 0.20071f
C91 dc_inst.x5.x14/a_27_47# dc_inst.x5.x2/a_27_47# 0
C92 dc_inst.x3.net16 dc_inst.x3.x5/a_27_47# 0
C93 dc_inst.x3.net16 path[5] 0
C94 dc_inst.x4.x15/a_27_47# dc_inst.x6.net6 0.0015f
C95 dc_inst.x5.net6 dc_inst.x2.x15/a_27_47# 0
C96 dc_inst.x6.net15 path_sel[2] 0.00675f
C97 dc_inst.net4 dc_inst.net7 0.0022f
C98 VPWR dc_inst.x6.net17 0.31693f
C99 dc_inst.x5.x14/a_27_47# dc_inst.x5.x16/a_27_47# 0
C100 dc_inst.x1.net10 _19_/a_109_297# 0
C101 path[0] path_sel[0] 0.11095f
C102 path[3] dc_inst.x1.net3 0
C103 dc_inst.x7.net16 dc_inst.net8 0
C104 dc_inst.x7.x1/a_27_47# dc_inst.x7.x5/a_27_47# 0.01018f
C105 dc_inst.x7.net4 _23_/a_27_47# 0
C106 dc_inst.x6.net14 dc_inst.x4.net7 0
C107 dc_inst.x5.net19 dc_inst.x7.x4/a_27_47# 0
C108 dc_inst.x9/a_757_363# clknet_0_clk 0
C109 dc_inst.x2.x20/a_27_47# dc_inst.x2.x18/a_27_47# 0.01191f
C110 dc_inst.x5.net13 dc_inst.x5.net15 0
C111 dc_inst.x2.x2/a_27_47# dc_inst.x4.net8 0.0022f
C112 dc_inst.x7.x15/a_27_47# delay_sel[1] 0
C113 VPWR dc_inst.x2.x5/a_27_47# 0.00877f
C114 dc_inst.net1 dc_inst.x2.net15 0
C115 dc_inst.x1.net13 dc_inst.x1.net6 0
C116 VPWR path[6] 0.39785f
C117 path[5] dc_inst.in 0
C118 dc_inst.x1.net8 dc_inst.x3.net17 0
C119 dc_inst.x6.x19/a_27_47# dc_inst.x6.net16 0
C120 dc_inst.x7.x9/a_27_47# dc_inst.x7.net10 0.00882f
C121 VPWR _24_/a_1283_21# -0.00364f
C122 dc_inst.x2.x19/a_27_47# path[7] 0
C123 clknet_1_0__leaf_clk dc_inst.x7.net3 0
C124 dc_inst.x4.net3 dc_inst.x4.x3/a_27_47# 0.05171f
C125 _19_/a_27_47# dc_inst.x1.net3 0.00118f
C126 dc_inst.x6.net14 dc_inst.x5.net6 0
C127 dc_inst.x4.x16/a_27_47# dc_inst.x4.net14 0.03765f
C128 dc_inst.x6.net9 dc_inst.x6.net11 0
C129 dc_inst.x2.net1 path_sel[2] 0
C130 dc_inst.x6.net12 dc_inst.x4.x11/a_27_47# 0
C131 VPWR dc_inst.x3.net17 0.27649f
C132 dc_inst.x7.net11 dc_inst.x7.net12 0.00682f
C133 dc_inst.x7.x6/a_27_47# path_sel[2] 0.00635f
C134 dc_inst.x6.x9/a_27_47# dc_inst.x6.net9 0.12901f
C135 _15_/a_397_47# dc_inst.x1.net2 0.00352f
C136 dc_inst.x1.net8 dc_inst.x1.net12 0.01725f
C137 _15_/a_288_47# dc_inst.x3.x4/a_27_47# 0
C138 VPWR dc_inst.x4.x13/a_27_47# 0.00316f
C139 dc_inst.x1.x13/a_27_47# dc_inst.x1.x8/a_27_47# 0
C140 dc_inst.x5.x16/a_27_47# dc_inst.x5.net15 0.04845f
C141 dc_inst.x2.net16 dc_inst.x1.net16 0.00932f
C142 dc_inst.x10/a_439_47# dc_inst.net9 0.00157f
C143 dc_inst.net9 _01_ 0
C144 delay_sel[1] dc_inst.x2.net19 0.00436f
C145 _15_/a_288_47# dc_inst.x2.net19 0
C146 dc_inst.x7.net4 dc_inst.x6.net9 0
C147 tdi _13_/a_470_297# 0
C148 path_sel[1] _18_/a_76_199# 0.00218f
C149 dc_inst.x6.x14/a_27_47# dc_inst.x6.net11 0.00332f
C150 dc_inst.x6.net18 dc_inst.x5.net6 0
C151 tdi _14_/a_439_47# 0.00123f
C152 VPWR dc_inst.x3.x9/a_27_47# 0.00426f
C153 dc_inst.x4.net3 dc_inst.net3 0
C154 dc_inst.x8/a_1478_413# delay_sel[1] 0
C155 dc_inst.x5.net7 path_sel[2] 0.00411f
C156 dc_inst.x7.x6/a_27_47# dc_inst.x6.x7/a_27_47# 0
C157 dc_inst.x5.x1/a_27_47# dc_inst.x4.x20/a_27_47# 0.01191f
C158 dc_inst.x7.x1/a_27_47# delay_sel[0] 0
C159 dc_inst.net3 _23_/a_1283_21# 0
C160 clkbuf_1_0__f_clk/a_110_47# _25_/a_448_47# 0
C161 VPWR dc_inst.x1.net12 0.32959f
C162 clkbuf_1_0__f_clk/a_110_47# dc_inst.x7.net12 0.02215f
C163 dc_inst.x1.x6/a_27_47# path_sel[0] 0.01963f
C164 dc_inst.x5.net2 dc_inst.x5.net3 0.00907f
C165 dc_inst.x5.net4 dc_inst.x5.x3/a_27_47# 0.015f
C166 dc_inst.x7.net7 dc_inst.x6.x15/a_27_47# 0
C167 _24_/a_1108_47# _24_/a_193_47# -0.00656f
C168 dc_inst.x2.net8 dc_inst.x2.x7/a_27_47# 0.04368f
C169 dc_inst.x5.net18 dc_inst.x6.net3 0
C170 dc_inst.x3.x5/a_27_47# path[6] 0.00526f
C171 dc_inst.x5.x12/a_27_47# path[2] 0
C172 path[5] path[6] 0.14723f
C173 dc_inst.x4.net7 dc_inst.x1.net19 0
C174 dc_inst.x3.net14 dc_inst.x3.x13/a_27_47# 0.00407f
C175 dc_inst.x7.x14/a_27_47# dc_inst.x7.net17 0
C176 VPWR _05_ 0.1171f
C177 VPWR clkload0/a_27_47# 0.09376f
C178 _23_/a_1108_47# dc_inst.x7.x3/a_27_47# 0.00104f
C179 dc_inst.x1.net4 dc_inst.x8/a_1290_413# 0
C180 _10_ _17_/a_27_93# 0
C181 dc_inst.x1.x16/a_27_47# dc_inst.x1.net9 0
C182 _04_ path[4] 0.00869f
C183 tdo path_sel[0] 0.07877f
C184 dc_inst.x2.x15/a_27_47# path_sel[2] 0.00525f
C185 dc_inst.x5.x17/a_27_47# dc_inst.x4.net17 0
C186 VPWR dc_inst.x5.x1/a_27_47# 0.00201f
C187 dc_inst.x7.net4 dc_inst.x6.net15 0
C188 dc_inst.x6.x10/a_27_47# dc_inst.x6.x11/a_27_47# 0.02448f
C189 VPWR dc_inst.x1.x2/a_27_47# -0.0018f
C190 dc_inst.x1.net7 _10_ 0.03764f
C191 dc_inst.x6.x12/a_27_47# dc_inst.net7 0
C192 dc_inst.x4.net13 dc_inst.x2.net11 0
C193 dc_inst.x1.x12/a_27_47# _17_/a_174_21# 0
C194 _14_/a_76_199# _02_ 0.00244f
C195 VPWR dc_inst.x5.x14/a_27_47# -0.00271f
C196 dc_inst.x6.net10 dc_inst.x6.net9 0.00377f
C197 dc_inst.x6.net14 dc_inst.net5 0
C198 dc_inst.x1.x11/a_27_47# path_sel[2] 0.01355f
C199 dc_inst.x3.x8/a_27_47# dc_inst.x3.x13/a_27_47# 0.01254f
C200 dc_inst.x3.net17 dc_inst.x3.x5/a_27_47# 0
C201 dc_inst.x1.net4 _02_ 0
C202 dc_inst.x5.net6 dc_inst.x1.net19 0.02091f
C203 dc_inst.x1.x15/a_27_47# dc_inst.in 0
C204 dc_inst.x3.net17 path[5] 0.04178f
C205 path_sel[1] dc_inst.x5.x4/a_27_47# 0.00504f
C206 dc_inst.x1.net2 dc_inst.x1.x9/a_27_47# 0
C207 dc_inst.x7.x1/a_27_47# dc_inst.x7.net2 0.00214f
C208 dc_inst.x9/a_1478_413# rst 0
C209 _14_/a_439_47# rst 0
C210 dc_inst.x7.x2/a_27_47# _25_/a_1108_47# 0
C211 dc_inst.x3.net1 dc_inst.x3.net18 0
C212 dc_inst.x6.net14 path_sel[2] 0.0372f
C213 dc_inst.x10/a_505_21# dc_inst.x3.net4 0
C214 dc_inst.x9/a_247_21# clknet_0_clk 0
C215 dc_inst.x3.x9/a_27_47# path[5] 0.01013f
C216 dc_inst.net1 dc_inst.x6.net15 0
C217 dc_inst.x4.x3/a_27_47# dc_inst.x2.net15 0
C218 dc_inst.x3.net19 dc_inst.x3.x20/a_27_47# 0.00819f
C219 dc_inst.x2.x16/a_27_47# delay_sel[1] 0
C220 dc_inst.x6.x20/a_27_47# dc_inst.x7.net19 0
C221 dc_inst.net6 dc_inst.x7.x6/a_27_47# 0
C222 dc_inst.x6.net18 dc_inst.net5 0
C223 dc_inst.x5.x5/a_27_47# dc_inst.x2.net6 0
C224 dc_inst.x2.x20/a_27_47# dc_inst.x1.net2 0
C225 path[5] dc_inst.x1.net12 0
C226 dc_inst.x5.net7 dc_inst.x6.net11 0
C227 VPWR dc_inst.x5.net4 -0.00549f
C228 dc_inst.x1.net11 dc_inst.x5.net12 0
C229 _13_/a_470_297# clknet_1_1__leaf_clk 0
C230 dc_inst.x1.x16/a_27_47# dc_inst.x2.net6 0
C231 se _02_ 0.01294f
C232 _14_/a_439_47# clknet_1_1__leaf_clk 0
C233 _14_/a_535_374# _02_ 0
C234 dc_inst.x7.x7/a_27_47# dc_inst.x6.net3 0
C235 dc_inst.x1.net15 delay_sel[1] 0
C236 VPWR dc_inst.x5.net15 0.0235f
C237 dc_inst.x6.x9/a_27_47# dc_inst.x5.net7 0
C238 VPWR dc_inst.x2.x4/a_27_47# 0.00937f
C239 dc_inst.x3.net7 dc_inst.x3.x15/a_27_47# 0
C240 dc_inst.x6.net18 path_sel[2] 0.00225f
C241 delay_sel[1] _25_/a_193_47# 0.00176f
C242 dc_inst.x3.net19 dc_inst.x3.net13 0
C243 VPWR dc_inst.x4.x18/a_27_47# -0.00892f
C244 dc_inst.x3.net4 rst 0
C245 _05_ dc_inst.x3.x5/a_27_47# 0
C246 dc_inst.x4.x1/a_27_47# path[7] 0
C247 dc_inst.net3 dc_inst.x2.net15 0
C248 _05_ path[5] 0.01081f
C249 clkbuf_1_0__f_clk/a_110_47# dc_inst.in 0
C250 VPWR _15_/a_600_345# 0.00292f
C251 dc_inst.x6.net12 dc_inst.x4.net7 0
C252 dc_inst.x2.x17/a_27_47# dc_inst.x1.net16 0
C253 dc_inst.x9/a_1290_413# _25_/a_1108_47# 0
C254 dc_inst.x5.net7 dc_inst.x1.net17 0
C255 dc_inst.x5.x1/a_27_47# dc_inst.x6.net6 0.03439f
C256 dc_inst.x4.x16/a_27_47# dc_inst.x5.x6/a_27_47# 0
C257 dc_inst.x1.x14/a_27_47# dc_inst.x2.x13/a_27_47# 0
C258 dc_inst.x9/a_750_97# dc_inst.x7.net12 0
C259 dc_inst.x3.net1 dc_inst.x3.net7 0.03092f
C260 dc_inst.net4 dc_inst.x6.net1 0.03674f
C261 dc_inst.x7.x19/a_27_47# rst 0
C262 dc_inst.x5.net3 dc_inst.x4.x19/a_27_47# 0.03779f
C263 dc_inst.x6.x19/a_27_47# dc_inst.x7.net19 0
C264 dc_inst.x1.x15/a_27_47# path[6] 0
C265 _02_ _24_/a_448_47# 0
C266 dc_inst.net3 _23_/a_27_47# 0
C267 dc_inst.x3.net16 dc_inst.net9 0
C268 dc_inst.x4.net13 dc_inst.x4.x12/a_27_47# 0.03187f
C269 path_sel[1] dc_inst.x5.x7/a_27_47# 0.00228f
C270 dc_inst.x6.net12 dc_inst.x5.net6 0
C271 dc_inst.x3.net4 clknet_1_1__leaf_clk 0
C272 dc_inst.x3.x12/a_27_47# dc_inst.x3.x9/a_27_47# 0
C273 dc_inst.net1 dc_inst.x5.net7 0
C274 dc_inst.x2.net14 dc_inst.x1.net11 0.00194f
C275 dc_inst.x3.x17/a_27_47# dc_inst.x3.net3 0.03436f
C276 dc_inst.x3.net14 path[4] 0
C277 dc_inst.x5.x17/a_27_47# dc_inst.x5.net17 0.00266f
C278 VPWR dc_inst.x4.x7/a_27_47# -0
C279 _06_ path_sel[2] 0
C280 dc_inst.x9/a_247_21# dc_inst.x7.x15/a_27_47# 0.00868f
C281 _15_/a_372_413# dc_inst.in 0
C282 path_sel[1] dc_inst.x3.net18 0
C283 dc_inst.x3.net8 capture_q 0
C284 dc_inst.in dc_inst.net9 0.09911f
C285 dc_inst.x2.x15/a_27_47# dc_inst.x1.net17 0
C286 dc_inst.x6.net14 dc_inst.x6.net11 0.00149f
C287 dc_inst.x2.net2 dc_inst.x5.net7 0.16557f
C288 path_sel[2] dc_inst.x1.net19 0.01881f
C289 _15_/a_788_316# dc_inst.x3.net6 0
C290 dc_inst.x3.x4/a_27_47# capture_q 0
C291 dc_inst.x6.net10 dc_inst.x5.net7 0.0089f
C292 _15_/a_27_47# dc_inst.x2.net18 0
C293 dc_inst.x6.net17 dc_inst.x6.x17/a_27_47# 0.00211f
C294 dc_inst.x5.net12 dc_inst.x1.net14 0
C295 dc_inst.x4.net13 dc_inst.x5.x15/a_27_47# 0
C296 VPWR _17_/a_174_21# 0.01331f
C297 dc_inst.x6.net6 dc_inst.x5.net15 0
C298 dc_inst.x5.net12 dc_inst.x4.net11 0
C299 dc_inst.x2.net8 dc_inst.x1.net18 0
C300 dc_inst.x8/a_1478_413# capture_q 0
C301 dc_inst.x7.net4 dc_inst.x6.net14 0
C302 dc_inst.net4 dc_inst.x5.x20/a_27_47# 0
C303 _08_ _18_/a_218_374# 0
C304 _15_/a_288_47# dc_inst.net2 0.00238f
C305 dc_inst.net2 delay_sel[1] 0.13183f
C306 _14_/a_505_21# dc_inst.x3.net6 0
C307 dc_inst.x9/a_193_413# dc_inst.x6.x4/a_27_47# 0
C308 dc_inst.x6.net14 dc_inst.x1.net17 0.01766f
C309 path[5] _15_/a_600_345# 0.00518f
C310 dc_inst.x1.net4 dc_inst.in 0.10588f
C311 dc_inst.x6.net1 dc_inst.x6.net8 0
C312 dc_inst.x1.net1 dc_inst.x1.net3 0
C313 dc_inst.x1.x15/a_27_47# dc_inst.x1.net12 0.07418f
C314 path[3] path_sel[2] 0.00651f
C315 delay_sel[2] _01_ 0.21392f
C316 _10_ dc_inst.x2.net17 0
C317 clknet_0_clk _25_/a_543_47# 0.00495f
C318 path_sel[1] dc_inst.net4 0.03984f
C319 dc_inst.net6 dc_inst.x6.net18 0
C320 delay_sel[0] dc_inst.x1.net18 0
C321 dc_inst.x5.x4/a_27_47# dc_inst.x2.x14/a_27_47# 0
C322 dc_inst.x8/a_750_97# dc_inst.net8 0.02676f
C323 dc_inst.x8/a_27_47# capture_d 0
C324 dc_inst.x5.net3 dc_inst.x5.net5 0.17678f
C325 dc_inst.x1.net11 dc_inst.x1.net7 0.3774f
C326 dc_inst.net1 dc_inst.x6.net14 0.07913f
C327 path_sel[1] dc_inst.x3.net7 0
C328 dc_inst.x4.net8 dc_inst.x4.x20/a_27_47# 0
C329 dc_inst.x7.net4 dc_inst.x6.net18 0.10622f
C330 dc_inst.x6.net17 dc_inst.net9 0
C331 dc_inst.x5.x13/a_27_47# dc_inst.x6.net8 0
C332 clknet_0_clk _25_/a_639_47# 0
C333 dc_inst.x6.net12 dc_inst.net5 0.00273f
C334 path_sel[2] _19_/a_27_47# 0.00871f
C335 dc_inst.x9/a_750_97# dc_inst.in 0
C336 clkbuf_0_clk/a_110_47# _25_/a_543_47# 0.01033f
C337 dc_inst.x5.net3 dc_inst.x2.x9/a_27_47# 0
C338 dc_inst.x5.net17 dc_inst.x4.net17 0
C339 dc_inst.x3.net5 dc_inst.x7.x3/a_27_47# 0
C340 dc_inst.x5.net6 dc_inst.x5.x5/a_27_47# 0.02967f
C341 dc_inst.x4.net13 dc_inst.x5.net14 0
C342 dc_inst.x1.x15/a_27_47# dc_inst.x1.x2/a_27_47# 0.08729f
C343 delay_sel[2] _02_ 0.03217f
C344 _15_/a_372_413# path[6] 0.00151f
C345 dc_inst.x3.net2 dc_inst.x7.x3/a_27_47# 0
C346 _04_ _15_/a_788_316# 0
C347 dc_inst.x1.x16/a_27_47# dc_inst.x5.net6 0.00103f
C348 dc_inst.x6.net17 dc_inst.x6.x13/a_27_47# 0
C349 dc_inst.x6.net12 path_sel[2] 0.04774f
C350 dc_inst.net4 dc_inst.x7.net7 0.00159f
C351 dc_inst.net1 dc_inst.x6.net18 0.00101f
C352 dc_inst.x6.net11 dc_inst.x1.net19 0.00148f
C353 dc_inst.x8/a_193_47# delay_sel[1] 0
C354 dc_inst.net3 _23_/a_1217_47# 0
C355 dc_inst.x9/a_277_47# dc_inst.x7.net12 0
C356 delay_sel[2] _25_/a_448_47# 0
C357 dc_inst.x7.net3 _23_/a_543_47# 0
C358 VPWR dc_inst.x4.net8 0.09796f
C359 dc_inst.x3.net7 _23_/a_1108_47# 0
C360 _23_/a_193_47# dc_inst.x8/a_757_363# 0
C361 delay_sel[0] dc_inst.x7.net15 0.01622f
C362 _14_/a_76_199# path[6] 0.02059f
C363 delay_sel[2] dc_inst.x7.net12 0
C364 dc_inst.x1.net1 dc_inst.x2.net12 0
C365 dc_inst.x5.net2 dc_inst.x4.net14 0
C366 dc_inst.net8 dc_inst.x3.x1/a_27_47# 0
C367 dc_inst.x1.net4 path[6] 0.17439f
C368 dc_inst.x4.net9 dc_inst.x2.x4/a_27_47# 0
C369 dc_inst.x1.net13 dc_inst.x2.net15 0.00144f
C370 path_sel[1] dc_inst.x6.net8 0.00539f
C371 dc_inst.x1.net15 dc_inst.x1.x13/a_27_47# 0.13028f
C372 _25_/a_27_47# clk 0.00915f
C373 VPWR dc_inst.x6.x6/a_27_47# -0.0055f
C374 dc_inst.x5.net7 dc_inst.x4.x8/a_27_47# 0.03002f
C375 dc_inst.x1.net10 dc_inst.x1.net5 0
C376 dc_inst.x5.x19/a_27_47# dc_inst.x5.x20/a_27_47# 0
C377 dc_inst.x1.net17 dc_inst.x1.net19 0.23844f
C378 dc_inst.x2.net18 dc_inst.x6.net19 0
C379 dc_inst.x2.net5 dc_inst.x1.x17/a_27_47# 0
C380 dc_inst.x2.net4 dc_inst.x4.net5 0.00349f
C381 dc_inst.x1.x3/a_27_47# dc_inst.x3.x14/a_27_47# 0
C382 _14_/a_76_199# dc_inst.x3.net17 0
C383 dc_inst.x7.net12 dc_inst.x7.net17 0
C384 dc_inst.x5.net3 dc_inst.x5.net9 0.2694f
C385 dc_inst.x5.net6 dc_inst.x1.x19/a_27_47# 0.02054f
C386 dc_inst.x7.x13/a_27_47# clknet_1_0__leaf_clk 0
C387 dc_inst.x1.net7 dc_inst.x1.net14 0
C388 _07_ _19_/a_109_297# 0
C389 dc_inst.x1.net4 dc_inst.x3.net17 0
C390 dc_inst.net1 dc_inst.x1.net19 0.00208f
C391 VPWR dc_inst.x7.x17/a_27_47# -0.00756f
C392 path_sel[1] dc_inst.x5.x19/a_27_47# 0.00295f
C393 dc_inst.x9/a_247_21# _25_/a_193_47# 0
C394 dc_inst.x4.net13 dc_inst.x4.net15 0.00632f
C395 se path[6] 0.10529f
C396 dc_inst.x5.net7 dc_inst.x5.x8/a_27_47# 0.00331f
C397 tdo dc_inst.x7.net3 0.03726f
C398 _14_/a_535_374# path[6] 0
C399 dc_inst.x3.net10 dc_inst.x3.net11 0.22901f
C400 path_sel[0] dc_inst.x3.x2/a_27_47# 0
C401 dc_inst.x4.x16/a_27_47# VPWR -0.00707f
C402 dc_inst.x4.net13 dc_inst.x5.net8 0.04376f
C403 path_sel[1] dc_inst.x6.x12/a_27_47# 0
C404 dc_inst.x1.net1 dc_inst.x2.net13 0.00439f
C405 _15_/a_788_316# dc_inst.x1.net5 0
C406 dc_inst.x7.net4 dc_inst.x10/a_505_21# 0.00146f
C407 dc_inst.x7.net7 dc_inst.x6.net8 0
C408 dc_inst.x2.net2 dc_inst.x1.net19 0.04724f
C409 clkload0/a_27_47# dc_inst.net9 0
C410 dc_inst.x4.net9 dc_inst.x4.x7/a_27_47# 0.00123f
C411 dc_inst.x1.x3/a_27_47# path[7] 0
C412 dc_inst.x4.net10 dc_inst.x5.net9 0
C413 dc_inst.x6.net10 dc_inst.x1.net19 0
C414 dc_inst.x1.net4 dc_inst.x1.net12 0.00148f
C415 dc_inst.x7.net15 dc_inst.x7.net1 0.02169f
C416 dc_inst.x4.x1/a_27_47# dc_inst.x8/a_247_21# 0.00115f
C417 dc_inst.x4.net8 dc_inst.x6.net6 0
C418 dc_inst.x6.net12 dc_inst.x6.net11 0.00591f
C419 dc_inst.x4.net18 dc_inst.x5.x13/a_27_47# 0.00214f
C420 se dc_inst.x3.net17 0
C421 path_sel[1] dc_inst.x5.x18/a_27_47# 0.00258f
C422 _24_/a_27_47# _24_/a_193_47# -0.21508f
C423 dc_inst.x8/a_668_97# dc_inst.x4.net5 0
C424 dc_inst.x3.net16 delay_sel[2] 0
C425 path_sel[1] dc_inst.x1.net9 0.01419f
C426 dc_inst.net6 dc_inst.x6.net12 0
C427 dc_inst.x6.net18 dc_inst.x7.net5 0.00512f
C428 _14_/a_76_199# _05_ 0.01254f
C429 dc_inst.x1.x16/a_27_47# path_sel[2] 0.0131f
C430 dc_inst.x3.net14 _15_/a_788_316# 0
C431 _02_ _25_/a_1283_21# 0
C432 dc_inst.x7.net4 rst 0.00838f
C433 dc_inst.x6.x6/a_27_47# dc_inst.x6.net6 0.01239f
C434 dc_inst.x4.net19 path_sel[0] 0.00133f
C435 delay_sel[2] dc_inst.in 0.01756f
C436 dc_inst.x2.x6/a_27_47# dc_inst.x1.net16 0
C437 dc_inst.x1.net11 dc_inst.x2.net17 0
C438 dc_inst.x6.net12 dc_inst.x1.net17 0.02879f
C439 _15_/a_27_47# dc_inst.x1.x12/a_27_47# 0
C440 dc_inst.x6.x18/a_27_47# delay_sel[1] 0
C441 dc_inst.net7 dc_inst.net5 0
C442 dc_inst.x3.net11 path_sel[0] 0.00481f
C443 dc_inst.x4.x19/a_27_47# dc_inst.x4.net14 0.03058f
C444 dc_inst.x4.net2 dc_inst.x1.net18 0
C445 VPWR dc_inst.x4.x9/a_27_47# 0.00192f
C446 dc_inst.x1.net1 _18_/a_218_47# 0
C447 dc_inst.x3.net14 _14_/a_505_21# 0
C448 delay_sel[2] _23_/a_639_47# 0.00107f
C449 dc_inst.net1 rst 0
C450 dc_inst.x7.net12 _25_/a_1283_21# 0
C451 path_sel[1] dc_inst.x4.x11/a_27_47# 0.01274f
C452 dc_inst.net1 dc_inst.x6.net12 0
C453 dc_inst.net7 path_sel[2] 0
C454 dc_inst.net4 dc_inst.x6.net4 0.00376f
C455 dc_inst.x4.net18 path_sel[1] 0.00612f
C456 se _05_ 0.0466f
C457 dc_inst.x3.net5 dc_inst.x3.net18 0.00368f
C458 dc_inst.x2.net18 dc_inst.x2.net19 0.12779f
C459 se clkload0/a_27_47# 0
C460 _05_ _14_/a_535_374# 0
C461 path_sel[1] dc_inst.x1.net3 0.02582f
C462 _09_ _19_/a_109_297# 0.0077f
C463 dc_inst.x6.net14 dc_inst.x1.x18/a_27_47# 0.01689f
C464 path_sel[2] dc_inst.x1.x19/a_27_47# 0.00379f
C465 dc_inst.x3.net2 dc_inst.x3.net18 0.01375f
C466 dc_inst.x1.x7/a_27_47# dc_inst.x1.net9 0.00205f
C467 _14_/a_505_21# dc_inst.x3.x8/a_27_47# 0.00191f
C468 dc_inst.x7.net12 _25_/a_805_47# 0
C469 path_sel[1] dc_inst.x2.net6 0.03881f
C470 dc_inst.net4 dc_inst.x5.net19 0.04396f
C471 dc_inst.x7.net15 dc_inst.x7.net18 0.01931f
C472 dc_inst.x1.net11 dc_inst.x5.net11 0
C473 dc_inst.net3 dc_inst.x6.net18 0
C474 dc_inst.x5.x6/a_27_47# dc_inst.x6.net19 0
C475 dc_inst.x6.net10 dc_inst.x6.net12 0
C476 dc_inst.x3.net4 dc_inst.x3.x15/a_27_47# 0
C477 _24_/a_1108_47# capture_q 0.00191f
C478 dc_inst.x4.x13/a_27_47# dc_inst.x6.net7 0
C479 dc_inst.x9/a_1290_413# dc_inst.x6.net16 0
C480 dc_inst.x6.net17 delay_sel[2] 0
C481 dc_inst.x4.net9 dc_inst.x4.net8 0.12312f
C482 clkload0/a_27_47# _24_/a_448_47# 0
C483 path[4] dc_inst.x3.net3 0
C484 dc_inst.x1.net4 _15_/a_600_345# 0
C485 dc_inst.x4.x10/a_27_47# dc_inst.x5.x7/a_27_47# 0
C486 path[2] _18_/a_439_47# 0.00187f
C487 _25_/a_193_47# _25_/a_543_47# -0.01017f
C488 dc_inst.x1.net13 dc_inst.x2.net1 0
C489 dc_inst.x6.x15/a_27_47# dc_inst.x4.x5/a_27_47# 0.00122f
C490 delay_sel[2] path[6] 0.00495f
C491 dc_inst.x4.net16 dc_inst.x5.x7/a_27_47# 0
C492 dc_inst.x4.x4/a_27_47# dc_inst.x2.net18 0
C493 _03_ clknet_0_clk 0.12397f
C494 dc_inst.x2.net17 dc_inst.x1.net14 0
C495 path_sel[0] dc_inst.x1.net2 0.11522f
C496 VPWR dc_inst.x1.x14/a_27_47# -0.00595f
C497 _20_/a_384_47# _06_ 0.00172f
C498 clkbuf_1_1__f_clk/a_110_47# dc_inst.x3.net15 0
C499 dc_inst.x3.net5 dc_inst.x3.net7 0.01651f
C500 _24_/a_1283_21# delay_sel[2] 0.00602f
C501 delay_sel[0] clknet_1_0__leaf_clk 0
C502 _15_/a_1064_47# path_sel[0] -0
C503 dc_inst.x4.net1 path_sel[0] 0
C504 dc_inst.x5.net2 dc_inst.x5.net13 0.0111f
C505 dc_inst.x1.net1 path_sel[2] 0.00191f
C506 dc_inst.x7.net4 dc_inst.x1.x16/a_27_47# 0
C507 dc_inst.x5.net3 dc_inst.x4.x17/a_27_47# 0
C508 path_sel[1] dc_inst.x2.net12 0.02272f
C509 _15_/a_288_47# dc_inst.x1.net7 0
C510 _15_/a_27_47# dc_inst.x1.net8 0.0015f
C511 _03_ clkbuf_0_clk/a_110_47# 0.01525f
C512 dc_inst.x1.x16/a_27_47# dc_inst.x1.net17 0
C513 dc_inst.x3.net17 delay_sel[2] 0.00231f
C514 dc_inst.x5.net3 dc_inst.x5.net12 0.02959f
C515 dc_inst.x5.net6 dc_inst.x6.net1 0
C516 clkbuf_1_1__f_clk/a_110_47# _24_/a_193_47# 0.01452f
C517 dc_inst.net7 dc_inst.x6.net11 0
C518 dc_inst.x5.net19 dc_inst.x6.net8 0.06959f
C519 dc_inst.x2.x16/a_27_47# dc_inst.x2.net18 0
C520 dc_inst.x4.net2 dc_inst.x2.x20/a_27_47# 0
C521 dc_inst.x7.net2 _00_ 0
C522 dc_inst.x5.x17/a_27_47# dc_inst.x5.net16 0.01776f
C523 _20_/a_79_21# dc_inst.x1.x5/a_27_47# 0.01002f
C524 dc_inst.x5.x1/a_27_47# dc_inst.x6.net7 0
C525 dc_inst.x1.x10/a_27_47# dc_inst.x1.net11 0
C526 dc_inst.net6 dc_inst.net7 0.0385f
C527 dc_inst.x5.net11 dc_inst.x1.net14 0
C528 dc_inst.x1.x18/a_27_47# dc_inst.x1.net19 0.00338f
C529 dc_inst.x5.net2 dc_inst.x5.x2/a_27_47# 0.02051f
C530 dc_inst.x4.net19 tdo 0
C531 VPWR _15_/a_27_47# 0.011f
C532 dc_inst.x1.x16/a_27_47# dc_inst.net1 0
C533 dc_inst.x7.net1 _00_ 0.03796f
C534 _06_ _18_/a_505_21# 0
C535 _20_/a_384_47# path[3] 0.00109f
C536 dc_inst.x7.net4 dc_inst.net7 0
C537 dc_inst.x1.net15 dc_inst.x2.net18 0
C538 dc_inst.x2.x19/a_27_47# delay_sel[1] 0
C539 dc_inst.x2.x11/a_27_47# dc_inst.x5.x10/a_27_47# 0
C540 dc_inst.x1.x4/a_27_47# dc_inst.x1.net8 0.00894f
C541 dc_inst.x9/a_247_21# dc_inst.x7.net10 0.01303f
C542 _13_/a_27_297# dc_inst.x3.net4 0
C543 dc_inst.x5.net2 dc_inst.x5.x16/a_27_47# 0.02896f
C544 dc_inst.x1.net8 dc_inst.x1.x8/a_27_47# 0.01895f
C545 dc_inst.x3.x17/a_27_47# _01_ 0
C546 dc_inst.x4.net16 dc_inst.net4 0.01325f
C547 dc_inst.x5.x19/a_27_47# dc_inst.x5.net19 0.01498f
C548 dc_inst.x7.net2 clknet_1_0__leaf_clk 0
C549 dc_inst.x8/a_1290_413# dc_inst.x3.x17/a_27_47# 0
C550 dc_inst.x5.net12 dc_inst.x4.net10 0
C551 path_sel[1] dc_inst.x2.net13 0.00844f
C552 dc_inst.x1.net17 dc_inst.x1.x19/a_27_47# 0.08076f
C553 dc_inst.x5.x20/a_27_47# dc_inst.x7.x19/a_27_47# 0.00109f
C554 clknet_1_0__leaf_clk dc_inst.x7.net1 0.16065f
C555 _20_/a_384_47# _19_/a_27_47# 0
C556 dc_inst.x6.x14/a_27_47# dc_inst.x6.net3 0
C557 path_sel[1] dc_inst.x4.net7 0.00598f
C558 dc_inst.x5.net2 dc_inst.x6.net2 0
C559 dc_inst.x1.x4/a_27_47# VPWR 0.01128f
C560 delay_sel[2] clkload0/a_27_47# 0.00732f
C561 VPWR dc_inst.x1.x8/a_27_47# 0.01235f
C562 dc_inst.x7.net14 dc_inst.x7.net15 0.03448f
C563 dc_inst.x3.x17/a_27_47# _02_ 0
C564 dc_inst.x4.net14 dc_inst.x5.net9 0
C565 dc_inst.x7.x20/a_27_47# dc_inst.x7.net19 0.03125f
C566 dc_inst.x4.net4 dc_inst.in 0
C567 dc_inst.x5.net15 dc_inst.x6.net7 0.00547f
C568 dc_inst.x2.x2/a_27_47# dc_inst.x2.net3 0.04368f
C569 dc_inst.x5.x18/a_27_47# dc_inst.x5.net19 0.00509f
C570 _20_/a_79_21# path_sel[0] 0.0122f
C571 dc_inst.x3.x10/a_27_47# dc_inst.x3.x11/a_27_47# 0
C572 dc_inst.x5.net6 dc_inst.x1.x20/a_27_47# 0
C573 path[3] _18_/a_505_21# 0.00239f
C574 dc_inst.x4.net5 dc_inst.x8/a_247_21# 0
C575 dc_inst.x7.x17/a_27_47# clkbuf_1_0__f_clk/a_110_47# 0.00579f
C576 path_sel[1] dc_inst.x5.net6 0.0409f
C577 dc_inst.x4.x9/a_27_47# dc_inst.x4.net9 0.01369f
C578 dc_inst.x2.net6 dc_inst.x2.x14/a_27_47# 0
C579 dc_inst.net3 rst 0
C580 dc_inst.x7.net19 dc_inst.x7.x2/a_27_47# 0.0428f
C581 tdo _24_/a_805_47# 0
C582 dc_inst.x2.net2 dc_inst.x1.x19/a_27_47# 0.0011f
C583 dc_inst.x2.x2/a_27_47# dc_inst.x2.x1/a_27_47# 0
C584 dc_inst.x2.net11 dc_inst.x5.x4/a_27_47# 0.01151f
C585 VPWR dc_inst.x3.x18/a_27_47# -0.00406f
C586 _24_/a_27_47# delay_sel[1] 0
C587 dc_inst.x5.net16 dc_inst.x4.net17 0
C588 dc_inst.x5.net3 dc_inst.x2.x8/a_27_47# 0
C589 tdo dc_inst.x6.x11/a_27_47# 0
C590 dc_inst.x4.net8 dc_inst.x6.x13/a_27_47# 0
C591 dc_inst.x1.x10/a_27_47# dc_inst.x1.net14 0
C592 _04_ _07_ 0
C593 dc_inst.x10/a_505_21# _23_/a_761_289# 0.00669f
C594 dc_inst.x4.x19/a_27_47# dc_inst.x5.net13 0.00106f
C595 _15_/a_27_47# path[5] 0.02633f
C596 _19_/a_109_297# _18_/a_76_199# 0
C597 _19_/a_27_47# _18_/a_505_21# 0
C598 dc_inst.x6.net12 dc_inst.x1.x18/a_27_47# 0.00134f
C599 dc_inst.x5.net2 dc_inst.x4.x20/a_27_47# 0
C600 dc_inst.x2.x2/a_27_47# dc_inst.x5.net9 0
C601 dc_inst.x6.net1 path_sel[2] 0.00484f
C602 dc_inst.x3.net12 dc_inst.x3.net18 0
C603 dc_inst.net2 dc_inst.x2.net18 0.02076f
C604 dc_inst.x4.net1 tdo 0.03773f
C605 dc_inst.x8/a_750_97# dc_inst.x7.x3/a_27_47# 0
C606 VPWR clknet_0_clk 0.27284f
C607 dc_inst.x1.net9 dc_inst.x3.net2 0
C608 clknet_1_0__leaf_clk dc_inst.x7.net18 0.00115f
C609 dc_inst.x4.net4 dc_inst.x6.net17 0
C610 _23_/a_761_289# rst 0.00118f
C611 _25_/a_27_47# dc_inst.x7.x12/a_27_47# 0
C612 VPWR dc_inst.x6.net19 0.00429f
C613 dc_inst.x9/a_1290_413# dc_inst.x7.net19 0.00356f
C614 dc_inst.x2.x5/a_27_47# dc_inst.x1.net16 0.01107f
C615 dc_inst.x2.x14/a_27_47# dc_inst.x2.net12 0.03467f
C616 dc_inst.x7.x1/a_27_47# dc_inst.x7.x6/a_27_47# 0.03162f
C617 _10_ _19_/a_205_47# 0
C618 dc_inst.x5.net2 VPWR 0.95643f
C619 dc_inst.x5.x20/a_27_47# dc_inst.net5 0.02185f
C620 VPWR clkbuf_0_clk/a_110_47# 0.05861f
C621 dc_inst.x6.net5 dc_inst.x6.x6/a_27_47# 0
C622 dc_inst.x7.x18/a_27_47# clknet_1_0__leaf_clk 0
C623 dc_inst.x5.x13/a_27_47# dc_inst.x6.x7/a_27_47# 0
C624 dc_inst.x6.net13 dc_inst.x4.net11 0
C625 dc_inst.x1.x16/a_27_47# dc_inst.x4.x3/a_27_47# 0.01013f
C626 dc_inst.x10/a_76_199# tdo 0.00623f
C627 dc_inst.x5.x11/a_27_47# path_sel[0] 0
C628 dc_inst.x1.net13 dc_inst.x1.net19 0
C629 dc_inst.x2.x20/a_27_47# _23_/a_1283_21# 0
C630 dc_inst.x2.net15 dc_inst.x1.net18 0
C631 dc_inst.net7 dc_inst.x7.net5 0
C632 dc_inst.x5.x20/a_27_47# path_sel[2] 0.0038f
C633 _23_/a_761_289# clknet_1_1__leaf_clk 0.00121f
C634 dc_inst.x1.net14 dc_inst.x5.net1 0
C635 path[5] dc_inst.x3.x18/a_27_47# 0.0191f
C636 dc_inst.x3.net2 dc_inst.x1.net3 0.05073f
C637 dc_inst.x1.x13/a_27_47# dc_inst.x1.net7 0
C638 dc_inst.x3.net12 dc_inst.x3.net7 0.05039f
C639 dc_inst.x2.net8 path_sel[0] 0
C640 dc_inst.x3.x1/a_27_47# dc_inst.x7.x3/a_27_47# 0.04629f
C641 dc_inst.x9/a_1478_413# _23_/a_193_47# 0
C642 dc_inst.x3.net16 dc_inst.x3.x17/a_27_47# 0.01982f
C643 dc_inst.x1.x20/a_27_47# path_sel[2] 0.01621f
C644 dc_inst.x2.net13 dc_inst.x2.x14/a_27_47# 0.04469f
C645 path[0] dc_inst.x5.x11/a_27_47# 0
C646 path_sel[1] path_sel[2] 0.54461f
C647 dc_inst.net3 dc_inst.x1.x16/a_27_47# 0
C648 dc_inst.x7.x17/a_27_47# dc_inst.x9/a_750_97# 0
C649 dc_inst.x3.x14/a_27_47# path[7] 0
C650 capture_d dc_inst.x8/a_247_21# 0
C651 _04_ _09_ 0
C652 dc_inst.net4 dc_inst.x4.x5/a_27_47# 0
C653 dc_inst.x6.net11 dc_inst.x6.net1 0.27556f
C654 dc_inst.x1.net12 dc_inst.x1.net16 0
C655 dc_inst.x8/a_834_97# dc_inst.net2 0.00486f
C656 dc_inst.x5.net17 dc_inst.x5.net16 0.00501f
C657 VPWR dc_inst.x7.x15/a_27_47# -0.00881f
C658 dc_inst.x3.x17/a_27_47# dc_inst.in 0
C659 dc_inst.x5.net7 dc_inst.x2.x7/a_27_47# 0.00227f
C660 dc_inst.x4.x16/a_27_47# dc_inst.x4.x14/a_27_47# 0.02448f
C661 dc_inst.x1.x15/a_27_47# _15_/a_27_47# 0
C662 _13_/a_112_47# _00_ 0
C663 _03_ _25_/a_193_47# -0.00248f
C664 dc_inst.x2.net19 dc_inst.x8/a_277_47# 0
C665 path_sel[1] dc_inst.x6.x7/a_27_47# 0.00736f
C666 dc_inst.x6.x9/a_27_47# dc_inst.x6.net1 0.03171f
C667 dc_inst.net6 dc_inst.x6.net1 0
C668 dc_inst.x7.net6 dc_inst.x7.x5/a_27_47# 0.00216f
C669 dc_inst.x7.net7 dc_inst.net5 0
C670 dc_inst.x3.net13 dc_inst.x3.x6/a_27_47# 0.00878f
C671 dc_inst.x10/a_535_374# rst 0.00106f
C672 dc_inst.x8/a_1478_413# dc_inst.x8/a_277_47# -0.00884f
C673 dc_inst.x8/a_750_97# dc_inst.x8/a_757_363# -0.00705f
C674 dc_inst.x6.net14 dc_inst.x6.net3 0
C675 dc_inst.x4.net16 dc_inst.x4.x11/a_27_47# 0.00838f
C676 dc_inst.x4.net5 dc_inst.x1.net14 0
C677 dc_inst.x4.net18 dc_inst.x4.net16 0
C678 dc_inst.x5.net2 dc_inst.x6.net6 0.09492f
C679 dc_inst.x4.net8 dc_inst.x6.net7 0
C680 dc_inst.x5.net6 dc_inst.x2.x14/a_27_47# 0.00177f
C681 VPWR dc_inst.x3.net8 0.03333f
C682 _13_/a_112_47# dc_inst.x3.x7/a_27_47# 0.00283f
C683 dc_inst.x7.net14 _00_ -0
C684 dc_inst.x4.net6 dc_inst.x6.net17 0
C685 dc_inst.x7.net7 path_sel[2] 0.00695f
C686 dc_inst.x1.x2/a_27_47# dc_inst.x1.net16 0
C687 dc_inst.x9/a_27_47# dc_inst.x7.net12 0.00235f
C688 dc_inst.x3.x13/a_27_47# _02_ 0.00182f
C689 VPWR dc_inst.x3.x4/a_27_47# 0.00214f
C690 dc_inst.x6.x20/a_27_47# dc_inst.in 0
C691 dc_inst.x4.x17/a_27_47# dc_inst.x4.net14 0
C692 dc_inst.x1.x7/a_27_47# path_sel[2] 0.00563f
C693 dc_inst.x1.x4/a_27_47# dc_inst.x1.x15/a_27_47# 0.01013f
C694 VPWR dc_inst.x2.net19 0.00996f
C695 dc_inst.x2.net15 dc_inst.x1.x9/a_27_47# 0
C696 dc_inst.x1.net7 _19_/a_465_47# 0
C697 dc_inst.x1.x5/a_27_47# dc_inst.x1.net6 0.00873f
C698 dc_inst.x7.x9/a_27_47# dc_inst.x7.net13 0
C699 dc_inst.x3.net5 _13_/a_470_297# 0
C700 VPWR dc_inst.x8/a_1478_413# -0.0104f
C701 dc_inst.x4.net14 dc_inst.x5.net12 0.00132f
C702 dc_inst.x6.x6/a_27_47# dc_inst.x6.net7 0.00338f
C703 dc_inst.x7.net7 dc_inst.x6.x7/a_27_47# 0
C704 dc_inst.x5.x12/a_27_47# path[3] 0
C705 dc_inst.x1.x16/a_27_47# dc_inst.x2.net9 0
C706 VPWR dc_inst.x4.x19/a_27_47# 0.00205f
C707 dc_inst.x7.net14 clknet_1_0__leaf_clk 0
C708 dc_inst.x5.net5 dc_inst.x5.x3/a_27_47# 0.04132f
C709 dc_inst.x6.x14/a_27_47# dc_inst.x1.net18 0
C710 dc_inst.x2.x20/a_27_47# dc_inst.x2.net15 0
C711 _24_/a_27_47# capture_q 0
C712 dc_inst.x5.net12 dc_inst.x2.x13/a_27_47# 0.11211f
C713 delay_sel[0] dc_inst.x7.net6 0.00126f
C714 dc_inst.x5.net19 dc_inst.x7.x19/a_27_47# 0
C715 _23_/a_1283_21# _00_ 0
C716 dc_inst.x6.net10 dc_inst.x6.net1 0.18548f
C717 path_sel[1] dc_inst.x6.net11 0.00188f
C718 dc_inst.x7.net4 dc_inst.x5.x20/a_27_47# 0.00106f
C719 delay_sel[0] _23_/a_543_47# 0.00163f
C720 dc_inst.x3.x17/a_27_47# path[6] 0.00161f
C721 dc_inst.x5.net6 dc_inst.x5.net19 0
C722 dc_inst.x2.x9/a_27_47# dc_inst.x5.x3/a_27_47# 0.01224f
C723 dc_inst.x6.x8/a_27_47# dc_inst.x6.x3/a_27_47# 0
C724 _24_/a_1283_21# dc_inst.x3.x17/a_27_47# 0
C725 dc_inst.x2.x4/a_27_47# dc_inst.x1.net16 0
C726 dc_inst.x4.x10/a_27_47# dc_inst.x2.net12 0
C727 dc_inst.x6.x19/a_27_47# dc_inst.in 0
C728 dc_inst.x6.x9/a_27_47# path_sel[1] 0.00294f
C729 dc_inst.x2.x2/a_27_47# dc_inst.x5.net12 0
C730 dc_inst.x3.net5 dc_inst.x3.net4 0.00504f
C731 dc_inst.x7.net4 dc_inst.x1.x20/a_27_47# 0
C732 dc_inst.x10/a_76_199# dc_inst.x7.net3 0.06622f
C733 VPWR dc_inst.x4.x4/a_27_47# 0.05217f
C734 dc_inst.x6.x18/a_27_47# dc_inst.x2.net18 0
C735 _24_/a_193_47# capture_d -0.00973f
C736 VPWR _25_/a_651_413# 0
C737 dc_inst.x1.net10 dc_inst.x2.net10 0
C738 dc_inst.x3.net7 shadow_q 0
C739 dc_inst.x3.net8 dc_inst.x3.x5/a_27_47# 0.00124f
C740 dc_inst.x3.net2 dc_inst.x3.net4 0.00644f
C741 dc_inst.x1.x20/a_27_47# dc_inst.x1.net17 0.04484f
C742 dc_inst.x1.net11 _19_/a_205_47# 0
C743 path[5] dc_inst.x3.net8 0.0178f
C744 dc_inst.x4.net11 dc_inst.x4.net17 0
C745 path_sel[0] dc_inst.x1.net6 0.03547f
C746 dc_inst.x3.net17 dc_inst.x3.x17/a_27_47# 0.00875f
C747 path_sel[1] dc_inst.x1.net17 0.00212f
C748 _10_ dc_inst.x3.x14/a_27_47# 0
C749 dc_inst.net7 dc_inst.x9/a_668_97# 0.00572f
C750 path[5] dc_inst.x3.x4/a_27_47# 0.00127f
C751 delay_sel[0] dc_inst.x9/a_834_97# 0
C752 dc_inst.net4 dc_inst.x4.x12/a_27_47# 0
C753 _20_/a_470_297# _04_ 0
C754 dc_inst.x7.x17/a_27_47# dc_inst.x9/a_277_47# 0
C755 dc_inst.x1.x1/a_27_47# path[7] 0
C756 dc_inst.x2.net14 dc_inst.x2.x13/a_27_47# 0.00471f
C757 dc_inst.net1 dc_inst.x1.x20/a_27_47# 0.01484f
C758 dc_inst.x1.net15 dc_inst.x1.net8 0.03083f
C759 path[2] path_sel[0] 0.08748f
C760 VPWR dc_inst.x2.x16/a_27_47# 0.00253f
C761 dc_inst.x7.x17/a_27_47# delay_sel[2] 0
C762 clknet_0_clk dc_inst.x7.net11 0
C763 dc_inst.x6.net13 delay_sel[1] 0
C764 path_sel[1] dc_inst.net1 0.00153f
C765 dc_inst.net6 dc_inst.x7.net7 0
C766 dc_inst.x7.net2 dc_inst.x7.net6 0
C767 dc_inst.x1.x13/a_27_47# dc_inst.x2.net17 0
C768 dc_inst.net3 _24_/a_761_289# 0
C769 dc_inst.x5.x9/a_27_47# path[1] 0
C770 dc_inst.x4.x19/a_27_47# dc_inst.x6.net6 0.01149f
C771 dc_inst.x1.net1 _18_/a_505_21# 0
C772 dc_inst.x7.x8/a_27_47# dc_inst.x7.net10 0
C773 dc_inst.x2.x14/a_27_47# path_sel[2] 0.00201f
C774 delay_sel[0] tdo 0.02259f
C775 VPWR dc_inst.x5.net5 0.0253f
C776 path[0] dc_inst.x1.net6 0
C777 dc_inst.x2.x2/a_27_47# dc_inst.x2.net14 0
C778 dc_inst.x1.net4 _15_/a_27_47# 0.02033f
C779 dc_inst.net2 _15_/a_1060_369# 0
C780 dc_inst.x5.net9 dc_inst.x5.x3/a_27_47# 0.02959f
C781 dc_inst.x7.net6 dc_inst.x7.net1 0.00244f
C782 path_sel[1] dc_inst.x2.net2 0.00495f
C783 dc_inst.x4.x9/a_27_47# dc_inst.x6.net7 0
C784 dc_inst.x2.net6 dc_inst.x2.net5 0.28453f
C785 VPWR dc_inst.x1.net15 0.57728f
C786 _10_ path[7] 0
C787 dc_inst.x6.net17 dc_inst.x6.x19/a_27_47# 0
C788 dc_inst.x3.net16 dc_inst.x3.x13/a_27_47# 0
C789 dc_inst.x6.net4 dc_inst.net5 0
C790 dc_inst.x7.net5 dc_inst.x6.net1 0
C791 path_sel[1] dc_inst.x6.net10 0.0038f
C792 dc_inst.x4.net7 dc_inst.x4.x10/a_27_47# 0
C793 VPWR dc_inst.x2.x9/a_27_47# 0
C794 VPWR _25_/a_193_47# 0.00104f
C795 dc_inst.x3.net9 _00_ 0
C796 dc_inst.x7.net11 clkbuf_0_clk/a_110_47# 0.00154f
C797 dc_inst.x3.x14/a_27_47# _15_/a_872_316# 0
C798 dc_inst.x5.net7 dc_inst.x1.net18 0.00645f
C799 path[0] path[2] 0.00687f
C800 dc_inst.x7.x17/a_27_47# dc_inst.x7.net17 0.00726f
C801 dc_inst.x4.net16 dc_inst.x4.net7 0
C802 path_sel[1] dc_inst.x5.x9/a_27_47# 0.00437f
C803 dc_inst.x2.x7/a_27_47# dc_inst.x1.net19 0
C804 dc_inst.x3.net10 dc_inst.x3.net13 0.01406f
C805 dc_inst.x1.x7/a_27_47# dc_inst.x1.net17 0
C806 clkbuf_1_0__f_clk/a_110_47# clknet_0_clk 0.01301f
C807 dc_inst.x5.net19 dc_inst.net5 0.0088f
C808 dc_inst.x7.net2 dc_inst.x9/a_834_97# 0
C809 dc_inst.x6.x17/a_27_47# dc_inst.x6.net19 0
C810 dc_inst.x4.net2 path_sel[0] 0
C811 dc_inst.x1.x13/a_27_47# dc_inst.x5.net11 0
C812 dc_inst.x6.net4 path_sel[2] 0.01816f
C813 tdo _23_/a_448_47# 0.00342f
C814 dc_inst.x5.net6 dc_inst.x4.x10/a_27_47# 0
C815 dc_inst.x7.x7/a_27_47# dc_inst.x7.net6 0.0033f
C816 dc_inst.net8 dc_inst.x3.net3 0.02685f
C817 dc_inst.x1.net2 dc_inst.x3.x2/a_27_47# 0
C818 VPWR dc_inst.x2.net3 0.07998f
C819 dc_inst.x1.net4 dc_inst.x1.x8/a_27_47# 0.00606f
C820 dc_inst.x7.net4 dc_inst.x7.x16/a_27_47# 0
C821 dc_inst.x1.x4/a_27_47# dc_inst.x1.net4 0.01573f
C822 dc_inst.x4.net16 dc_inst.x5.net6 0.01059f
C823 dc_inst.x9/a_834_97# dc_inst.x7.net1 0
C824 dc_inst.x5.net19 path_sel[2] 0.04733f
C825 dc_inst.x7.net2 tdo 0.1285f
C826 clkbuf_1_0__f_clk/a_110_47# clkbuf_0_clk/a_110_47# 0.00337f
C827 _15_/a_872_316# path[7] 0.05277f
C828 dc_inst.x6.net12 dc_inst.x6.net3 0.00342f
C829 dc_inst.x3.x20/a_27_47# path_sel[0] 0.01126f
C830 dc_inst.x6.net4 dc_inst.x6.x7/a_27_47# 0
C831 _20_/a_470_297# dc_inst.x1.net5 0
C832 _20_/a_384_47# dc_inst.x3.net1 0
C833 dc_inst.x1.x3/a_27_47# delay_sel[1] 0
C834 dc_inst.x4.net5 delay_sel[1] 0
C835 tdo dc_inst.x7.net1 0
C836 VPWR dc_inst.x2.x1/a_27_47# -0
C837 dc_inst.net2 dc_inst.x8/a_277_47# 0.115f
C838 dc_inst.x4.x17/a_27_47# dc_inst.x5.x6/a_27_47# 0
C839 _23_/a_27_47# _00_ 0
C840 dc_inst.x2.net5 dc_inst.x2.net12 0.00377f
C841 clkbuf_1_1__f_clk/a_110_47# capture_q 0.02509f
C842 clknet_0_clk dc_inst.net9 0
C843 dc_inst.x1.x6/a_27_47# dc_inst.x1.net6 0.05353f
C844 dc_inst.x7.net5 dc_inst.x5.x20/a_27_47# 0
C845 VPWR dc_inst.x5.net9 0.75905f
C846 path_sel[0] dc_inst.x5.net10 0.00313f
C847 dc_inst.x7.net6 dc_inst.x7.net18 0
C848 dc_inst.x3.net13 path_sel[0] 0.00214f
C849 dc_inst.x4.net15 dc_inst.x5.x7/a_27_47# 0
C850 dc_inst.x6.net14 dc_inst.x1.net18 0
C851 clknet_1_0__leaf_clk _23_/a_27_47# 0.01449f
C852 dc_inst.x5.x15/a_27_47# dc_inst.x6.net8 0
C853 dc_inst.x1.x6/a_27_47# path[2] 0.00101f
C854 dc_inst.x2.net18 dc_inst.x2.x19/a_27_47# 0.05126f
C855 dc_inst.x2.net11 dc_inst.x2.net6 0.00394f
C856 dc_inst.x5.x7/a_27_47# dc_inst.x5.net8 0.01298f
C857 dc_inst.x3.net2 path_sel[2] 0
C858 VPWR dc_inst.net2 0.20633f
C859 dc_inst.x5.net7 dc_inst.x6.x10/a_27_47# 0
C860 dc_inst.x9/a_27_413# delay_sel[1] 0
C861 clkbuf_1_0__f_clk/a_110_47# dc_inst.x7.x15/a_27_47# 0.00506f
C862 dc_inst.x5.net12 dc_inst.x5.net13 0.01915f
C863 dc_inst.x3.net6 dc_inst.x3.net18 0.00133f
C864 VPWR _16_/a_27_93# 0.04319f
C865 dc_inst.x8/a_193_413# dc_inst.x9/a_1290_413# 0
C866 dc_inst.x3.x13/a_27_47# path[6] 0
C867 dc_inst.x5.net18 dc_inst.x6.x8/a_27_47# 0
C868 dc_inst.x2.net5 dc_inst.x2.net13 0.04819f
C869 dc_inst.x6.net4 dc_inst.x6.net11 0
C870 dc_inst.x5.net3 dc_inst.x5.net1 0
C871 path_sel[1] dc_inst.x4.x8/a_27_47# 0.00664f
C872 dc_inst.x7.net4 _23_/a_193_47# 0
C873 dc_inst.x1.net10 _19_/a_193_297# 0
C874 dc_inst.x9/a_750_97# clknet_0_clk 0
C875 delay_sel[0] dc_inst.x7.net3 0
C876 dc_inst.x5.net12 dc_inst.x5.x2/a_27_47# 0.00135f
C877 dc_inst.x5.net19 dc_inst.x6.net11 0
C878 dc_inst.x9/a_834_97# dc_inst.x7.x18/a_27_47# 0
C879 tdo dc_inst.x7.net18 0
C880 dc_inst.x4.net13 dc_inst.x2.net7 0
C881 dc_inst.x2.x15/a_27_47# dc_inst.x1.x9/a_27_47# 0.03162f
C882 se clknet_0_clk 0
C883 VPWR dc_inst.x2.x10/a_27_47# -0.00264f
C884 dc_inst.x4.x10/a_27_47# path_sel[2] 0
C885 dc_inst.x3.x11/a_27_47# path[7] 0.0016f
C886 path[4] dc_inst.in 0
C887 dc_inst.x5.net14 dc_inst.x6.net8 0.00798f
C888 dc_inst.x4.net13 dc_inst.x2.net10 0
C889 dc_inst.x4.net16 path_sel[2] 0.00124f
C890 dc_inst.net6 dc_inst.x5.net19 0
C891 dc_inst.x9/a_750_97# dc_inst.x6.net19 0
C892 dc_inst.x4.net15 dc_inst.net4 0
C893 dc_inst.x2.net2 dc_inst.x2.x14/a_27_47# 0
C894 dc_inst.x2.net11 dc_inst.x2.net12 0.25259f
C895 dc_inst.x6.x9/a_27_47# dc_inst.x5.net19 0.00182f
C896 dc_inst.x6.x8/a_27_47# dc_inst.x7.net1 0
C897 VPWR _24_/a_1108_47# -0.01283f
C898 dc_inst.x5.net6 dc_inst.x2.net5 0.02452f
C899 dc_inst.x3.x9/a_27_47# dc_inst.x3.x13/a_27_47# 0
C900 path_sel[1] dc_inst.x5.x8/a_27_47# 0.00395f
C901 dc_inst.x7.x18/a_27_47# tdo 0
C902 dc_inst.x4.net2 tdo 0
C903 path[1] _18_/a_505_21# 0
C904 dc_inst.x7.net4 dc_inst.x5.net19 0.00625f
C905 dc_inst.x3.net7 dc_inst.x3.net6 0.35229f
C906 dc_inst.x2.x20/a_27_47# dc_inst.x2.x15/a_27_47# 0
C907 dc_inst.x8/a_193_47# VPWR -0
C908 dc_inst.x4.x11/a_27_47# dc_inst.x4.x12/a_27_47# 0
C909 dc_inst.net1 _23_/a_193_47# 0
C910 dc_inst.x1.net10 _08_ 0
C911 dc_inst.x1.x20/a_27_47# dc_inst.x1.x18/a_27_47# 0.01771f
C912 _10_ _15_/a_872_316# 0
C913 dc_inst.x3.net4 dc_inst.x3.x3/a_27_47# 0.03666f
C914 dc_inst.x1.net1 dc_inst.x5.x12/a_27_47# 0.00144f
C915 capture_d delay_sel[1] 0
C916 path_sel[1] dc_inst.x1.x18/a_27_47# 0
C917 dc_inst.x2.x3/a_27_47# dc_inst.x5.net7 0.00188f
C918 dc_inst.x1.net11 path[7] 0
C919 dc_inst.net2 path[5] 0
C920 dc_inst.x4.net7 dc_inst.x4.x5/a_27_47# 0.02511f
C921 dc_inst.x1.net18 dc_inst.x1.net19 0.0414f
C922 dc_inst.x5.net3 dc_inst.x4.net5 0
C923 _15_/a_1064_47# dc_inst.x1.net2 0
C924 dc_inst.x8/a_750_97# dc_inst.x1.net3 0
C925 dc_inst.x5.net3 dc_inst.x5.x17/a_27_47# 0
C926 dc_inst.x2.x11/a_27_47# dc_inst.x2.net6 0.00198f
C927 dc_inst.x5.net12 dc_inst.x5.x3/a_27_47# 0.00212f
C928 dc_inst.x6.x5/a_27_47# dc_inst.x6.net2 0
C929 dc_inst.x7.net2 dc_inst.x7.net3 0.00552f
C930 dc_inst.x8/a_27_47# delay_sel[1] 0.01243f
C931 dc_inst.x1.x15/a_27_47# dc_inst.x1.net15 0.0021f
C932 _14_/a_76_199# dc_inst.x3.net8 0
C933 dc_inst.x7.net4 dc_inst.x3.net5 0
C934 dc_inst.x5.x5/a_27_47# dc_inst.x2.x7/a_27_47# 0
C935 dc_inst.x3.net10 dc_inst.x3.net9 0.00165f
C936 dc_inst.net3 _23_/a_1108_47# 0
C937 dc_inst.x5.net6 dc_inst.x4.x5/a_27_47# 0.07088f
C938 dc_inst.x2.net11 dc_inst.x2.net13 0
C939 dc_inst.x7.net3 dc_inst.x7.net1 0
C940 clkbuf_1_0__f_clk/a_110_47# _25_/a_651_413# 0
C941 dc_inst.x7.net4 dc_inst.x3.net2 0.00409f
C942 dc_inst.x4.x17/a_27_47# dc_inst.x4.x20/a_27_47# 0.00817f
C943 VPWR dc_inst.x7.net10 0.10272f
C944 dc_inst.x4.net9 dc_inst.x2.net3 0
C945 dc_inst.x2.net17 dc_inst.x2.net18 0.00682f
C946 dc_inst.x4.net6 dc_inst.x4.net8 0.01298f
C947 dc_inst.x5.net12 dc_inst.x4.x20/a_27_47# 0
C948 dc_inst.x4.net10 dc_inst.x4.net5 0
C949 path_sel[1] dc_inst.x2.net9 0.0223f
C950 dc_inst.x6.net10 dc_inst.x5.net19 0
C951 dc_inst.x1.net4 dc_inst.x3.x4/a_27_47# 0
C952 path[4] path[6] 0
C953 dc_inst.x7.net11 _25_/a_193_47# 0.00191f
C954 dc_inst.x1.net4 dc_inst.x2.net19 0
C955 dc_inst.x6.net18 dc_inst.x2.x20/a_27_47# 0
C956 dc_inst.x8/a_834_97# _24_/a_27_47# 0
C957 dc_inst.x1.net4 dc_inst.x8/a_1478_413# 0
C958 dc_inst.x6.x5/a_27_47# dc_inst.x4.x20/a_27_47# 0
C959 dc_inst.x7.x10/a_27_47# dc_inst.in 0
C960 dc_inst.x4.x6/a_27_47# tdo 0.00826f
C961 _14_/a_505_21# _02_ 0.04491f
C962 dc_inst.x4.x1/a_27_47# dc_inst.x2.net18 0.00602f
C963 dc_inst.x5.net2 dc_inst.x6.net7 0.0356f
C964 dc_inst.x2.x11/a_27_47# dc_inst.x2.net12 0.00362f
C965 se dc_inst.x3.net8 0.00148f
C966 dc_inst.x3.net19 dc_inst.x3.x15/a_27_47# 0
C967 dc_inst.x8/a_193_413# dc_inst.net8 0.0011f
C968 dc_inst.x5.net11 dc_inst.x2.x13/a_27_47# 0.00166f
C969 dc_inst.x7.net13 delay_sel[1] 0.13221f
C970 dc_inst.x1.net7 dc_inst.x1.x12/a_27_47# 0.14989f
C971 dc_inst.x4.x17/a_27_47# VPWR 0.02493f
C972 dc_inst.x3.x19/a_27_47# dc_inst.x3.net18 0.13315f
C973 dc_inst.x6.x10/a_27_47# dc_inst.x1.net19 0
C974 dc_inst.x3.net9 path_sel[0] 0
C975 clkbuf_1_0__f_clk/a_110_47# _25_/a_193_47# 0.00878f
C976 dc_inst.x4.net18 dc_inst.x5.net14 0
C977 VPWR dc_inst.x5.net12 0.16255f
C978 dc_inst.x6.net12 dc_inst.x1.net18 0
C979 dc_inst.x2.net5 path_sel[2] 0.00109f
C980 dc_inst.x5.net3 dc_inst.x4.net17 0.03608f
C981 dc_inst.x4.x10/a_27_47# dc_inst.x1.net17 0
C982 dc_inst.x9/a_277_47# clknet_0_clk 0
C983 dc_inst.x3.net19 dc_inst.x3.net1 0
C984 VPWR dc_inst.x6.x5/a_27_47# 0.01404f
C985 dc_inst.x3.net4 shadow_q 0
C986 dc_inst.x3.x9/a_27_47# path[4] 0
C987 clknet_0_clk delay_sel[2] 0.02628f
C988 VPWR dc_inst.x6.x18/a_27_47# 0.06714f
C989 dc_inst.x7.net3 dc_inst.x7.net18 0
C990 dc_inst.net1 dc_inst.x4.x10/a_27_47# 0
C991 dc_inst.x2.net14 dc_inst.x1.net8 0
C992 dc_inst.x8/a_27_413# path_sel[2] 0
C993 dc_inst.x7.net5 dc_inst.x5.net19 0
C994 dc_inst.x2.x11/a_27_47# dc_inst.x2.net13 0
C995 dc_inst.x1.x14/a_27_47# dc_inst.x1.net16 0
C996 dc_inst.x1.net11 _10_ 0.10421f
C997 delay_sel[2] clkbuf_0_clk/a_110_47# 0.02098f
C998 delay_sel[1] _25_/a_761_289# 0
C999 dc_inst.x3.net14 dc_inst.x3.net18 0
C1000 dc_inst.x7.x18/a_27_47# dc_inst.x7.net3 0.00142f
C1001 dc_inst.x4.net3 tdo 0
C1002 dc_inst.x2.net2 dc_inst.x4.x10/a_27_47# 0.00182f
C1003 clknet_0_clk dc_inst.x7.net17 0.01442f
C1004 dc_inst.x4.net2 dc_inst.x7.net3 0
C1005 dc_inst.x4.x5/a_27_47# path_sel[2] 0.00459f
C1006 VPWR dc_inst.x2.net14 0.17534f
C1007 dc_inst.x7.net15 rst 0
C1008 dc_inst.x3.x19/a_27_47# dc_inst.x3.net7 0
C1009 dc_inst.x1.net13 path_sel[1] 0
C1010 path[3] _18_/a_439_47# 0
C1011 dc_inst.x2.net10 _07_ 0
C1012 _03_ _24_/a_27_47# 0.0033f
C1013 dc_inst.x7.net17 clkbuf_0_clk/a_110_47# 0
C1014 dc_inst.x4.x17/a_27_47# dc_inst.x6.net6 0
C1015 dc_inst.net3 _23_/a_193_47# 0.00125f
C1016 dc_inst.x1.net4 dc_inst.x1.net15 0
C1017 dc_inst.x5.net12 dc_inst.x6.net6 0
C1018 dc_inst.x2.x3/a_27_47# dc_inst.x1.net19 0
C1019 dc_inst.x1.net11 _15_/a_872_316# 0
C1020 dc_inst.x4.net18 dc_inst.x4.net15 0.23138f
C1021 dc_inst.x2.net11 path_sel[2] 0
C1022 dc_inst.x9/a_277_47# dc_inst.x7.x15/a_27_47# 0
C1023 VPWR dc_inst.x2.x8/a_27_47# 0
C1024 dc_inst.x3.net6 dc_inst.x1.net3 0
C1025 dc_inst.x1.net14 dc_inst.x1.x1/a_27_47# 0
C1026 dc_inst.x6.x5/a_27_47# dc_inst.x6.net6 0.01725f
C1027 dc_inst.net4 dc_inst.x6.net16 0.0015f
C1028 _15_/a_788_316# dc_inst.in 0
C1029 dc_inst.x1.net7 dc_inst.x1.net8 0.0134f
C1030 path_sel[1] dc_inst.x3.net19 0
C1031 dc_inst.x4.x19/a_27_47# dc_inst.x6.net7 0.00103f
C1032 dc_inst.x3.net14 dc_inst.x3.net7 0.30059f
C1033 capture_d capture_q 0
C1034 dc_inst.x1.x16/a_27_47# dc_inst.x1.net18 0
C1035 dc_inst.x6.net18 clknet_1_0__leaf_clk 0
C1036 path_sel[1] dc_inst.x5.x12/a_27_47# 0.0086f
C1037 VPWR _17_/a_27_93# 0.03047f
C1038 dc_inst.x3.net4 dc_inst.x3.x1/a_27_47# 0
C1039 dc_inst.x2.x19/a_27_47# dc_inst.x8/a_277_47# 0
C1040 dc_inst.x9/a_193_413# dc_inst.x9/a_247_21# -0.0024f
C1041 VPWR dc_inst.x1.net7 0.03565f
C1042 dc_inst.x3.net7 dc_inst.x3.x8/a_27_47# 0.00109f
C1043 dc_inst.x1.net9 _04_ 0
C1044 _15_/a_372_413# dc_inst.net2 0
C1045 dc_inst.x7.x15/a_27_47# dc_inst.x7.net17 0
C1046 dc_inst.x4.net1 dc_inst.x2.net8 0
C1047 dc_inst.x1.x4/a_27_47# dc_inst.x4.net4 0
C1048 dc_inst.x9/a_247_21# dc_inst.x6.x4/a_27_47# 0
C1049 path[4] _15_/a_600_345# 0
C1050 dc_inst.x4.net4 dc_inst.x1.x8/a_27_47# 0
C1051 dc_inst.x3.x4/a_27_47# delay_sel[2] 0
C1052 dc_inst.x7.x1/a_27_47# dc_inst.x6.net1 0
C1053 dc_inst.x1.net10 dc_inst.x2.x5/a_27_47# 0
C1054 dc_inst.x4.x5/a_27_47# dc_inst.x6.net11 0
C1055 dc_inst.net8 _01_ 0
C1056 clknet_0_clk _25_/a_1283_21# 0.03803f
C1057 dc_inst.x8/a_1290_413# dc_inst.net8 0.04316f
C1058 dc_inst.x7.net4 dc_inst.x8/a_27_413# 0
C1059 dc_inst.net3 dc_inst.x3.net2 0.07208f
C1060 dc_inst.x2.net17 dc_inst.x1.x12/a_27_47# 0
C1061 dc_inst.x5.net16 dc_inst.x4.net11 0
C1062 dc_inst.x8/a_27_413# dc_inst.x1.net17 0
C1063 dc_inst.x7.net14 dc_inst.x7.net3 0
C1064 tdi _00_ 0
C1065 VPWR dc_inst.x2.x19/a_27_47# 0
C1066 dc_inst.x1.x19/a_27_47# dc_inst.x1.net18 0.03428f
C1067 clknet_0_clk _25_/a_805_47# 0
C1068 dc_inst.x1.net4 dc_inst.net2 0.02064f
C1069 tdo dc_inst.x2.net15 0
C1070 dc_inst.x2.net2 dc_inst.x2.net5 0
C1071 dc_inst.x9/a_1290_413# dc_inst.in 0
C1072 clkbuf_0_clk/a_110_47# _25_/a_1283_21# 0.02393f
C1073 dc_inst.x4.x17/a_27_47# dc_inst.x4.net9 0
C1074 dc_inst.x4.net2 dc_inst.x2.x18/a_27_47# 0
C1075 dc_inst.net8 _02_ 0
C1076 dc_inst.x4.x5/a_27_47# dc_inst.x1.net17 0
C1077 tdi dc_inst.x3.x7/a_27_47# 0
C1078 _04_ dc_inst.x1.net3 0.04258f
C1079 dc_inst.x4.net16 dc_inst.x4.x8/a_27_47# 0.00526f
C1080 dc_inst.x6.net2 dc_inst.x6.x16/a_27_47# 0
C1081 _15_/a_288_47# path[7] 0.03458f
C1082 dc_inst.x4.net9 dc_inst.x5.net12 0
C1083 dc_inst.net1 dc_inst.x8/a_27_413# 0.01733f
C1084 _24_/a_27_47# dc_inst.x8/a_277_47# 0
C1085 dc_inst.x7.net6 dc_inst.x6.net9 0
C1086 dc_inst.x4.x12/a_27_47# path_sel[2] 0
C1087 dc_inst.x4.net12 dc_inst.x6.net1 0
C1088 dc_inst.x2.x11/a_27_47# path_sel[2] 0
C1089 tdo _23_/a_27_47# 0.04334f
C1090 dc_inst.x5.net9 dc_inst.x4.x14/a_27_47# 0
C1091 dc_inst.x5.x20/a_27_47# dc_inst.x6.net3 0
C1092 dc_inst.x4.net3 dc_inst.x7.net3 0
C1093 dc_inst.x8/a_750_97# path_sel[2] 0
C1094 delay_sel[0] dc_inst.x10/a_76_199# 0
C1095 dc_inst.x9/a_247_21# dc_inst.x7.net13 0
C1096 dc_inst.x8/a_193_47# dc_inst.net9 0.00117f
C1097 dc_inst.x8/a_668_97# delay_sel[1] 0
C1098 dc_inst.net1 dc_inst.x4.x5/a_27_47# 0.00371f
C1099 dc_inst.x1.net9 dc_inst.x1.net5 0.00487f
C1100 delay_sel[2] _25_/a_651_413# 0
C1101 dc_inst.x7.net3 _23_/a_1283_21# 0
C1102 dc_inst.x2.net1 path_sel[0] 0
C1103 dc_inst.x1.net10 dc_inst.x1.net12 0
C1104 clkbuf_1_0__f_clk/a_110_47# dc_inst.x7.net10 0
C1105 dc_inst.x3.x20/a_27_47# dc_inst.x3.x2/a_27_47# 0
C1106 dc_inst.x4.net5 dc_inst.x2.net18 0
C1107 _14_/a_505_21# path[6] 0.00863f
C1108 dc_inst.net7 dc_inst.x7.net15 0
C1109 dc_inst.x4.net16 dc_inst.x5.x8/a_27_47# 0
C1110 dc_inst.x7.x13/a_27_47# delay_sel[0] 0.04267f
C1111 path_sel[1] dc_inst.x6.net3 0
C1112 dc_inst.x2.x2/a_27_47# dc_inst.x4.net5 0
C1113 VPWR _24_/a_27_47# 0.07211f
C1114 dc_inst.x5.x15/a_27_47# path_sel[2] 0
C1115 dc_inst.x6.net10 dc_inst.x4.x5/a_27_47# 0
C1116 _15_/a_788_316# dc_inst.x3.x9/a_27_47# 0
C1117 rst _00_ 0.13068f
C1118 dc_inst.x5.net7 path_sel[0] 0.00188f
C1119 dc_inst.x4.net7 dc_inst.x5.net8 0
C1120 dc_inst.x6.net17 dc_inst.x9/a_1290_413# 0
C1121 _07_ _19_/a_193_297# 0.00759f
C1122 dc_inst.x2.net17 dc_inst.x8/a_277_47# 0
C1123 dc_inst.x3.x7/a_27_47# rst 0
C1124 dc_inst.x4.net15 dc_inst.x5.net6 0
C1125 dc_inst.x3.x19/a_27_47# dc_inst.x1.net3 0
C1126 dc_inst.x2.net7 dc_inst.x5.x10/a_27_47# 0
C1127 dc_inst.x1.net5 dc_inst.x1.net3 0.20478f
C1128 dc_inst.x9/a_247_21# _25_/a_761_289# 0
C1129 clknet_1_0__leaf_clk rst 0.14965f
C1130 dc_inst.x9/a_277_47# _25_/a_193_47# 0
C1131 dc_inst.x5.net6 dc_inst.x5.net8 0.00884f
C1132 dc_inst.x2.net10 dc_inst.x5.x10/a_27_47# 0
C1133 _14_/a_218_47# path[6] 0.00108f
C1134 dc_inst.x7.net7 dc_inst.x6.net3 0.01044f
C1135 dc_inst.x1.net8 dc_inst.x2.net17 0.02697f
C1136 clknet_1_1__leaf_clk _00_ 0.18198f
C1137 delay_sel[2] _25_/a_193_47# 0.00113f
C1138 dc_inst.x4.net14 dc_inst.x4.net17 0.05279f
C1139 dc_inst.x5.x5/a_27_47# dc_inst.x2.x3/a_27_47# 0
C1140 dc_inst.x7.x1/a_27_47# dc_inst.x7.net7 0
C1141 path_sel[1] dc_inst.x4.net12 0.03333f
C1142 VPWR dc_inst.x6.x16/a_27_47# -0.00415f
C1143 path_sel[1] dc_inst.x2.x7/a_27_47# 0.01307f
C1144 dc_inst.x5.x6/a_27_47# dc_inst.x6.net13 0
C1145 dc_inst.x6.x14/a_27_47# tdo 0.00367f
C1146 _15_/a_288_47# dc_inst.x1.x1/a_27_47# 0
C1147 dc_inst.x5.net14 path_sel[2] 0
C1148 dc_inst.net4 dc_inst.x7.net19 0
C1149 _08_ _07_ 0.45869f
C1150 dc_inst.x7.x13/a_27_47# dc_inst.x7.net1 0
C1151 _25_/a_27_47# _25_/a_448_47# -0.00297f
C1152 dc_inst.x1.x11/a_27_47# path_sel[0] 0.00436f
C1153 VPWR dc_inst.x2.net17 0.17118f
C1154 _25_/a_27_47# dc_inst.x7.net12 0.10783f
C1155 dc_inst.x7.net6 dc_inst.x7.x6/a_27_47# 0.01693f
C1156 dc_inst.x7.net17 _25_/a_193_47# 0
C1157 _14_/a_505_21# _05_ 0.00385f
C1158 dc_inst.x3.net14 dc_inst.x1.net3 0.03769f
C1159 dc_inst.x3.net16 dc_inst.net8 0
C1160 dc_inst.x3.net13 dc_inst.x3.net11 0.42382f
C1161 dc_inst.x1.net10 dc_inst.x2.x4/a_27_47# 0
C1162 dc_inst.x5.net14 dc_inst.x6.x7/a_27_47# 0
C1163 tdo dc_inst.x6.net15 0.02694f
C1164 dc_inst.x1.net8 dc_inst.x5.net11 0.00303f
C1165 dc_inst.x6.x3/a_27_47# dc_inst.x7.net1 0
C1166 dc_inst.x7.net9 dc_inst.x7.net10 0.0053f
C1167 dc_inst.x7.net4 dc_inst.x8/a_750_97# 0.02528f
C1168 delay_sel[0] dc_inst.x7.x5/a_27_47# 0.00932f
C1169 dc_inst.x6.x18/a_27_47# dc_inst.net9 0
C1170 dc_inst.net8 dc_inst.in 0.02711f
C1171 dc_inst.x1.net13 dc_inst.x3.net2 0
C1172 dc_inst.x4.net3 dc_inst.x2.x18/a_27_47# 0.01317f
C1173 dc_inst.x1.x15/a_27_47# dc_inst.x1.net7 0.01236f
C1174 dc_inst.x4.x1/a_27_47# VPWR 0.01817f
C1175 dc_inst.x5.x17/a_27_47# dc_inst.x7.x8/a_27_47# 0
C1176 dc_inst.x4.net2 dc_inst.x1.net2 0
C1177 dc_inst.x2.x3/a_27_47# dc_inst.x1.x19/a_27_47# 0.01013f
C1178 dc_inst.x3.net10 _06_ 0.00274f
C1179 VPWR dc_inst.x5.net11 0.02288f
C1180 dc_inst.x1.net1 _18_/a_439_47# 0
C1181 dc_inst.x9/a_668_97# dc_inst.x7.net16 0
C1182 dc_inst.x7.net3 _23_/a_27_47# 0
C1183 dc_inst.x3.net18 dc_inst.x3.net3 0
C1184 dc_inst.x6.net9 dc_inst.x6.x8/a_27_47# 0.04365f
C1185 dc_inst.x8/a_750_97# dc_inst.net1 0
C1186 dc_inst.x3.x20/a_27_47# dc_inst.x1.net2 0
C1187 dc_inst.net2 delay_sel[2] 0
C1188 _09_ _19_/a_193_297# 0.00899f
C1189 dc_inst.x7.x7/a_27_47# dc_inst.x6.x3/a_27_47# 0
C1190 dc_inst.x3.net19 dc_inst.x3.net5 0.21284f
C1191 _20_/a_79_21# dc_inst.x1.net6 0
C1192 dc_inst.x3.net10 tdi 0.00224f
C1193 dc_inst.net3 dc_inst.x8/a_27_413# 0
C1194 dc_inst.x7.net12 _25_/a_1217_47# 0
C1195 clkbuf_1_1__f_clk/a_110_47# VPWR -0.00132f
C1196 dc_inst.x3.net19 dc_inst.x3.net2 0.2219f
C1197 dc_inst.x6.net5 dc_inst.x6.x5/a_27_47# 0.04936f
C1198 dc_inst.x5.net7 tdo 0.20438f
C1199 dc_inst.net3 dc_inst.x3.x3/a_27_47# 0
C1200 dc_inst.x7.net2 dc_inst.x7.x5/a_27_47# 0
C1201 dc_inst.x7.net4 dc_inst.x3.x1/a_27_47# 0
C1202 dc_inst.x4.net13 dc_inst.x4.x13/a_27_47# 0.00201f
C1203 dc_inst.x4.x5/a_27_47# dc_inst.x5.x8/a_27_47# 0
C1204 dc_inst.x6.x20/a_27_47# clknet_0_clk 0
C1205 dc_inst.net7 _00_ 0
C1206 _20_/a_79_21# path[2] 0
C1207 dc_inst.x5.net15 dc_inst.x6.x2/a_27_47# 0
C1208 dc_inst.x4.net4 dc_inst.x4.x4/a_27_47# 0.02193f
C1209 dc_inst.x5.net12 dc_inst.x4.x14/a_27_47# 0
C1210 path[3] dc_inst.x1.x5/a_27_47# 0.00131f
C1211 dc_inst.x3.net14 _13_/a_470_297# 0
C1212 dc_inst.x3.x19/a_27_47# dc_inst.x3.net4 0.00173f
C1213 _08_ _09_ 0
C1214 dc_inst.x5.x17/a_27_47# dc_inst.x5.net13 0
C1215 dc_inst.x1.net4 _15_/a_193_47# 0
C1216 dc_inst.x6.x20/a_27_47# dc_inst.x6.net19 0.12444f
C1217 dc_inst.x2.net9 dc_inst.x2.net5 0
C1218 dc_inst.x7.x9/a_27_47# delay_sel[1] 0
C1219 _25_/a_193_47# _25_/a_1283_21# -0
C1220 _06_ path_sel[0] 0.23342f
C1221 dc_inst.net8 path[6] 0.00208f
C1222 dc_inst.x2.x16/a_27_47# dc_inst.x1.net16 0.11175f
C1223 _13_/a_470_297# dc_inst.x3.x8/a_27_47# 0.03087f
C1224 _24_/a_1108_47# delay_sel[2] 0.01021f
C1225 _24_/a_1283_21# dc_inst.net8 0
C1226 dc_inst.net7 clknet_1_0__leaf_clk 0
C1227 _15_/a_27_47# dc_inst.x3.x13/a_27_47# 0
C1228 dc_inst.x6.net4 dc_inst.x6.net3 0.01445f
C1229 _19_/a_27_47# dc_inst.x1.x5/a_27_47# 0
C1230 _15_/a_1281_47# path_sel[0] 0
C1231 delay_sel[1] dc_inst.x8/a_247_21# 0.27349f
C1232 dc_inst.x5.net5 dc_inst.x1.net16 0
C1233 dc_inst.x5.x4/a_27_47# dc_inst.x2.net7 0
C1234 dc_inst.x5.x3/a_27_47# dc_inst.x5.net1 0
C1235 tdo dc_inst.x2.x15/a_27_47# 0
C1236 VPWR dc_inst.x1.x10/a_27_47# 0.01655f
C1237 dc_inst.x5.x4/a_27_47# dc_inst.x2.net10 0
C1238 dc_inst.x6.net18 dc_inst.x7.net6 0
C1239 dc_inst.x1.net15 dc_inst.x1.net16 0.06214f
C1240 dc_inst.x5.net19 dc_inst.x6.net3 0.04559f
C1241 dc_inst.x1.x20/a_27_47# dc_inst.x1.net18 0.00662f
C1242 dc_inst.x3.net14 dc_inst.x3.net4 0.01044f
C1243 dc_inst.x5.x17/a_27_47# dc_inst.x5.x16/a_27_47# 0
C1244 dc_inst.x2.x9/a_27_47# dc_inst.x1.net16 0
C1245 dc_inst.x6.x10/a_27_47# dc_inst.x6.net1 0.01371f
C1246 path_sel[1] dc_inst.x1.net18 0.00153f
C1247 dc_inst.x7.x1/a_27_47# dc_inst.x5.net19 0
C1248 dc_inst.x4.net13 dc_inst.x5.x1/a_27_47# 0
C1249 dc_inst.x1.net15 dc_inst.x4.net4 0
C1250 dc_inst.x6.x19/a_27_47# dc_inst.x6.net19 0.04302f
C1251 path_sel[1] _15_/a_397_47# 0.00147f
C1252 dc_inst.x6.net14 tdo 0.2289f
C1253 path[3] path_sel[0] 0.57785f
C1254 dc_inst.x7.net2 delay_sel[0] 0.02317f
C1255 dc_inst.x7.x6/a_27_47# dc_inst.x6.x8/a_27_47# 0
C1256 dc_inst.x7.x4/a_27_47# dc_inst.in 0
C1257 dc_inst.x5.net1 _17_/a_478_47# 0
C1258 dc_inst.x4.net5 dc_inst.x6.net2 0
C1259 _04_ path_sel[2] 0.03499f
C1260 delay_sel[0] dc_inst.x7.net1 0.03034f
C1261 dc_inst.x9/a_277_47# dc_inst.x7.net10 0
C1262 dc_inst.x5.net12 dc_inst.x6.net7 0
C1263 dc_inst.x5.net3 dc_inst.x5.net16 0
C1264 dc_inst.x6.x8/a_27_47# dc_inst.x5.net7 0
C1265 dc_inst.x3.x16/a_27_47# dc_inst.x3.net7 0
C1266 dc_inst.x5.net13 dc_inst.x4.net17 0
C1267 dc_inst.x8/a_1478_413# dc_inst.x3.x17/a_27_47# 0.0126f
C1268 VPWR dc_inst.x6.net13 -0.00561f
C1269 path_sel[0] _19_/a_27_47# 0.0046f
C1270 path[0] path[3] 0
C1271 dc_inst.net3 shadow_q 0
C1272 dc_inst.x6.net18 tdo 0.04837f
C1273 dc_inst.x2.net11 dc_inst.x2.net9 0.01471f
C1274 dc_inst.x1.x15/a_27_47# dc_inst.x2.net17 0
C1275 dc_inst.x8/a_750_97# dc_inst.x4.x3/a_27_47# 0
C1276 dc_inst.x3.net11 dc_inst.x3.net9 0.20751f
C1277 VPWR dc_inst.x5.net1 0.58831f
C1278 dc_inst.net8 clkload0/a_27_47# 0
C1279 dc_inst.x9/a_757_363# dc_inst.x8/a_247_21# 0
C1280 _24_/a_761_289# _00_ 0.01877f
C1281 dc_inst.x5.x7/a_27_47# dc_inst.x2.net7 0.00101f
C1282 dc_inst.x4.net13 dc_inst.x5.net15 0
C1283 dc_inst.x1.net4 dc_inst.x2.x19/a_27_47# 0
C1284 dc_inst.x5.net9 dc_inst.x1.net16 0
C1285 dc_inst.x1.x6/a_27_47# _06_ 0.00206f
C1286 dc_inst.x4.net13 dc_inst.x4.x18/a_27_47# 0
C1287 dc_inst.x5.x2/a_27_47# dc_inst.x4.net17 0
C1288 VPWR dc_inst.x3.x10/a_27_47# 0.04053f
C1289 dc_inst.x4.net5 dc_inst.x8/a_277_47# 0
C1290 tdo _24_/a_1217_47# 0
C1291 _03_ capture_d 0.00374f
C1292 dc_inst.x7.net2 dc_inst.x7.net1 0
C1293 dc_inst.x4.net5 dc_inst.x1.net8 0
C1294 dc_inst.net3 dc_inst.x8/a_750_97# 0.34763f
C1295 path_sel[1] dc_inst.x6.x10/a_27_47# 0.00248f
C1296 dc_inst.x6.x17/a_27_47# dc_inst.x6.x16/a_27_47# 0.02448f
C1297 _24_/a_27_47# dc_inst.net9 0.00101f
C1298 dc_inst.x3.x19/a_27_47# path_sel[2] 0
C1299 path_sel[1] dc_inst.x1.x9/a_27_47# 0.00607f
C1300 dc_inst.x4.net5 dc_inst.x6.x1/a_27_47# 0
C1301 dc_inst.x1.net9 dc_inst.x2.net16 0.0027f
C1302 dc_inst.x10/a_505_21# _23_/a_543_47# 0
C1303 path_sel[2] dc_inst.x1.net5 0.09056f
C1304 _19_/a_193_297# _18_/a_76_199# 0
C1305 _23_/a_761_289# shadow_q 0
C1306 _15_/a_27_47# path[4] 0.01483f
C1307 dc_inst.x6.x18/a_27_47# delay_sel[2] 0
C1308 dc_inst.x2.net2 dc_inst.x5.net8 0
C1309 _09_ dc_inst.in 0
C1310 delay_sel[0] dc_inst.x7.net18 0
C1311 dc_inst.x6.net10 dc_inst.x4.net15 0
C1312 tdo dc_inst.x1.net19 0
C1313 VPWR dc_inst.x1.x3/a_27_47# -0.00292f
C1314 _01_ dc_inst.x7.x3/a_27_47# 0.01368f
C1315 VPWR dc_inst.x4.net5 0.66587f
C1316 path_sel[1] dc_inst.x2.x20/a_27_47# 0
C1317 VPWR dc_inst.x5.x17/a_27_47# 0.03257f
C1318 dc_inst.net5 dc_inst.x6.net16 0.09517f
C1319 dc_inst.x7.net2 dc_inst.x7.x7/a_27_47# 0
C1320 dc_inst.x6.net6 dc_inst.x6.net13 0.00286f
C1321 dc_inst.x1.x6/a_27_47# path[3] 0.01629f
C1322 dc_inst.x3.x15/a_27_47# _00_ 0
C1323 dc_inst.x3.net19 dc_inst.x3.net12 0
C1324 dc_inst.x6.x19/a_27_47# dc_inst.x2.net19 0
C1325 delay_sel[0] dc_inst.x7.x18/a_27_47# 0
C1326 dc_inst.x9/a_27_47# dc_inst.x7.x15/a_27_47# 0
C1327 _15_/a_288_47# dc_inst.x1.net14 0
C1328 dc_inst.x4.net2 delay_sel[0] 0.00295f
C1329 _23_/a_543_47# rst 0.00237f
C1330 _08_ _18_/a_76_199# 0.02265f
C1331 dc_inst.x9/a_1478_413# dc_inst.x7.net19 0
C1332 dc_inst.x6.net16 path_sel[2] 0.00752f
C1333 _10_ _19_/a_465_47# 0.00141f
C1334 dc_inst.net4 dc_inst.x7.net8 0
C1335 dc_inst.x1.x6/a_27_47# _19_/a_27_47# 0.00585f
C1336 dc_inst.x7.x16/a_27_47# dc_inst.x7.net15 0.13602f
C1337 dc_inst.x3.net19 dc_inst.x3.x3/a_27_47# 0
C1338 dc_inst.net3 dc_inst.x3.x1/a_27_47# 0
C1339 dc_inst.x4.x10/a_27_47# dc_inst.x2.x7/a_27_47# 0.04629f
C1340 dc_inst.x4.x2/a_27_47# dc_inst.in 0
C1341 dc_inst.x1.net12 _07_ 0.0031f
C1342 dc_inst.x1.x7/a_27_47# dc_inst.x1.x9/a_27_47# 0.02448f
C1343 _03_ _25_/a_1270_413# -0
C1344 dc_inst.in clkload0/X 0
C1345 delay_sel[0] dc_inst.x3.x20/a_27_47# 0
C1346 dc_inst.x5.x5/a_27_47# path_sel[0] 0.00239f
C1347 dc_inst.x4.net16 dc_inst.x4.net12 0.02276f
C1348 dc_inst.x4.x20/a_27_47# dc_inst.x4.net17 0.00185f
C1349 dc_inst.x6.x4/a_27_47# dc_inst.x6.net2 0
C1350 dc_inst.x3.x10/a_27_47# path[5] 0.00431f
C1351 VPWR dc_inst.x9/a_27_413# -0
C1352 dc_inst.x3.net1 dc_inst.x3.x7/a_27_47# 0
C1353 dc_inst.x6.net14 dc_inst.x7.net3 0
C1354 dc_inst.x1.net3 dc_inst.x3.net3 0.00431f
C1355 dc_inst.x4.net6 dc_inst.x2.x1/a_27_47# 0
C1356 dc_inst.x1.x20/a_27_47# dc_inst.x2.x3/a_27_47# 0
C1357 dc_inst.x6.x13/a_27_47# dc_inst.x6.x16/a_27_47# 0.01224f
C1358 dc_inst.x7.net2 dc_inst.x7.net18 0
C1359 dc_inst.x2.net18 path[7] 0
C1360 _23_/a_543_47# clknet_1_1__leaf_clk 0
C1361 path_sel[1] dc_inst.x2.x3/a_27_47# 0.00725f
C1362 dc_inst.x3.net1 dc_inst.x3.x6/a_27_47# 0.12214f
C1363 dc_inst.x1.x15/a_27_47# dc_inst.x1.x10/a_27_47# 0
C1364 dc_inst.x7.net1 dc_inst.x7.net18 0.02798f
C1365 dc_inst.x6.x1/a_27_47# dc_inst.x4.net17 0
C1366 dc_inst.x5.net17 dc_inst.x5.x2/a_27_47# 0
C1367 dc_inst.x7.net2 dc_inst.x7.x18/a_27_47# 0.00339f
C1368 dc_inst.x4.net2 dc_inst.x7.net2 0
C1369 dc_inst.x3.net8 dc_inst.x3.x13/a_27_47# 0.11245f
C1370 dc_inst.x1.net4 dc_inst.x2.net17 0
C1371 path[2] dc_inst.x1.net6 0
C1372 dc_inst.x1.x3/a_27_47# path[5] 0.02134f
C1373 tdo rst 0.20709f
C1374 dc_inst.x9/a_247_21# dc_inst.x8/a_247_21# 0
C1375 dc_inst.x6.net12 tdo 0.00996f
C1376 dc_inst.x7.x18/a_27_47# dc_inst.x7.net1 0.00104f
C1377 dc_inst.x5.x17/a_27_47# dc_inst.x6.net6 0
C1378 VPWR dc_inst.x4.net17 0.14248f
C1379 dc_inst.x7.net19 dc_inst.x7.x19/a_27_47# 0.00148f
C1380 _24_/a_27_47# _24_/a_448_47# -0.00297f
C1381 _13_/a_27_297# _00_ 0.01366f
C1382 _03_ _25_/a_761_289# 0
C1383 dc_inst.x8/a_27_47# dc_inst.x8/a_277_47# -0.0075f
C1384 dc_inst.x4.x2/a_27_47# dc_inst.x6.net17 0
C1385 dc_inst.x5.net17 dc_inst.x6.net2 0
C1386 dc_inst.x1.net9 dc_inst.x2.x17/a_27_47# 0.00488f
C1387 dc_inst.x1.net4 dc_inst.x4.x1/a_27_47# 0
C1388 dc_inst.x6.net9 dc_inst.x6.x11/a_27_47# 0.00144f
C1389 tdo clknet_1_1__leaf_clk 0.03066f
C1390 dc_inst.x3.x12/a_27_47# dc_inst.x3.x10/a_27_47# 0.01254f
C1391 dc_inst.x4.net13 dc_inst.x4.net8 0
C1392 VPWR dc_inst.x9/a_193_413# -0
C1393 dc_inst.x10/a_76_199# _23_/a_27_47# 0
C1394 dc_inst.x1.net4 dc_inst.x5.net11 0
C1395 dc_inst.net2 dc_inst.x3.x17/a_27_47# 0.0031f
C1396 dc_inst.x9/a_193_47# dc_inst.x7.net12 0
C1397 VPWR capture_d 0.39776f
C1398 dc_inst.x5.x20/a_27_47# clknet_1_0__leaf_clk 0
C1399 dc_inst.x2.x5/a_27_47# dc_inst.x1.x17/a_27_47# 0
C1400 VPWR dc_inst.x6.x4/a_27_47# 0.00515f
C1401 dc_inst.net6 dc_inst.x6.net16 0
C1402 dc_inst.x1.net13 dc_inst.x2.x11/a_27_47# 0
C1403 dc_inst.x7.x11/a_27_47# clknet_1_0__leaf_clk 0.00207f
C1404 dc_inst.x1.x15/a_27_47# dc_inst.x5.net1 0
C1405 dc_inst.x5.x19/a_27_47# dc_inst.x7.net8 0
C1406 dc_inst.x3.net15 capture_q 0.01111f
C1407 path_sel[1] dc_inst.x3.x7/a_27_47# 0
C1408 dc_inst.x4.net13 dc_inst.x6.x6/a_27_47# 0
C1409 _09_ dc_inst.x1.net12 0
C1410 dc_inst.x2.x15/a_27_47# dc_inst.x2.x18/a_27_47# 0
C1411 clkbuf_1_1__f_clk/a_110_47# _14_/a_76_199# 0.01055f
C1412 dc_inst.x3.net19 shadow_q 0
C1413 VPWR dc_inst.x8/a_27_47# 0.00296f
C1414 dc_inst.x4.net15 dc_inst.x5.x8/a_27_47# 0
C1415 dc_inst.x7.net4 dc_inst.x6.net16 0
C1416 dc_inst.x5.net3 dc_inst.x4.net11 0
C1417 dc_inst.x3.net16 dc_inst.x7.x3/a_27_47# 0.0025f
C1418 dc_inst.x5.net8 dc_inst.x5.x8/a_27_47# 0.043f
C1419 dc_inst.x2.net18 dc_inst.x1.x1/a_27_47# 0
C1420 dc_inst.x2.net16 dc_inst.x2.net13 0
C1421 dc_inst.x6.x15/a_27_47# dc_inst.in 0
C1422 dc_inst.x4.net19 dc_inst.x5.net7 0
C1423 dc_inst.x7.x18/a_27_47# dc_inst.x7.net18 0.00204f
C1424 dc_inst.x6.net6 dc_inst.x4.net17 0
C1425 _24_/a_193_47# capture_q 0
C1426 dc_inst.x1.net1 path_sel[0] 0
C1427 dc_inst.in dc_inst.x7.x3/a_27_47# 0
C1428 dc_inst.x3.net18 _01_ 0
C1429 dc_inst.x1.net9 dc_inst.x2.net10 0
C1430 dc_inst.x4.x16/a_27_47# dc_inst.x4.net13 0.003f
C1431 dc_inst.in _18_/a_76_199# 0
C1432 dc_inst.x6.x17/a_27_47# dc_inst.x6.net13 0
C1433 dc_inst.x5.x5/a_27_47# tdo 0.00116f
C1434 dc_inst.x8/a_750_97# dc_inst.x3.net19 0
C1435 dc_inst.x3.net4 dc_inst.x3.net3 0.01777f
C1436 dc_inst.x5.net19 dc_inst.x6.x10/a_27_47# 0
C1437 _23_/a_1108_47# dc_inst.x3.x7/a_27_47# 0
C1438 dc_inst.x7.net19 dc_inst.net5 0.00234f
C1439 dc_inst.x10/a_505_21# dc_inst.x7.net3 0.0459f
C1440 dc_inst.x4.net10 dc_inst.x4.net11 0.00132f
C1441 clkbuf_1_1__f_clk/a_110_47# se 0.04994f
C1442 _24_/a_27_47# delay_sel[2] 0.0312f
C1443 dc_inst.x7.x10/a_27_47# dc_inst.x6.net19 0
C1444 VPWR _25_/a_1270_413# 0
C1445 dc_inst.x2.net14 dc_inst.x1.net16 0.01113f
C1446 dc_inst.x1.net11 _19_/a_465_47# 0
C1447 VPWR dc_inst.x7.net13 0.10338f
C1448 dc_inst.x7.net14 dc_inst.x7.net1 0.02173f
C1449 dc_inst.x4.x10/a_27_47# dc_inst.x1.net18 0
C1450 VPWR dc_inst.x5.net17 0.40791f
C1451 _15_/a_27_47# _15_/a_788_316# -0
C1452 dc_inst.x3.net18 _02_ 0
C1453 dc_inst.x1.x4/a_27_47# dc_inst.x1.net10 0
C1454 dc_inst.x1.x13/a_27_47# dc_inst.x1.net14 0.04665f
C1455 dc_inst.x2.net7 dc_inst.x4.x11/a_27_47# 0
C1456 _07_ _17_/a_174_21# 0.00702f
C1457 dc_inst.x6.net6 dc_inst.x6.x4/a_27_47# 0.00331f
C1458 dc_inst.net7 dc_inst.x9/a_834_97# 0.01255f
C1459 clkload0/a_27_47# clkload0/X 0
C1460 _20_/a_384_47# _04_ 0.01778f
C1461 dc_inst.x3.x14/a_27_47# dc_inst.x1.x12/a_27_47# 0
C1462 dc_inst.x6.net17 dc_inst.x6.x15/a_27_47# 0.04322f
C1463 dc_inst.x4.net3 dc_inst.x7.net2 0
C1464 dc_inst.x3.net10 dc_inst.x3.net1 0.00214f
C1465 dc_inst.x2.net6 dc_inst.x2.net7 0.00295f
C1466 dc_inst.x8/a_1478_413# path[4] 0
C1467 dc_inst.x3.net7 _01_ 0
C1468 dc_inst.x7.net3 rst 0.41672f
C1469 dc_inst.net3 _24_/a_543_47# 0
C1470 dc_inst.net7 tdo 0.00245f
C1471 dc_inst.x2.net6 dc_inst.x2.net10 0.00757f
C1472 dc_inst.x2.x17/a_27_47# dc_inst.x2.net12 0
C1473 dc_inst.x7.x7/a_27_47# dc_inst.x7.net14 0
C1474 dc_inst.x7.x16/a_27_47# clknet_1_0__leaf_clk 0
C1475 dc_inst.x5.net7 dc_inst.x6.x11/a_27_47# 0
C1476 dc_inst.x1.net4 _15_/a_193_369# 0.00166f
C1477 dc_inst.x4.net13 dc_inst.x4.x9/a_27_47# 0.00514f
C1478 tdo dc_inst.x1.x19/a_27_47# 0
C1479 dc_inst.x6.x17/a_27_47# dc_inst.x4.net5 0
C1480 dc_inst.x6.net13 dc_inst.x6.x13/a_27_47# 0.01506f
C1481 VPWR _25_/a_761_289# 0.00249f
C1482 dc_inst.x1.x12/a_27_47# path[7] 0
C1483 _24_/a_1283_21# dc_inst.x7.x3/a_27_47# 0
C1484 dc_inst.x7.net3 clknet_1_1__leaf_clk 0
C1485 dc_inst.x3.net7 _02_ 0
C1486 path_sel[0] dc_inst.x3.x15/a_27_47# 0
C1487 dc_inst.x4.net1 dc_inst.x5.net7 0.01765f
C1488 dc_inst.x4.net9 dc_inst.x4.net17 0.00422f
C1489 dc_inst.x1.net7 dc_inst.x1.net16 0
C1490 _04_ _18_/a_505_21# 0
C1491 dc_inst.x6.net5 dc_inst.x6.net13 0.0039f
C1492 dc_inst.x7.net14 dc_inst.x7.net18 0.10102f
C1493 dc_inst.x5.net17 dc_inst.x6.net6 0
C1494 dc_inst.x4.x2/a_27_47# dc_inst.x2.x4/a_27_47# 0
C1495 dc_inst.x3.net17 dc_inst.x7.x3/a_27_47# 0
C1496 dc_inst.net4 dc_inst.x7.net12 0.00118f
C1497 _24_/a_761_289# _23_/a_543_47# 0.00631f
C1498 _24_/a_543_47# _23_/a_761_289# 0
C1499 dc_inst.x3.net1 path_sel[0] 0
C1500 dc_inst.x2.x17/a_27_47# dc_inst.x2.net13 0
C1501 dc_inst.x2.net7 dc_inst.x2.net12 0
C1502 dc_inst.x2.net10 dc_inst.x2.net12 0.02462f
C1503 dc_inst.x7.net16 dc_inst.x7.net15 0.03523f
C1504 _23_/a_193_47# _00_ 0
C1505 clkbuf_1_0__f_clk/a_110_47# dc_inst.x9/a_27_413# 0
C1506 dc_inst.x3.x20/a_27_47# _13_/a_112_47# 0
C1507 dc_inst.net2 dc_inst.x8/a_923_363# 0
C1508 dc_inst.x2.net16 path_sel[2] 0.01411f
C1509 delay_sel[0] _23_/a_27_47# 0
C1510 path_sel[1] dc_inst.x1.x5/a_27_47# 0
C1511 dc_inst.x5.x13/a_27_47# path_sel[0] 0.0025f
C1512 dc_inst.net6 dc_inst.x7.net19 0
C1513 dc_inst.x5.net4 dc_inst.x5.x10/a_27_47# 0.00267f
C1514 dc_inst.x7.x8/a_27_47# dc_inst.x5.net16 0
C1515 path_sel[2] dc_inst.x3.net3 0
C1516 _24_/a_27_47# _25_/a_1283_21# 0.00126f
C1517 dc_inst.x5.x15/a_27_47# dc_inst.x6.net3 0
C1518 dc_inst.x7.x2/a_27_47# clknet_0_clk 0.00146f
C1519 clknet_1_0__leaf_clk _23_/a_193_47# 0.00103f
C1520 _06_ dc_inst.x3.net11 0
C1521 dc_inst.x7.net4 dc_inst.x7.net19 0
C1522 clkbuf_1_1__f_clk/a_110_47# delay_sel[2] 0.0471f
C1523 dc_inst.x1.net4 dc_inst.x1.x3/a_27_47# 0.00201f
C1524 dc_inst.x4.net3 dc_inst.x4.net2 0.01665f
C1525 _24_/a_761_289# tdo 0
C1526 dc_inst.x4.net12 dc_inst.x4.x12/a_27_47# 0.01506f
C1527 dc_inst.x2.net10 dc_inst.x2.net13 0
C1528 path_sel[0] path[1] 0.08275f
C1529 _23_/a_27_47# _23_/a_448_47# -0.00373f
C1530 dc_inst.net3 dc_inst.x3.net14 0
C1531 VPWR dc_inst.x2.net4 0.04291f
C1532 dc_inst.x1.net11 dc_inst.x2.x13/a_27_47# 0
C1533 dc_inst.x7.x2/a_27_47# clkbuf_0_clk/a_110_47# 0
C1534 VPWR _16_/a_229_47# 0
C1535 VPWR dc_inst.x3.x14/a_27_47# 0.00487f
C1536 VPWR dc_inst.x2.x12/a_27_47# -0.00377f
C1537 tdi dc_inst.x3.net11 0.00161f
C1538 dc_inst.x3.net19 dc_inst.x3.net6 0
C1539 dc_inst.x5.net19 clknet_1_0__leaf_clk 0
C1540 dc_inst.x3.net5 _00_ 0
C1541 dc_inst.x8/a_668_97# dc_inst.x8/a_277_47# -0.01493f
C1542 dc_inst.x7.x9/a_27_47# dc_inst.x7.x8/a_27_47# 0.01018f
C1543 dc_inst.x7.x14/a_27_47# dc_inst.x7.x19/a_27_47# 0
C1544 dc_inst.x6.net14 dc_inst.x10/a_76_199# 0
C1545 dc_inst.x9/a_193_413# clkbuf_1_0__f_clk/a_110_47# 0
C1546 path[0] path[1] 0.24955f
C1547 path_sel[1] path_sel[0] 0.31364f
C1548 dc_inst.x3.net2 _00_ 0
C1549 dc_inst.x4.x15/a_27_47# dc_inst.net4 0.0122f
C1550 dc_inst.x4.net12 dc_inst.x5.x15/a_27_47# 0
C1551 dc_inst.x5.net6 dc_inst.x2.net7 0.17246f
C1552 dc_inst.x3.net16 dc_inst.x3.net7 0
C1553 dc_inst.net7 dc_inst.x7.net3 0.23305f
C1554 dc_inst.x5.net14 dc_inst.x6.net3 0
C1555 dc_inst.x5.net6 dc_inst.x2.net10 0
C1556 dc_inst.x5.net13 dc_inst.x5.net16 0
C1557 _10_ dc_inst.x1.x12/a_27_47# 0.01787f
C1558 dc_inst.x7.x19/a_27_47# dc_inst.x7.net8 0
C1559 dc_inst.x3.net5 dc_inst.x3.x7/a_27_47# 0.00171f
C1560 VPWR path[7] 0.20276f
C1561 dc_inst.x9/a_1290_413# dc_inst.x6.net19 0
C1562 dc_inst.net4 dc_inst.in 0
C1563 dc_inst.x6.net9 dc_inst.x5.net18 0.00582f
C1564 dc_inst.x6.x18/a_27_47# dc_inst.x6.x19/a_27_47# 0
C1565 dc_inst.x4.net14 dc_inst.x4.net11 0
C1566 path[0] path_sel[1] 0
C1567 _06_ dc_inst.x1.net2 0
C1568 dc_inst.x8/a_668_97# VPWR 0.0019f
C1569 dc_inst.x2.net1 dc_inst.x5.x11/a_27_47# 0.00131f
C1570 dc_inst.x6.net14 dc_inst.x6.x3/a_27_47# 0
C1571 _10_ _15_/a_1060_369# 0
C1572 dc_inst.x9/a_247_21# delay_sel[1] 0.02431f
C1573 dc_inst.x7.net11 dc_inst.x7.net13 0.00242f
C1574 _06_ _15_/a_1064_47# 0
C1575 dc_inst.x9/a_750_97# dc_inst.x9/a_27_413# -0
C1576 delay_sel[0] dc_inst.x6.net15 0
C1577 clknet_0_clk _24_/a_651_413# 0.00199f
C1578 capture_d dc_inst.net9 0.00337f
C1579 _15_/a_1281_47# dc_inst.x1.net2 0
C1580 dc_inst.x3.net11 rst 0
C1581 dc_inst.x3.net18 path[6] 0.00408f
C1582 dc_inst.x1.x12/a_27_47# _15_/a_872_316# 0
C1583 dc_inst.x8/a_1290_413# dc_inst.x1.net3 0
C1584 dc_inst.x5.x16/a_27_47# dc_inst.x5.net16 0.01526f
C1585 dc_inst.x7.net6 dc_inst.x5.x20/a_27_47# 0.00116f
C1586 tdo dc_inst.x6.net1 0
C1587 dc_inst.x2.net17 dc_inst.x1.net16 0
C1588 dc_inst.x2.net16 dc_inst.x1.net17 0
C1589 dc_inst.x3.x14/a_27_47# path[5] 0.01018f
C1590 dc_inst.x2.net6 dc_inst.x2.x6/a_27_47# 0.01247f
C1591 dc_inst.x2.x17/a_27_47# path_sel[2] 0.01175f
C1592 dc_inst.x7.net4 dc_inst.x3.net3 0
C1593 dc_inst.x4.net12 dc_inst.x5.net14 0
C1594 dc_inst.x1.x7/a_27_47# path_sel[0] 0
C1595 dc_inst.x8/a_27_47# dc_inst.net9 0.10522f
C1596 dc_inst.x4.net4 dc_inst.x2.net17 0.00137f
C1597 _14_/a_505_21# dc_inst.x3.net8 0.00214f
C1598 dc_inst.x1.net3 _02_ 0
C1599 dc_inst.x7.net2 dc_inst.x6.x14/a_27_47# 0
C1600 clkbuf_1_0__f_clk/a_110_47# dc_inst.x7.net13 0.00973f
C1601 dc_inst.x3.net17 dc_inst.x3.net18 0.0989f
C1602 dc_inst.net1 dc_inst.x2.net16 0
C1603 dc_inst.x5.net16 dc_inst.x6.net2 0
C1604 dc_inst.net4 dc_inst.x6.net17 0.00122f
C1605 dc_inst.x5.net7 dc_inst.x2.net8 0.00247f
C1606 dc_inst.x4.x1/a_27_47# dc_inst.x1.net16 0
C1607 dc_inst.x5.x17/a_27_47# dc_inst.x6.net7 0
C1608 dc_inst.x4.x14/a_27_47# dc_inst.x4.net17 0.00146f
C1609 dc_inst.x7.net5 dc_inst.x7.net19 0
C1610 dc_inst.x3.x5/a_27_47# path[7] 0
C1611 path[5] path[7] 0.1692f
C1612 dc_inst.x4.x1/a_27_47# dc_inst.x4.net4 0
C1613 dc_inst.x5.x4/a_27_47# dc_inst.x5.net4 0.04991f
C1614 dc_inst.x7.net2 dc_inst.x6.net15 0
C1615 dc_inst.x6.net5 dc_inst.x6.x4/a_27_47# 0.01506f
C1616 dc_inst.x3.net7 path[6] 0.00137f
C1617 dc_inst.x3.net13 dc_inst.x3.net9 0.05324f
C1618 VPWR dc_inst.x1.x1/a_27_47# 0.04206f
C1619 dc_inst.x5.net2 dc_inst.x4.net13 0.00455f
C1620 dc_inst.x1.net8 _10_ 0
C1621 dc_inst.x9/a_750_97# dc_inst.x9/a_193_413# -0
C1622 dc_inst.x9/a_757_363# dc_inst.x9/a_247_21# -0.0033f
C1623 dc_inst.x7.net16 clknet_1_0__leaf_clk 0
C1624 _17_/a_174_21# _18_/a_76_199# 0.00158f
C1625 dc_inst.x7.net6 dc_inst.x7.net7 0.01747f
C1626 dc_inst.x2.net10 path_sel[2] 0
C1627 dc_inst.x5.net3 dc_inst.x4.net10 0
C1628 path_sel[2] dc_inst.x7.net8 0.00506f
C1629 dc_inst.x3.x12/a_27_47# dc_inst.x3.x14/a_27_47# 0
C1630 _20_/a_79_21# _06_ 0
C1631 clkbuf_1_0__f_clk/a_110_47# _25_/a_761_289# 0.00956f
C1632 dc_inst.x7.x9/a_27_47# dc_inst.x6.net2 0
C1633 _05_ dc_inst.x3.net18 0
C1634 dc_inst.x3.net17 dc_inst.x3.net7 0.04162f
C1635 dc_inst.x3.net19 dc_inst.x3.x19/a_27_47# 0.00305f
C1636 path_sel[1] tdo 0.03675f
C1637 VPWR _10_ 0.147f
C1638 dc_inst.x4.x13/a_27_47# dc_inst.net4 0.00573f
C1639 dc_inst.x4.net15 dc_inst.x4.net12 0
C1640 dc_inst.x5.net18 dc_inst.x5.net7 0
C1641 dc_inst.x4.net1 dc_inst.x6.net12 0
C1642 dc_inst.x4.net9 dc_inst.x2.net4 0
C1643 dc_inst.x2.x14/a_27_47# path_sel[0] 0
C1644 dc_inst.x7.net2 dc_inst.x7.x6/a_27_47# 0
C1645 dc_inst.x6.net18 dc_inst.x7.x5/a_27_47# 0
C1646 dc_inst.x3.x9/a_27_47# dc_inst.x3.net7 0.00113f
C1647 capture_d _24_/a_448_47# 0.00574f
C1648 dc_inst.x7.net6 dc_inst.x7.x16/a_27_47# 0
C1649 dc_inst.x8/a_193_413# path_sel[2] 0
C1650 dc_inst.x1.net9 dc_inst.in 0.0348f
C1651 _13_/a_470_297# _02_ 0.00914f
C1652 dc_inst.x3.x12/a_27_47# path[7] 0.00118f
C1653 dc_inst.x6.net7 dc_inst.x4.net17 0
C1654 VPWR dc_inst.x5.net16 0.01712f
C1655 dc_inst.x5.x13/a_27_47# dc_inst.x6.x8/a_27_47# 0
C1656 dc_inst.x10/a_76_199# rst 0.04748f
C1657 delay_sel[1] _25_/a_543_47# 0
C1658 dc_inst.x3.net4 _01_ 0
C1659 dc_inst.x1.net11 dc_inst.x1.x12/a_27_47# 0.02018f
C1660 dc_inst.x9/a_277_47# dc_inst.x9/a_27_413# -0.00157f
C1661 dc_inst.x3.net19 dc_inst.x3.net14 0
C1662 dc_inst.x7.net9 dc_inst.x7.net13 0.00672f
C1663 VPWR _15_/a_872_316# 0
C1664 dc_inst.x5.x7/a_27_47# dc_inst.x5.net4 0
C1665 dc_inst.x7.net9 dc_inst.x5.net17 0
C1666 dc_inst.x6.net14 delay_sel[0] 0
C1667 path[5] dc_inst.x1.x1/a_27_47# 0
C1668 _05_ dc_inst.x3.net7 0
C1669 _03_ _24_/a_193_47# 0
C1670 dc_inst.x4.net18 dc_inst.x4.x15/a_27_47# 0.03823f
C1671 dc_inst.x5.x6/a_27_47# dc_inst.x4.net11 0
C1672 dc_inst.net4 dc_inst.x5.x1/a_27_47# 0.03968f
C1673 dc_inst.x1.net10 dc_inst.x5.net9 0
C1674 dc_inst.x7.x7/a_27_47# dc_inst.x7.x6/a_27_47# 0
C1675 _02_ _24_/a_1270_413# -0
C1676 dc_inst.x8/a_247_21# dc_inst.x8/a_277_47# -0.00757f
C1677 dc_inst.x10/a_76_199# clknet_1_1__leaf_clk 0
C1678 dc_inst.x2.x20/a_27_47# shadow_q 0
C1679 dc_inst.x5.net6 dc_inst.x2.x6/a_27_47# 0.02421f
C1680 dc_inst.net1 dc_inst.x2.x17/a_27_47# 0
C1681 _20_/a_79_21# _19_/a_27_47# 0
C1682 dc_inst.x3.net4 _02_ 0
C1683 dc_inst.x6.x4/a_27_47# dc_inst.x6.net7 0
C1684 dc_inst.x3.net12 dc_inst.x3.x7/a_27_47# 0.03092f
C1685 dc_inst.x1.net3 dc_inst.in 0.02823f
C1686 dc_inst.x4.net2 dc_inst.x6.net15 0
C1687 dc_inst.x6.net18 delay_sel[0] 0
C1688 dc_inst.x6.net12 dc_inst.x6.x3/a_27_47# 0
C1689 VPWR dc_inst.x7.x9/a_27_47# 0.04146f
C1690 dc_inst.x7.x16/a_27_47# tdo 0
C1691 dc_inst.x3.net12 dc_inst.x3.x6/a_27_47# 0.01151f
C1692 _25_/a_27_47# clknet_0_clk 0.01994f
C1693 path_sel[1] dc_inst.x6.x8/a_27_47# 0.00255f
C1694 dc_inst.x4.net3 dc_inst.x2.net15 0.00114f
C1695 dc_inst.x6.net13 dc_inst.x1.net16 0
C1696 dc_inst.x2.net7 dc_inst.x1.net17 0
C1697 dc_inst.x7.net2 dc_inst.x6.net14 0
C1698 VPWR dc_inst.x8/a_247_21# -0.03283f
C1699 dc_inst.x2.net18 delay_sel[1] 0
C1700 VPWR _17_/a_574_297# 0
C1701 dc_inst.x3.net5 path_sel[0] 0
C1702 dc_inst.x6.net6 dc_inst.x5.net16 0
C1703 dc_inst.x9/a_193_413# dc_inst.x9/a_277_47# -0.00148f
C1704 dc_inst.x8/a_750_97# dc_inst.x2.x20/a_27_47# 0
C1705 dc_inst.net3 dc_inst.x2.net16 0
C1706 _25_/a_27_47# clkbuf_0_clk/a_110_47# 0.01066f
C1707 dc_inst.x7.x10/a_27_47# dc_inst.x7.net10 0.04326f
C1708 dc_inst.net4 dc_inst.x5.net15 0
C1709 _08_ _18_/a_218_47# 0
C1710 dc_inst.x4.x13/a_27_47# dc_inst.x6.x12/a_27_47# 0
C1711 dc_inst.x3.net2 path_sel[0] 0
C1712 _15_/a_788_316# dc_inst.net2 0
C1713 capture_d delay_sel[2] 0.10177f
C1714 _23_/a_543_47# _23_/a_193_47# 0
C1715 dc_inst.x7.x19/a_27_47# dc_inst.x7.net12 0.01108f
C1716 dc_inst.x9/a_277_47# dc_inst.x6.x4/a_27_47# 0
C1717 path[5] _15_/a_872_316# 0.02841f
C1718 dc_inst.net3 dc_inst.x3.net3 0.02012f
C1719 dc_inst.x7.net6 dc_inst.x6.net4 0.01044f
C1720 dc_inst.x1.net10 dc_inst.x2.x10/a_27_47# 0.00149f
C1721 dc_inst.x1.x18/a_27_47# dc_inst.x2.net16 0
C1722 dc_inst.x1.net9 dc_inst.x3.net17 0
C1723 clkbuf_1_1__f_clk/a_110_47# dc_inst.x3.x17/a_27_47# 0
C1724 dc_inst.x7.net7 dc_inst.x6.x8/a_27_47# 0
C1725 dc_inst.x6.x19/a_27_47# dc_inst.x6.x16/a_27_47# 0
C1726 dc_inst.x7.net2 dc_inst.x6.net18 0.00505f
C1727 dc_inst.x3.net7 _15_/a_600_345# 0
C1728 dc_inst.x8/a_27_47# delay_sel[2] 0
C1729 VPWR dc_inst.x3.x11/a_27_47# 0.0144f
C1730 dc_inst.x8/a_1478_413# dc_inst.net8 0.04548f
C1731 dc_inst.x7.net4 dc_inst.x8/a_193_413# 0.00211f
C1732 dc_inst.x7.net6 dc_inst.x5.net19 0.04343f
C1733 capture_d dc_inst.x7.net17 0
C1734 dc_inst.x2.net7 dc_inst.x5.x9/a_27_47# 0
C1735 dc_inst.x6.net19 dc_inst.x7.x4/a_27_47# 0
C1736 path[2] dc_inst.x1.x11/a_27_47# 0.0011f
C1737 clknet_0_clk _25_/a_1217_47# 0
C1738 dc_inst.x1.net3 path[6] 0.077f
C1739 dc_inst.x2.net10 dc_inst.x5.x9/a_27_47# 0
C1740 dc_inst.x9/a_1478_413# dc_inst.in 0
C1741 dc_inst.x7.x1/a_27_47# dc_inst.x6.net16 0
C1742 dc_inst.x2.net1 dc_inst.x5.net10 0
C1743 dc_inst.x1.net9 dc_inst.x1.net12 0
C1744 dc_inst.x4.x10/a_27_47# path_sel[0] 0
C1745 dc_inst.x2.net6 dc_inst.x2.x5/a_27_47# 0.00364f
C1746 dc_inst.x4.net5 dc_inst.x1.net16 0.10135f
C1747 dc_inst.x5.x19/a_27_47# dc_inst.x5.x14/a_27_47# 0
C1748 VPWR dc_inst.x1.net11 0.1365f
C1749 _24_/a_193_47# dc_inst.x8/a_277_47# 0
C1750 dc_inst.x1.net4 dc_inst.x3.x14/a_27_47# 0
C1751 dc_inst.net1 dc_inst.x8/a_193_413# 0.00553f
C1752 dc_inst.x2.x20/a_27_47# dc_inst.x3.x1/a_27_47# 0
C1753 dc_inst.x4.net16 path_sel[0] 0.00146f
C1754 dc_inst.x4.net4 dc_inst.x4.net5 0.04173f
C1755 tdo _23_/a_193_47# 0.03504f
C1756 VPWR dc_inst.x3.net15 0.02944f
C1757 dc_inst.net7 dc_inst.x10/a_76_199# 0
C1758 shadow_q _00_ 0.00202f
C1759 dc_inst.x8/a_1290_413# path_sel[2] 0
C1760 delay_sel[0] dc_inst.x10/a_505_21# 0.02087f
C1761 dc_inst.x3.net16 dc_inst.x3.net4 0.00242f
C1762 dc_inst.x3.net17 dc_inst.x1.net3 0.01379f
C1763 dc_inst.x8/a_834_97# delay_sel[1] 0.00137f
C1764 dc_inst.x4.net13 dc_inst.x2.x9/a_27_47# 0
C1765 dc_inst.x9/a_277_47# dc_inst.x7.net13 0
C1766 delay_sel[2] _25_/a_1270_413# 0
C1767 dc_inst.x7.net3 _23_/a_1108_47# 0.00172f
C1768 dc_inst.net3 dc_inst.x3.x16/a_27_47# 0
C1769 _14_/a_76_199# path[7] 0
C1770 dc_inst.x1.net7 path[4] 0
C1771 _08_ path_sel[2] 0
C1772 dc_inst.x5.net3 dc_inst.x4.net14 0.12403f
C1773 dc_inst.x3.x7/a_27_47# shadow_q 0
C1774 dc_inst.x1.net4 path[7] 0
C1775 VPWR _24_/a_193_47# -0.28109f
C1776 dc_inst.x4.net6 dc_inst.x6.net13 0
C1777 dc_inst.x1.net1 dc_inst.x1.net2 0
C1778 dc_inst.net5 dc_inst.x7.net12 0.02278f
C1779 clk _00_ 0.01719f
C1780 dc_inst.x4.net2 dc_inst.x6.net14 0
C1781 dc_inst.x1.net12 dc_inst.x1.net3 0.1039f
C1782 dc_inst.x3.x11/a_27_47# path[5] 0.00606f
C1783 dc_inst.x5.x19/a_27_47# dc_inst.x5.net15 0
C1784 dc_inst.x4.x6/a_27_47# dc_inst.x5.net7 0.11198f
C1785 delay_sel[0] rst 0.00178f
C1786 dc_inst.x4.net3 dc_inst.x6.net15 0
C1787 dc_inst.x7.net13 dc_inst.x7.net17 0
C1788 dc_inst.x6.net17 dc_inst.x9/a_1478_413# 0
C1789 dc_inst.x2.x5/a_27_47# dc_inst.x2.net12 0.00502f
C1790 dc_inst.x1.net8 dc_inst.x1.net14 0.03259f
C1791 dc_inst.x7.x16/a_27_47# dc_inst.x7.net3 0
C1792 dc_inst.x2.x15/a_27_47# dc_inst.x5.net10 0
C1793 _06_ dc_inst.x1.net6 0
C1794 dc_inst.x7.net12 path_sel[2] 0
C1795 dc_inst.x5.net3 dc_inst.x2.x2/a_27_47# 0
C1796 dc_inst.x9/a_247_21# _25_/a_543_47# 0
C1797 se path[7] 0
C1798 _13_/a_470_297# path[6] 0.0246f
C1799 clknet_1_0__leaf_clk clk 0
C1800 _05_ dc_inst.x1.net3 0
C1801 _14_/a_439_47# path[6] 0
C1802 delay_sel[2] _25_/a_761_289# 0
C1803 _14_/a_535_374# path[7] 0
C1804 dc_inst.x3.net1 dc_inst.x3.net11 0.04049f
C1805 dc_inst.x3.net10 dc_inst.x3.net12 0.25729f
C1806 capture_d _25_/a_1283_21# 0
C1807 dc_inst.x1.net10 dc_inst.x5.net12 0.0086f
C1808 dc_inst.x1.net11 path[5] 0.0024f
C1809 dc_inst.x4.net13 dc_inst.x5.net9 0
C1810 dc_inst.x4.net18 dc_inst.x5.x1/a_27_47# 0
C1811 VPWR dc_inst.x1.net14 0.06779f
C1812 delay_sel[0] clknet_1_1__leaf_clk 0
C1813 dc_inst.x4.net2 dc_inst.x6.net18 0
C1814 VPWR dc_inst.x4.net11 0.01396f
C1815 dc_inst.x1.x2/a_27_47# dc_inst.x1.net3 0.00171f
C1816 _06_ path[2] 0
C1817 dc_inst.x3.net15 dc_inst.x3.x5/a_27_47# 0.00106f
C1818 _23_/a_448_47# rst 0
C1819 dc_inst.x3.net15 path[5] 0
C1820 dc_inst.x4.net19 dc_inst.x5.x13/a_27_47# 0
C1821 clknet_0_clk clkload0/X 0.06625f
C1822 _13_/a_470_297# dc_inst.x3.net17 0
C1823 dc_inst.x1.net13 dc_inst.x2.net16 0.01826f
C1824 _00_ _25_/a_1108_47# 0.06457f
C1825 dc_inst.x4.net7 dc_inst.x6.net17 0.00226f
C1826 dc_inst.net4 dc_inst.x4.net8 0
C1827 path_sel[1] dc_inst.x3.x2/a_27_47# 0.00432f
C1828 dc_inst.x7.net17 _25_/a_761_289# 0
C1829 dc_inst.x2.x2/a_27_47# dc_inst.x4.net10 0
C1830 dc_inst.x2.x5/a_27_47# dc_inst.x2.net13 0.00164f
C1831 dc_inst.x7.net2 rst 0
C1832 dc_inst.x7.net2 dc_inst.x6.net12 0
C1833 dc_inst.x4.net6 dc_inst.x4.net5 0
C1834 dc_inst.x6.net4 dc_inst.x6.x8/a_27_47# 0
C1835 dc_inst.x6.x20/a_27_47# dc_inst.x6.net13 0
C1836 _03_ delay_sel[1] 0
C1837 path[3] dc_inst.x1.net6 0.04236f
C1838 dc_inst.x3.x1/a_27_47# _00_ 0
C1839 dc_inst.x3.net4 path[6] 0.0281f
C1840 dc_inst.x1.net13 dc_inst.x3.net3 0
C1841 dc_inst.x7.net4 _01_ 0.06485f
C1842 dc_inst.x7.net1 rst 0.01975f
C1843 dc_inst.x5.x8/a_27_47# dc_inst.x2.net7 0
C1844 clkbuf_0_clk/a_110_47# clkload0/X 0
C1845 dc_inst.x5.net6 dc_inst.x6.net17 0
C1846 dc_inst.x6.x8/a_27_47# dc_inst.x5.net19 0.05771f
C1847 dc_inst.x7.net4 dc_inst.x8/a_1290_413# 0
C1848 dc_inst.x4.x10/a_27_47# tdo 0.00606f
C1849 dc_inst.x1.net10 dc_inst.x2.net14 0.03001f
C1850 clknet_1_0__leaf_clk _25_/a_1108_47# 0
C1851 dc_inst.x1.net4 dc_inst.x1.x1/a_27_47# 0.00823f
C1852 dc_inst.net7 dc_inst.x7.x5/a_27_47# 0.00159f
C1853 dc_inst.x2.x6/a_27_47# dc_inst.x1.net17 0
C1854 path[3] path[2] 0.11116f
C1855 dc_inst.x3.net12 path_sel[0] 0
C1856 dc_inst.x4.net16 tdo 0.02516f
C1857 _19_/a_27_47# dc_inst.x1.net6 0
C1858 dc_inst.x4.net18 dc_inst.x4.x18/a_27_47# 0.00435f
C1859 dc_inst.x2.net6 dc_inst.x5.net4 0.00332f
C1860 dc_inst.x5.net6 dc_inst.x2.x5/a_27_47# 0.00722f
C1861 dc_inst.x3.net11 _13_/a_27_297# 0
C1862 dc_inst.x3.net17 dc_inst.x3.net4 0.09037f
C1863 dc_inst.x6.net1 dc_inst.x6.x11/a_27_47# 0.04988f
C1864 dc_inst.x7.net3 _23_/a_193_47# 0
C1865 dc_inst.x2.net6 dc_inst.x2.x4/a_27_47# 0.00331f
C1866 _15_/a_600_345# dc_inst.x1.net3 0.01417f
C1867 dc_inst.x7.x17/a_27_47# dc_inst.net4 0
C1868 dc_inst.x4.x6/a_27_47# dc_inst.x6.net18 0
C1869 _25_/a_27_47# _25_/a_193_47# -0.28991f
C1870 dc_inst.x4.net19 path_sel[1] 0.04138f
C1871 dc_inst.x1.net4 _10_ 0
C1872 _05_ _13_/a_470_297# 0.02426f
C1873 dc_inst.x6.net6 dc_inst.x4.net11 0
C1874 _05_ _14_/a_439_47# 0
C1875 dc_inst.net2 dc_inst.net8 0.04354f
C1876 dc_inst.x3.net19 dc_inst.x3.net3 0.05306f
C1877 dc_inst.x6.x19/a_27_47# dc_inst.x6.net13 0
C1878 path[2] _19_/a_27_47# 0.00693f
C1879 dc_inst.x7.x9/a_27_47# clkbuf_1_0__f_clk/a_110_47# 0
C1880 dc_inst.x7.net16 tdo 0
C1881 dc_inst.net3 dc_inst.x8/a_193_413# 0
C1882 dc_inst.x7.net12 _25_/a_1462_47# 0
C1883 path_sel[2] dc_inst.in 0.03765f
C1884 dc_inst.x2.net8 dc_inst.x1.x19/a_27_47# 0
C1885 dc_inst.x3.net13 _06_ 0
C1886 dc_inst.x2.net9 dc_inst.x2.net7 0.0026f
C1887 dc_inst.x4.net2 dc_inst.x10/a_505_21# 0
C1888 dc_inst.x2.net9 dc_inst.x2.net10 0.00485f
C1889 dc_inst.x4.net3 dc_inst.x6.net14 0
C1890 dc_inst.x5.net3 dc_inst.x5.x6/a_27_47# 0
C1891 dc_inst.x1.net10 dc_inst.x1.net7 0.00336f
C1892 rst dc_inst.x7.net18 0
C1893 delay_sel[0] dc_inst.net7 0.00535f
C1894 dc_inst.x2.net6 dc_inst.x4.x7/a_27_47# 0
C1895 dc_inst.x5.net4 dc_inst.x2.net12 0
C1896 dc_inst.x2.net11 path_sel[0] 0
C1897 dc_inst.x2.x4/a_27_47# dc_inst.x2.net12 0.00101f
C1898 dc_inst.x6.net17 dc_inst.net5 0.00131f
C1899 dc_inst.x4.x6/a_27_47# dc_inst.x1.net19 0
C1900 dc_inst.x3.net5 dc_inst.x7.net3 0
C1901 dc_inst.x7.x18/a_27_47# rst 0.00106f
C1902 _19_/a_109_297# dc_inst.x1.x5/a_27_47# 0
C1903 dc_inst.net9 dc_inst.x8/a_247_21# 0.01206f
C1904 dc_inst.x4.net2 rst 0
C1905 delay_sel[1] dc_inst.x8/a_277_47# 0.15614f
C1906 dc_inst.x5.net3 dc_inst.x5.net13 0.15527f
C1907 dc_inst.x3.net2 dc_inst.x7.net3 0
C1908 path_sel[1] dc_inst.x6.x11/a_27_47# 0.00188f
C1909 dc_inst.x1.net13 dc_inst.x2.x17/a_27_47# 0.03174f
C1910 dc_inst.x6.net17 path_sel[2] 0.01101f
C1911 tdi _13_/a_112_47# 0
C1912 delay_sel[0] _23_/a_651_413# 0
C1913 dc_inst.x3.net6 dc_inst.x3.x7/a_27_47# 0.12378f
C1914 dc_inst.x6.x1/a_27_47# delay_sel[1] 0
C1915 path_sel[1] dc_inst.x1.net2 0.52953f
C1916 path_sel[2] path[6] 0.00195f
C1917 dc_inst.x3.x6/a_27_47# dc_inst.x3.net6 0.03883f
C1918 dc_inst.x7.net2 dc_inst.net7 0.13481f
C1919 dc_inst.x5.net9 _07_ 0
C1920 path_sel[1] dc_inst.x4.net1 0.02473f
C1921 dc_inst.x2.net13 dc_inst.x5.net4 0
C1922 dc_inst.x5.net3 dc_inst.x5.x2/a_27_47# 0.00211f
C1923 dc_inst.x4.net9 dc_inst.x4.net11 0.00369f
C1924 dc_inst.x4.x17/a_27_47# dc_inst.x4.net13 0
C1925 dc_inst.x4.x7/a_27_47# dc_inst.x2.net12 0
C1926 VPWR _15_/a_288_47# 0
C1927 dc_inst.x1.net4 dc_inst.x8/a_247_21# 0
C1928 VPWR delay_sel[1] 0.41048f
C1929 dc_inst.x7.x9/a_27_47# dc_inst.x7.net9 0.01798f
C1930 dc_inst.x7.net4 dc_inst.x3.net16 0
C1931 dc_inst.net7 dc_inst.x7.net1 0.02072f
C1932 dc_inst.x4.net13 dc_inst.x5.net12 0
C1933 dc_inst.x5.net3 dc_inst.x5.x16/a_27_47# 0
C1934 dc_inst.x1.x15/a_27_47# dc_inst.x1.net14 0.04524f
C1935 dc_inst.x4.x2/a_27_47# dc_inst.x4.x4/a_27_47# 0.08729f
C1936 dc_inst.net6 dc_inst.in 0
C1937 dc_inst.x3.net13 rst 0
C1938 dc_inst.x2.net15 dc_inst.x2.x15/a_27_47# 0.00377f
C1939 dc_inst.x8/a_27_413# tdo 0
C1940 dc_inst.x3.net17 path_sel[2] 0
C1941 path_sel[0] _19_/a_109_297# 0
C1942 dc_inst.x7.net4 dc_inst.in 0.48195f
C1943 _16_/a_27_93# _07_ 0.00101f
C1944 dc_inst.x1.net13 dc_inst.x2.net10 0
C1945 dc_inst.x4.net8 dc_inst.x4.x11/a_27_47# 0.01154f
C1946 dc_inst.x5.net6 dc_inst.x5.net4 0.00711f
C1947 dc_inst.x4.x12/a_27_47# path_sel[0] 0
C1948 dc_inst.x4.x13/a_27_47# path_sel[2] 0
C1949 dc_inst.x1.net17 dc_inst.in 0
C1950 dc_inst.x9/a_750_97# dc_inst.x8/a_247_21# 0
C1951 dc_inst.x7.x6/a_27_47# dc_inst.x6.net9 0
C1952 dc_inst.x4.x5/a_27_47# tdo 0.0139f
C1953 dc_inst.x2.x11/a_27_47# path_sel[0] 0
C1954 dc_inst.x5.net6 dc_inst.x2.x4/a_27_47# 0.022f
C1955 dc_inst.x4.x6/a_27_47# dc_inst.x6.net12 0.01153f
C1956 dc_inst.x1.x7/a_27_47# dc_inst.x1.net2 0
C1957 _24_/a_543_47# _00_ 0.02975f
C1958 _13_/a_112_47# rst 0
C1959 delay_sel[0] _24_/a_761_289# 0
C1960 dc_inst.x5.net16 dc_inst.x6.net7 0.04145f
C1961 dc_inst.x4.net8 dc_inst.x2.net6 0
C1962 dc_inst.x6.x3/a_27_47# dc_inst.x5.x20/a_27_47# 0
C1963 dc_inst.x7.net16 dc_inst.x7.net3 0.00239f
C1964 dc_inst.x5.net3 dc_inst.x5.x3/a_27_47# 0.01613f
C1965 dc_inst.x9/a_757_363# dc_inst.x6.x1/a_27_47# 0
C1966 dc_inst.x6.net9 dc_inst.x5.net7 0
C1967 dc_inst.x1.net12 path_sel[2] 0.06975f
C1968 _03_ dc_inst.x9/a_247_21# 0
C1969 dc_inst.net3 _01_ 0
C1970 dc_inst.net1 dc_inst.in 0.36395f
C1971 dc_inst.x4.net18 dc_inst.x6.x6/a_27_47# 0.01151f
C1972 tdo _24_/a_1462_47# 0
C1973 dc_inst.x4.net7 dc_inst.x4.x7/a_27_47# 0.01872f
C1974 dc_inst.x5.net5 dc_inst.x1.x17/a_27_47# 0
C1975 dc_inst.x6.net1 dc_inst.x7.x5/a_27_47# 0
C1976 dc_inst.net3 dc_inst.x8/a_1290_413# 0.05491f
C1977 _24_/a_193_47# dc_inst.net9 0
C1978 dc_inst.x7.net14 rst 0
C1979 path_sel[1] dc_inst.x6.x3/a_27_47# 0
C1980 dc_inst.x5.x15/a_27_47# path_sel[0] 0
C1981 VPWR dc_inst.x9/a_757_363# -0.01426f
C1982 dc_inst.net6 dc_inst.x6.net17 0
C1983 VPWR _14_/a_218_374# -0
C1984 _13_/a_112_47# clknet_1_1__leaf_clk 0
C1985 _15_/a_288_47# path[5] 0.00385f
C1986 dc_inst.x1.net4 dc_inst.x3.net15 0
C1987 dc_inst.x1.net15 dc_inst.x1.x17/a_27_47# 0
C1988 _23_/a_543_47# shadow_q 0
C1989 path[5] delay_sel[1] 0
C1990 dc_inst.x5.net3 dc_inst.x4.x20/a_27_47# 0
C1991 dc_inst.net7 dc_inst.x7.net18 0.00316f
C1992 dc_inst.x2.x9/a_27_47# dc_inst.x1.x17/a_27_47# 0
C1993 dc_inst.x5.x12/a_27_47# dc_inst.x2.net10 0.01152f
C1994 dc_inst.x5.net6 dc_inst.x4.x7/a_27_47# 0
C1995 dc_inst.x4.net4 dc_inst.x2.net4 0
C1996 dc_inst.x5.x1/a_27_47# path_sel[2] 0
C1997 dc_inst.x1.x2/a_27_47# path_sel[2] 0.03035f
C1998 dc_inst.net3 _02_ 0
C1999 dc_inst.x7.net4 dc_inst.x6.net17 0.00254f
C2000 dc_inst.x4.net18 dc_inst.x4.x16/a_27_47# 0
C2001 dc_inst.x4.net13 dc_inst.x2.x8/a_27_47# 0
C2002 dc_inst.x3.net2 dc_inst.x3.x2/a_27_47# 0.0514f
C2003 dc_inst.x6.net17 dc_inst.x1.net17 0.00115f
C2004 dc_inst.x3.net18 dc_inst.x3.x18/a_27_47# 0.03666f
C2005 dc_inst.x5.net5 dc_inst.x5.x10/a_27_47# 0.00129f
C2006 dc_inst.net7 dc_inst.x7.x18/a_27_47# 0.0224f
C2007 dc_inst.x4.net8 dc_inst.x2.net12 0
C2008 _23_/a_761_289# _01_ 0
C2009 _23_/a_1283_21# rst 0
C2010 _08_ _18_/a_505_21# 0
C2011 dc_inst.x7.net7 dc_inst.x6.x3/a_27_47# 0
C2012 dc_inst.x9/a_247_21# dc_inst.x6.net2 0
C2013 dc_inst.x8/a_750_97# _23_/a_543_47# 0
C2014 dc_inst.x7.x12/a_27_47# _00_ 0
C2015 dc_inst.x4.net2 dc_inst.x1.x19/a_27_47# 0
C2016 dc_inst.net1 dc_inst.x6.net17 0.31441f
C2017 dc_inst.x4.x13/a_27_47# dc_inst.x6.net11 0
C2018 tdi dc_inst.x3.net9 0
C2019 dc_inst.x5.net3 VPWR 0.90866f
C2020 dc_inst.x5.net14 path_sel[0] 0.002f
C2021 dc_inst.x6.x15/a_27_47# dc_inst.x4.x4/a_27_47# 0
C2022 dc_inst.x3.x10/a_27_47# path[4] 0.00368f
C2023 dc_inst.x7.net4 dc_inst.x3.net17 0
C2024 tdo shadow_q 0
C2025 dc_inst.x1.net10 dc_inst.x5.net11 0.09748f
C2026 dc_inst.x1.net1 path[2] 0.00407f
C2027 dc_inst.x2.net15 dc_inst.x1.net19 0.00304f
C2028 _23_/a_761_289# _02_ 0.00132f
C2029 _23_/a_1283_21# clknet_1_1__leaf_clk 0
C2030 dc_inst.x7.net10 dc_inst.x7.x4/a_27_47# 0.00275f
C2031 dc_inst.x7.x12/a_27_47# clknet_1_0__leaf_clk 0.03745f
C2032 dc_inst.x5.net9 dc_inst.x1.x17/a_27_47# 0
C2033 dc_inst.x5.net15 path_sel[2] 0
C2034 dc_inst.x2.x4/a_27_47# path_sel[2] 0.00219f
C2035 dc_inst.x1.net4 dc_inst.x1.net14 0
C2036 dc_inst.x3.net10 dc_inst.x3.net6 0.00894f
C2037 dc_inst.x4.x9/a_27_47# dc_inst.x4.x11/a_27_47# 0.08729f
C2038 dc_inst.x6.net14 dc_inst.x6.x14/a_27_47# 0.00201f
C2039 dc_inst.x1.x13/a_27_47# dc_inst.x1.net8 0.03051f
C2040 dc_inst.x2.net2 dc_inst.x2.x5/a_27_47# 0
C2041 dc_inst.x3.net14 _00_ 0
C2042 dc_inst.x3.net11 dc_inst.x3.net2 0
C2043 _15_/a_600_345# path_sel[2] 0.00186f
C2044 dc_inst.x7.net5 dc_inst.in 0
C2045 dc_inst.x3.net7 dc_inst.x3.x18/a_27_47# 0.12258f
C2046 dc_inst.x8/a_834_97# dc_inst.x2.net18 0
C2047 VPWR dc_inst.x4.net10 0.04539f
C2048 tdo dc_inst.x4.x12/a_27_47# 0
C2049 path_sel[1] dc_inst.x5.x11/a_27_47# 0.01776f
C2050 dc_inst.x1.x3/a_27_47# path[4] 0.00109f
C2051 dc_inst.x9/a_277_47# dc_inst.x8/a_247_21# 0
C2052 dc_inst.x7.net15 dc_inst.x7.net19 0.06094f
C2053 dc_inst.x5.net19 dc_inst.x6.x11/a_27_47# 0
C2054 dc_inst.x4.net8 dc_inst.x4.net7 0.01401f
C2055 dc_inst.x3.net14 dc_inst.x3.x7/a_27_47# 0.05149f
C2056 dc_inst.x3.x8/a_27_47# _00_ 0
C2057 dc_inst.x7.net3 dc_inst.x3.x3/a_27_47# 0
C2058 dc_inst.x6.net14 dc_inst.x6.net15 0.01391f
C2059 VPWR dc_inst.x1.x13/a_27_47# -0.01126f
C2060 _24_/a_193_47# _24_/a_448_47# -0.00779f
C2061 dc_inst.x5.net12 _07_ 0
C2062 dc_inst.x1.net9 dc_inst.x1.x14/a_27_47# 0.01274f
C2063 dc_inst.x5.net9 dc_inst.x5.x10/a_27_47# 0.05039f
C2064 path_sel[1] dc_inst.x2.net8 0.02668f
C2065 dc_inst.x6.net3 dc_inst.x7.net8 0
C2066 dc_inst.x1.x15/a_27_47# _15_/a_288_47# 0
C2067 VPWR capture_q 0.05515f
C2068 _03_ _25_/a_543_47# 0
C2069 dc_inst.x4.x3/a_27_47# dc_inst.in 0
C2070 delay_sel[0] dc_inst.x5.x20/a_27_47# 0
C2071 dc_inst.x9/a_1290_413# dc_inst.x6.x16/a_27_47# 0
C2072 dc_inst.x3.net14 dc_inst.x3.x6/a_27_47# 0.00889f
C2073 dc_inst.x10/a_535_374# _01_ 0
C2074 dc_inst.net4 dc_inst.x6.net19 0
C2075 dc_inst.x3.net9 rst 0
C2076 path_sel[2] dc_inst.x4.x7/a_27_47# 0.00194f
C2077 dc_inst.x5.net3 dc_inst.x6.net6 0
C2078 dc_inst.x4.x13/a_27_47# dc_inst.x6.net10 0
C2079 dc_inst.x4.net19 dc_inst.x4.net16 0.00407f
C2080 dc_inst.x10/a_76_199# _23_/a_193_47# 0
C2081 dc_inst.net3 dc_inst.x3.net16 0
C2082 dc_inst.x10/a_505_21# _23_/a_27_47# 0
C2083 VPWR dc_inst.x9/a_247_21# -0.06411f
C2084 dc_inst.x4.net15 path_sel[0] 0.00279f
C2085 dc_inst.x2.net16 dc_inst.x1.net18 0
C2086 delay_sel[0] dc_inst.x1.x20/a_27_47# 0
C2087 dc_inst.x5.net2 dc_inst.net4 0.00143f
C2088 dc_inst.x6.x5/a_27_47# dc_inst.x7.x4/a_27_47# 0
C2089 dc_inst.x7.net11 delay_sel[1] 0.03196f
C2090 dc_inst.x3.x6/a_27_47# dc_inst.x3.x8/a_27_47# 0
C2091 dc_inst.x3.net6 path_sel[0] 0
C2092 dc_inst.x5.net8 path_sel[0] 0.00257f
C2093 dc_inst.x6.net18 dc_inst.x6.net15 0
C2094 _20_/a_384_47# dc_inst.in 0
C2095 dc_inst.x9/a_27_47# dc_inst.x7.net13 0
C2096 dc_inst.x4.net14 dc_inst.x5.net13 0
C2097 dc_inst.x1.x10/a_27_47# dc_inst.x1.net10 0.02773f
C2098 dc_inst.x4.net3 dc_inst.x1.x16/a_27_47# 0
C2099 dc_inst.x2.x19/a_27_47# dc_inst.net8 0
C2100 dc_inst.net3 dc_inst.in 0.05576f
C2101 dc_inst.x4.net12 dc_inst.x2.net7 0
C2102 dc_inst.x1.x7/a_27_47# dc_inst.x5.x11/a_27_47# 0.00122f
C2103 dc_inst.x1.net13 dc_inst.x8/a_1290_413# 0
C2104 tdo _25_/a_1108_47# 0
C2105 dc_inst.x2.x7/a_27_47# dc_inst.x2.net7 0.06006f
C2106 dc_inst.x4.x9/a_27_47# dc_inst.x2.net12 0
C2107 _04_ dc_inst.x1.x5/a_27_47# 0
C2108 dc_inst.x2.net10 dc_inst.x2.x7/a_27_47# 0
C2109 dc_inst.x6.x17/a_27_47# delay_sel[1] 0.0012f
C2110 path_sel[1] dc_inst.x5.net18 0.0028f
C2111 dc_inst.x1.x18/a_27_47# dc_inst.in 0
C2112 _23_/a_27_47# rst 0.0321f
C2113 dc_inst.x6.net14 dc_inst.x5.net7 0.0014f
C2114 dc_inst.x6.x14/a_27_47# dc_inst.x1.net19 0
C2115 clkbuf_1_0__f_clk/a_110_47# delay_sel[1] 0.00532f
C2116 dc_inst.x3.x4/a_27_47# dc_inst.x3.net18 0.00173f
C2117 dc_inst.x4.x3/a_27_47# dc_inst.x6.net17 0
C2118 dc_inst.x3.net15 delay_sel[2] 0
C2119 dc_inst.x4.x16/a_27_47# dc_inst.x5.net6 0
C2120 VPWR _19_/a_465_47# -0
C2121 dc_inst.x5.x20/a_27_47# dc_inst.x7.net1 0.00555f
C2122 dc_inst.x5.net5 dc_inst.x5.x4/a_27_47# 0.0087f
C2123 dc_inst.x6.net4 dc_inst.x6.x3/a_27_47# 0.04368f
C2124 dc_inst.x3.net16 _23_/a_761_289# 0
C2125 dc_inst.net4 dc_inst.x7.x15/a_27_47# 0
C2126 dc_inst.x3.net19 _01_ 0
C2127 dc_inst.x1.x4/a_27_47# dc_inst.x1.net9 0
C2128 dc_inst.x1.net9 dc_inst.x1.x8/a_27_47# 0.00366f
C2129 dc_inst.x4.net11 dc_inst.x6.net7 0
C2130 dc_inst.x7.x11/a_27_47# dc_inst.x7.net1 0.01241f
C2131 dc_inst.x8/a_1290_413# dc_inst.x3.net19 0.00586f
C2132 dc_inst.x2.x4/a_27_47# dc_inst.x1.net17 0
C2133 _23_/a_27_47# clknet_1_1__leaf_clk 0
C2134 dc_inst.x6.x3/a_27_47# dc_inst.x5.net19 0.01646f
C2135 _15_/a_27_47# dc_inst.x1.net3 0.02437f
C2136 _24_/a_193_47# delay_sel[2] 0.02948f
C2137 _24_/a_27_47# dc_inst.net8 0
C2138 _23_/a_761_289# dc_inst.in 0
C2139 dc_inst.x5.net2 dc_inst.x6.net8 0
C2140 dc_inst.x5.net12 _09_ 0
C2141 dc_inst.net2 dc_inst.x7.x3/a_27_47# 0.01004f
C2142 dc_inst.x1.net10 dc_inst.x5.net1 0.00221f
C2143 delay_sel[1] dc_inst.net9 0.15641f
C2144 dc_inst.net3 dc_inst.x6.net17 0.00287f
C2145 _04_ path_sel[0] 0.02866f
C2146 dc_inst.x4.net1 dc_inst.x4.x10/a_27_47# 0.00882f
C2147 _07_ _17_/a_27_93# 0.0128f
C2148 dc_inst.x1.net15 dc_inst.x8/a_757_363# 0
C2149 dc_inst.x7.x7/a_27_47# dc_inst.x5.x20/a_27_47# 0.01191f
C2150 dc_inst.x3.x20/a_27_47# dc_inst.x3.x15/a_27_47# 0
C2151 delay_sel[0] dc_inst.x7.x16/a_27_47# 0.01427f
C2152 dc_inst.x3.net7 dc_inst.x3.net8 0.02663f
C2153 dc_inst.x5.net3 dc_inst.x4.net9 0
C2154 dc_inst.x4.net1 dc_inst.x4.net16 0.00321f
C2155 dc_inst.x1.x14/a_27_47# dc_inst.x2.net12 0
C2156 dc_inst.x1.net7 _07_ 0
C2157 dc_inst.x4.net8 path_sel[2] 0.00182f
C2158 dc_inst.x7.x10/a_27_47# dc_inst.x9/a_27_413# 0
C2159 dc_inst.net3 path[6] 0.004f
C2160 dc_inst.x2.net2 dc_inst.x2.x4/a_27_47# 0
C2161 dc_inst.x1.x5/a_27_47# dc_inst.x1.net5 0.01301f
C2162 dc_inst.x6.net17 dc_inst.x1.x18/a_27_47# 0.00109f
C2163 dc_inst.x5.net2 dc_inst.x5.x19/a_27_47# 0
C2164 path[2] path[1] 0.09164f
C2165 dc_inst.x7.net2 dc_inst.x7.net7 0
C2166 dc_inst.x7.net3 dc_inst.x10/a_218_47# 0.00134f
C2167 dc_inst.x2.x20/a_27_47# dc_inst.x2.net16 0
C2168 path_sel[1] dc_inst.x1.net6 0
C2169 dc_inst.x1.net17 dc_inst.x4.x7/a_27_47# 0
C2170 dc_inst.x8/a_750_97# dc_inst.x7.net3 0
C2171 dc_inst.x4.x9/a_27_47# dc_inst.x5.net6 0
C2172 dc_inst.x6.net10 dc_inst.x4.x18/a_27_47# 0
C2173 dc_inst.x7.net7 dc_inst.x7.net1 0.00134f
C2174 dc_inst.x1.net4 _15_/a_288_47# 0.00232f
C2175 dc_inst.x1.net4 delay_sel[1] 0
C2176 dc_inst.x4.net8 dc_inst.x6.x7/a_27_47# 0
C2177 dc_inst.x6.x6/a_27_47# path_sel[2] 0
C2178 dc_inst.x6.net12 dc_inst.x6.x14/a_27_47# 0.14849f
C2179 _23_/a_805_47# shadow_q 0
C2180 dc_inst.x4.net14 dc_inst.x4.x20/a_27_47# 0
C2181 dc_inst.x1.x16/a_27_47# dc_inst.x2.net15 0.0322f
C2182 dc_inst.x5.x20/a_27_47# dc_inst.x7.net18 0
C2183 VPWR _25_/a_543_47# 0.00538f
C2184 dc_inst.x4.net15 tdo 0
C2185 dc_inst.x5.net5 dc_inst.x5.x7/a_27_47# 0
C2186 dc_inst.x5.net9 dc_inst.x5.x4/a_27_47# 0.03031f
C2187 dc_inst.x4.net9 dc_inst.x4.net10 0.01448f
C2188 dc_inst.x5.net7 dc_inst.x1.net19 0
C2189 dc_inst.x7.net19 _00_ 0
C2190 path_sel[1] path[2] 0
C2191 dc_inst.net1 dc_inst.x4.x7/a_27_47# 0
C2192 dc_inst.x3.x10/a_27_47# _15_/a_788_316# 0
C2193 dc_inst.x2.net17 dc_inst.net8 0
C2194 dc_inst.x1.net10 dc_inst.x4.net5 0
C2195 dc_inst.x3.net11 dc_inst.x3.net12 0.21131f
C2196 _24_/a_1108_47# dc_inst.x7.x3/a_27_47# 0
C2197 dc_inst.x5.net8 tdo 0.0347f
C2198 dc_inst.x5.net2 dc_inst.x5.x18/a_27_47# 0
C2199 dc_inst.x3.net1 dc_inst.x3.net13 0.18601f
C2200 dc_inst.x3.net10 dc_inst.x3.net14 0
C2201 dc_inst.x3.x18/a_27_47# dc_inst.x1.net3 0
C2202 dc_inst.x6.net14 dc_inst.x6.net18 0
C2203 dc_inst.x5.net19 dc_inst.x7.x5/a_27_47# 0
C2204 dc_inst.x6.x8/a_27_47# dc_inst.x5.net14 0
C2205 dc_inst.x7.net9 delay_sel[1] 0
C2206 dc_inst.x2.net2 dc_inst.x4.x7/a_27_47# 0.0016f
C2207 dc_inst.x6.net12 dc_inst.x6.net15 0.01302f
C2208 dc_inst.x10/a_535_374# dc_inst.in 0
C2209 _13_/a_112_47# dc_inst.x3.x15/a_27_47# 0
C2210 _25_/a_27_47# _24_/a_27_47# 0
C2211 dc_inst.x7.x7/a_27_47# dc_inst.x7.net7 0.12789f
C2212 dc_inst.x9/a_750_97# delay_sel[1] 0.04375f
C2213 dc_inst.x7.net16 dc_inst.x10/a_76_199# 0
C2214 _24_/a_543_47# _23_/a_543_47# 0
C2215 clknet_1_0__leaf_clk dc_inst.x7.net19 0.00151f
C2216 dc_inst.x7.x16/a_27_47# dc_inst.x7.net1 0.00896f
C2217 dc_inst.x1.x15/a_27_47# dc_inst.x1.x13/a_27_47# 0
C2218 path_sel[0] dc_inst.x1.net5 0
C2219 dc_inst.x2.net18 dc_inst.x8/a_277_47# 0.00126f
C2220 dc_inst.x2.net9 dc_inst.x2.x5/a_27_47# 0.01151f
C2221 dc_inst.x5.net12 dc_inst.x5.x10/a_27_47# 0.00809f
C2222 dc_inst.x7.x10/a_27_47# dc_inst.x9/a_193_413# 0
C2223 _15_/a_1279_413# path[7] 0
C2224 VPWR dc_inst.x4.net14 0.00411f
C2225 dc_inst.x2.net15 dc_inst.x1.x19/a_27_47# 0
C2226 dc_inst.x7.net3 dc_inst.x3.x1/a_27_47# 0.00182f
C2227 dc_inst.x9/a_1290_413# dc_inst.x6.net13 0
C2228 dc_inst.net2 dc_inst.x8/a_757_363# 0.00318f
C2229 dc_inst.x2.net7 dc_inst.x1.net18 0
C2230 dc_inst.x2.net14 dc_inst.x1.x17/a_27_47# 0.0026f
C2231 dc_inst.x1.net13 dc_inst.in 0
C2232 delay_sel[0] _23_/a_193_47# 0
C2233 dc_inst.x3.x14/a_27_47# dc_inst.x3.x13/a_27_47# 0
C2234 _09_ _17_/a_27_93# 0.00109f
C2235 dc_inst.x1.x6/a_27_47# _04_ 0.0107f
C2236 dc_inst.x5.net2 dc_inst.x4.net18 0
C2237 path[1] dc_inst.x5.net10 0
C2238 VPWR dc_inst.x2.x13/a_27_47# 0
C2239 delay_sel[0] dc_inst.x6.net4 0
C2240 dc_inst.x1.net7 _09_ 0.00208f
C2241 _24_/a_193_47# _25_/a_1283_21# 0
C2242 dc_inst.x3.net14 path_sel[0] 0
C2243 _15_/a_27_47# dc_inst.x3.net4 0
C2244 VPWR dc_inst.x2.net18 0.05417f
C2245 dc_inst.x6.net14 dc_inst.x1.net19 0
C2246 dc_inst.x6.net5 dc_inst.x9/a_757_363# 0
C2247 shadow_q dc_inst.x3.x2/a_27_47# 0
C2248 VPWR dc_inst.x2.x2/a_27_47# 0.01421f
C2249 delay_sel[0] dc_inst.x5.net19 0
C2250 dc_inst.x5.x7/a_27_47# dc_inst.x5.net9 0.02951f
C2251 dc_inst.x2.net14 dc_inst.x5.x10/a_27_47# 0
C2252 dc_inst.x7.x8/a_27_47# dc_inst.x6.net2 0.0296f
C2253 dc_inst.x6.net12 dc_inst.x5.net7 0
C2254 _24_/a_543_47# tdo 0
C2255 path_sel[1] dc_inst.x5.net10 0.00551f
C2256 path[3] dc_inst.x1.x11/a_27_47# 0
C2257 dc_inst.x5.x17/a_27_47# dc_inst.x6.x2/a_27_47# 0
C2258 dc_inst.x4.x9/a_27_47# path_sel[2] 0
C2259 _23_/a_193_47# _23_/a_448_47# -0.00373f
C2260 dc_inst.x3.net19 dc_inst.in 0
C2261 dc_inst.x6.x9/a_27_47# dc_inst.x6.x6/a_27_47# 0
C2262 dc_inst.x8/a_193_413# dc_inst.x1.net18 0
C2263 dc_inst.x6.net3 dc_inst.x7.net12 0
C2264 dc_inst.x9/a_757_363# dc_inst.x9/a_750_97# -0.0095f
C2265 se _14_/a_218_374# 0.00206f
C2266 dc_inst.x2.x20/a_27_47# dc_inst.x2.x17/a_27_47# 0
C2267 dc_inst.x3.net3 _00_ 0
C2268 dc_inst.x7.x16/a_27_47# dc_inst.x7.net18 0.01547f
C2269 dc_inst.x5.net13 dc_inst.x5.x2/a_27_47# 0.03174f
C2270 dc_inst.x5.net18 dc_inst.x5.net19 0.01983f
C2271 _13_/a_112_47# _13_/a_27_297# -0.00287f
C2272 dc_inst.x8/a_834_97# dc_inst.x8/a_277_47# -0.00465f
C2273 dc_inst.x4.net14 dc_inst.x6.net6 0
C2274 dc_inst.x1.net7 dc_inst.x1.x17/a_27_47# 0
C2275 dc_inst.x9/a_247_21# clkbuf_1_0__f_clk/a_110_47# 0.00138f
C2276 dc_inst.x8/a_750_97# dc_inst.x3.x2/a_27_47# 0
C2277 path_sel[1] dc_inst.x4.x6/a_27_47# 0.0027f
C2278 dc_inst.x1.x11/a_27_47# _19_/a_27_47# 0
C2279 dc_inst.x5.net13 dc_inst.x5.x16/a_27_47# 0.01107f
C2280 dc_inst.x6.x18/a_27_47# dc_inst.x6.x15/a_27_47# 0
C2281 dc_inst.x4.net1 dc_inst.x4.x5/a_27_47# 0
C2282 dc_inst.x5.net12 _18_/a_76_199# 0
C2283 dc_inst.x3.net5 _13_/a_470_47# 0.00156f
C2284 delay_sel[0] dc_inst.x3.net2 0
C2285 dc_inst.x2.net2 dc_inst.x4.net8 0
C2286 dc_inst.x5.x20/a_27_47# dc_inst.x7.net14 0
C2287 dc_inst.x6.net4 dc_inst.x7.net1 0
C2288 dc_inst.x3.net11 shadow_q 0
C2289 dc_inst.x7.net2 dc_inst.x5.net19 0
C2290 dc_inst.x2.net10 dc_inst.x1.x9/a_27_47# 0
C2291 dc_inst.x8/a_27_413# dc_inst.x10/a_76_199# 0
C2292 dc_inst.x4.x8/a_27_47# dc_inst.x4.x7/a_27_47# 0.01543f
C2293 dc_inst.x7.net6 dc_inst.x6.net16 0
C2294 dc_inst.x4.x10/a_27_47# dc_inst.x2.net8 0.00145f
C2295 dc_inst.x5.net19 dc_inst.x7.net1 0.00377f
C2296 dc_inst.x1.net14 dc_inst.x1.net16 0
C2297 dc_inst.x8/a_834_97# VPWR -0
C2298 dc_inst.x5.net3 dc_inst.x4.x14/a_27_47# 0.03973f
C2299 dc_inst.x6.net14 dc_inst.x6.net12 0.11713f
C2300 dc_inst.x9/a_277_47# delay_sel[1] 0.77113f
C2301 _06_ _15_/a_1281_47# 0
C2302 _24_/a_761_289# _23_/a_27_47# 0.00135f
C2303 dc_inst.x1.x14/a_27_47# path_sel[2] 0.0113f
C2304 delay_sel[2] delay_sel[1] 0.05854f
C2305 dc_inst.x1.net3 dc_inst.x2.net19 0
C2306 dc_inst.x5.net11 _07_ 0
C2307 dc_inst.x7.x20/a_27_47# capture_d 0.00687f
C2308 dc_inst.x1.net4 dc_inst.x1.x13/a_27_47# 0.00168f
C2309 dc_inst.x3.x16/a_27_47# _00_ 0
C2310 dc_inst.x4.net18 dc_inst.x4.x19/a_27_47# 0.049f
C2311 dc_inst.x5.x8/a_27_47# dc_inst.x4.x7/a_27_47# 0
C2312 VPWR dc_inst.x7.x8/a_27_47# 0.00149f
C2313 dc_inst.x3.net19 path[6] 0.13869f
C2314 dc_inst.x1.net4 capture_q 0
C2315 dc_inst.x3.x14/a_27_47# path[4] 0.00167f
C2316 dc_inst.x5.x5/a_27_47# dc_inst.x5.net7 0.0292f
C2317 dc_inst.x7.x2/a_27_47# capture_d 0
C2318 dc_inst.x7.x7/a_27_47# dc_inst.x5.net19 0.01484f
C2319 dc_inst.x6.net18 rst 0
C2320 dc_inst.x4.net3 path_sel[1] 0
C2321 dc_inst.x5.net12 dc_inst.x5.x4/a_27_47# 0.00446f
C2322 dc_inst.x6.net12 dc_inst.x6.net18 0
C2323 dc_inst.x3.net1 dc_inst.x3.net9 0.31174f
C2324 dc_inst.x4.net19 dc_inst.x5.x15/a_27_47# 0
C2325 dc_inst.x1.net13 dc_inst.x1.net12 0.02494f
C2326 delay_sel[1] dc_inst.x7.net17 0.00183f
C2327 _06_ path[3] 0.00618f
C2328 dc_inst.x7.net7 dc_inst.x7.net14 0
C2329 VPWR dc_inst.x5.x6/a_27_47# 0.00677f
C2330 dc_inst.x1.net9 dc_inst.x2.x16/a_27_47# 0.00103f
C2331 dc_inst.x3.net19 dc_inst.x3.net17 0.03741f
C2332 tdo dc_inst.x6.net16 0.0053f
C2333 _24_/a_27_47# clkload0/X 0
C2334 _15_/a_27_47# path_sel[2] 0.00256f
C2335 dc_inst.x2.x3/a_27_47# dc_inst.x2.net7 0
C2336 dc_inst.x5.net6 dc_inst.x6.net19 0
C2337 path[3] _15_/a_1281_47# 0
C2338 delay_sel[0] dc_inst.x7.net16 0.01385f
C2339 se capture_q 0
C2340 path[4] path[7] 0.17682f
C2341 _23_/a_27_47# dc_inst.x3.x15/a_27_47# 0
C2342 _06_ _19_/a_27_47# 0.00135f
C2343 dc_inst.x1.net15 dc_inst.x1.net9 0.02472f
C2344 dc_inst.x1.net13 dc_inst.x1.x2/a_27_47# 0
C2345 dc_inst.x5.net19 dc_inst.x7.net18 0.00164f
C2346 dc_inst.x9/a_750_97# dc_inst.x9/a_247_21# -0.00559f
C2347 dc_inst.x9/a_757_363# dc_inst.x9/a_277_47# -0
C2348 _13_/a_470_297# dc_inst.x3.net8 0.00166f
C2349 dc_inst.x5.net3 dc_inst.x6.net7 0
C2350 _14_/a_439_47# dc_inst.x3.net8 0
C2351 VPWR dc_inst.x5.net13 -0.00634f
C2352 _17_/a_27_93# _18_/a_76_199# 0
C2353 _17_/a_174_21# _18_/a_505_21# 0.00151f
C2354 dc_inst.x7.x16/a_27_47# dc_inst.x7.net14 0
C2355 dc_inst.x1.x10/a_27_47# _07_ 0.00139f
C2356 dc_inst.x1.x4/a_27_47# path_sel[2] 0.01588f
C2357 VPWR _03_ -0.02381f
C2358 path_sel[2] dc_inst.x1.x8/a_27_47# 0.00573f
C2359 clkbuf_1_0__f_clk/a_110_47# _25_/a_543_47# 0.00856f
C2360 dc_inst.x4.net19 dc_inst.x5.net14 0.05398f
C2361 dc_inst.x6.net12 dc_inst.x1.net19 0
C2362 dc_inst.x5.x12/a_27_47# dc_inst.x1.net12 0
C2363 dc_inst.x4.net8 dc_inst.x4.x8/a_27_47# 0.04557f
C2364 dc_inst.x8/a_27_47# dc_inst.x9/a_1290_413# 0
C2365 capture_q _24_/a_448_47# 0
C2366 dc_inst.x4.net5 dc_inst.net8 0
C2367 dc_inst.x2.x2/a_27_47# dc_inst.x4.net9 0
C2368 tdi rst 0.19219f
C2369 _13_/a_27_297# dc_inst.x3.net9 0
C2370 _15_/a_872_316# dc_inst.x3.x13/a_27_47# 0
C2371 dc_inst.x4.x2/a_27_47# dc_inst.x2.net17 0
C2372 VPWR dc_inst.x1.x12/a_27_47# 0.003f
C2373 dc_inst.x9/a_757_363# dc_inst.x7.net17 0
C2374 VPWR dc_inst.x5.x2/a_27_47# 0.07214f
C2375 dc_inst.x5.net5 dc_inst.x2.net6 0.07421f
C2376 dc_inst.x5.net12 dc_inst.x5.x7/a_27_47# 0
C2377 dc_inst.x7.net2 dc_inst.x7.net16 0
C2378 dc_inst.x7.x15/a_27_47# dc_inst.x7.x19/a_27_47# 0
C2379 dc_inst.x2.x19/a_27_47# dc_inst.x7.x3/a_27_47# 0
C2380 dc_inst.x4.net10 dc_inst.x6.net7 0
C2381 path[3] _19_/a_27_47# 0.02078f
C2382 dc_inst.x7.x1/a_27_47# dc_inst.x6.net17 0
C2383 dc_inst.x1.net15 dc_inst.x1.net3 0
C2384 VPWR dc_inst.x5.x16/a_27_47# 0.02434f
C2385 dc_inst.x5.net17 dc_inst.x6.x2/a_27_47# 0
C2386 dc_inst.x7.net16 dc_inst.x7.net1 0.00564f
C2387 dc_inst.x1.net15 dc_inst.x2.net6 0
C2388 dc_inst.x4.net13 dc_inst.x4.net17 0.05658f
C2389 dc_inst.net4 dc_inst.x7.net10 0
C2390 dc_inst.x2.x9/a_27_47# dc_inst.x2.net6 0.01435f
C2391 dc_inst.x6.x1/a_27_47# dc_inst.x6.net2 0.0023f
C2392 dc_inst.x3.x4/a_27_47# dc_inst.x3.net4 0.13315f
C2393 dc_inst.x1.net9 dc_inst.x5.net9 0
C2394 tdi clknet_1_1__leaf_clk 0.00213f
C2395 delay_sel[1] _25_/a_1283_21# 0
C2396 dc_inst.x10/a_505_21# rst 0.07933f
C2397 dc_inst.net5 dc_inst.x6.net19 0.02517f
C2398 dc_inst.x4.x1/a_27_47# dc_inst.x4.x2/a_27_47# 0.01018f
C2399 clknet_1_0__leaf_clk dc_inst.x7.x14/a_27_47# 0
C2400 dc_inst.x6.net9 dc_inst.x6.net1 0.01816f
C2401 path_sel[1] dc_inst.x2.net15 0.0016f
C2402 VPWR dc_inst.x6.net2 0.89378f
C2403 dc_inst.x2.net6 dc_inst.x2.net3 0
C2404 _07_ dc_inst.x5.net1 0.02988f
C2405 dc_inst.x6.net19 path_sel[2] 0.00257f
C2406 _02_ _24_/a_639_47# 0
C2407 VPWR dc_inst.x5.x3/a_27_47# -0.0056f
C2408 dc_inst.x3.x20/a_27_47# dc_inst.x3.net2 0.04519f
C2409 dc_inst.x7.net6 dc_inst.x7.net19 0
C2410 dc_inst.x8/a_27_413# delay_sel[0] 0.039f
C2411 dc_inst.x4.x17/a_27_47# dc_inst.net4 0.00444f
C2412 _20_/a_79_21# _19_/a_109_297# 0
C2413 dc_inst.x4.net19 dc_inst.x4.net15 0.00161f
C2414 _24_/a_27_47# dc_inst.x7.x3/a_27_47# 0
C2415 dc_inst.x5.net2 path_sel[2] 0
C2416 dc_inst.net4 dc_inst.x5.net12 0
C2417 _10_ path[4] 0
C2418 dc_inst.x3.net11 dc_inst.x3.net6 0
C2419 dc_inst.x1.net15 dc_inst.x2.net12 0
C2420 dc_inst.x5.x5/a_27_47# dc_inst.x1.net19 0
C2421 dc_inst.x2.x9/a_27_47# dc_inst.x2.net12 0.00124f
C2422 dc_inst.net4 dc_inst.x6.x5/a_27_47# 0.01971f
C2423 delay_sel[2] capture_q 0.00188f
C2424 dc_inst.x5.net9 dc_inst.x2.net6 0.02742f
C2425 VPWR dc_inst.x4.x20/a_27_47# 0.01627f
C2426 dc_inst.x3.net13 dc_inst.x3.net2 0
C2427 dc_inst.x5.net2 dc_inst.x6.x7/a_27_47# 0
C2428 dc_inst.x1.net1 dc_inst.x1.x11/a_27_47# 0.12862f
C2429 dc_inst.x6.net8 dc_inst.x7.net10 0
C2430 VPWR dc_inst.x8/a_277_47# -0.01878f
C2431 dc_inst.x2.x10/a_27_47# dc_inst.x1.net9 0
C2432 dc_inst.x1.x16/a_27_47# dc_inst.x1.net19 0
C2433 dc_inst.x5.net19 dc_inst.x7.net14 0
C2434 dc_inst.x7.net16 dc_inst.x7.net18 0.02038f
C2435 clknet_1_1__leaf_clk rst 0.70232f
C2436 path_sel[0] dc_inst.x3.net3 0
C2437 VPWR _17_/a_478_47# -0
C2438 dc_inst.x8/a_1290_413# dc_inst.x2.x20/a_27_47# 0.01118f
C2439 dc_inst.net2 dc_inst.x1.net3 0
C2440 dc_inst.x9/a_247_21# dc_inst.x9/a_277_47# -0.00594f
C2441 dc_inst.x6.x15/a_27_47# dc_inst.x6.x16/a_27_47# 0
C2442 dc_inst.x6.x3/a_27_47# dc_inst.x5.x15/a_27_47# 0
C2443 VPWR dc_inst.x1.net8 0.12554f
C2444 dc_inst.x2.net3 dc_inst.x2.net12 0
C2445 dc_inst.x3.net5 _13_/a_112_47# 0
C2446 _23_/a_1283_21# _23_/a_193_47# -0
C2447 dc_inst.x4.x13/a_27_47# dc_inst.x4.net12 0.05174f
C2448 VPWR dc_inst.x6.x1/a_27_47# 0.0032f
C2449 dc_inst.x5.net6 dc_inst.x4.x4/a_27_47# 0
C2450 capture_d dc_inst.net8 0.00218f
C2451 dc_inst.x7.x18/a_27_47# dc_inst.x7.net16 0.00156f
C2452 path[5] _15_/a_1060_369# 0.00119f
C2453 path[4] _15_/a_872_316# 0.00547f
C2454 dc_inst.x6.net6 dc_inst.x6.net2 0
C2455 tdo dc_inst.x7.net19 0.00598f
C2456 _15_/a_788_316# dc_inst.x3.x14/a_27_47# 0
C2457 path_sel[1] dc_inst.x6.net9 0.00282f
C2458 dc_inst.x1.net4 dc_inst.x2.net18 0.00475f
C2459 dc_inst.x8/a_27_47# dc_inst.net8 0.00108f
C2460 dc_inst.x3.net15 dc_inst.x3.x13/a_27_47# 0
C2461 dc_inst.x9/a_247_21# dc_inst.x7.net17 0.00204f
C2462 dc_inst.x1.x19/a_27_47# dc_inst.x1.net19 0.00336f
C2463 dc_inst.x4.net14 dc_inst.x4.x14/a_27_47# 0.00273f
C2464 dc_inst.x5.net12 dc_inst.x6.net8 0
C2465 dc_inst.x4.x9/a_27_47# dc_inst.x5.x8/a_27_47# 0
C2466 dc_inst.net6 clknet_0_clk 0
C2467 clknet_0_clk _25_/a_1462_47# 0
C2468 dc_inst.x5.net9 dc_inst.x2.net12 0
C2469 path_sel[1] dc_inst.x6.x14/a_27_47# 0
C2470 dc_inst.x1.net18 dc_inst.in 0
C2471 dc_inst.x5.net6 dc_inst.x5.net5 0.0282f
C2472 dc_inst.x2.x10/a_27_47# dc_inst.x2.net6 0
C2473 dc_inst.net6 dc_inst.x6.net19 0.01054f
C2474 dc_inst.x7.net4 clknet_0_clk 0
C2475 dc_inst.x7.x17/a_27_47# dc_inst.x9/a_668_97# 0
C2476 _15_/a_788_316# path[7] 0.0501f
C2477 dc_inst.x6.x3/a_27_47# dc_inst.x5.net14 0
C2478 dc_inst.x5.net7 dc_inst.x6.net1 0
C2479 _04_ dc_inst.x3.net11 0
C2480 dc_inst.x3.net6 _15_/a_1064_47# 0
C2481 dc_inst.x6.net6 dc_inst.x4.x20/a_27_47# 0.021f
C2482 dc_inst.x1.net15 dc_inst.x5.net6 0
C2483 dc_inst.x7.net4 dc_inst.x6.net19 0.05767f
C2484 path_sel[2] dc_inst.x2.net19 0.00124f
C2485 dc_inst.x4.net1 dc_inst.x5.net8 0
C2486 dc_inst.x5.x1/a_27_47# dc_inst.x4.net12 0.00265f
C2487 dc_inst.x8/a_1478_413# path_sel[2] 0.00111f
C2488 dc_inst.x3.x19/a_27_47# dc_inst.x3.x2/a_27_47# 0.01254f
C2489 dc_inst.x4.net7 dc_inst.x2.net3 0
C2490 dc_inst.x3.net5 _23_/a_1283_21# 0
C2491 dc_inst.x1.net5 dc_inst.x3.x2/a_27_47# 0
C2492 _14_/a_505_21# path[7] 0
C2493 _13_/a_470_47# shadow_q -0.0072f
C2494 dc_inst.x2.net15 dc_inst.x2.x14/a_27_47# 0.00116f
C2495 _25_/a_27_47# capture_d 0
C2496 _03_ dc_inst.x7.net11 0
C2497 dc_inst.x2.x1/a_27_47# dc_inst.x4.net7 0.01355f
C2498 dc_inst.x5.net9 dc_inst.x2.net13 0
C2499 dc_inst.x5.net6 dc_inst.x2.net3 0.00626f
C2500 dc_inst.x6.x12/a_27_47# dc_inst.x6.x5/a_27_47# 0.04629f
C2501 dc_inst.net1 dc_inst.x6.net19 0
C2502 VPWR dc_inst.x6.net6 0.10599f
C2503 VPWR dc_inst.x3.x5/a_27_47# 0.06445f
C2504 _01_ _00_ 0
C2505 VPWR path[5] 0.31985f
C2506 dc_inst.x3.x11/a_27_47# path[4] 0
C2507 dc_inst.x2.net16 tdo 0
C2508 dc_inst.x4.net7 dc_inst.x5.net9 0
C2509 path_sel[1] dc_inst.x2.net1 0.02686f
C2510 dc_inst.net7 rst 0.00734f
C2511 dc_inst.x10/a_505_21# _23_/a_651_413# 0
C2512 dc_inst.x2.x10/a_27_47# dc_inst.x2.net12 0
C2513 dc_inst.x1.net9 dc_inst.x5.net12 0
C2514 dc_inst.x3.net14 dc_inst.x3.x2/a_27_47# 0
C2515 dc_inst.x2.x1/a_27_47# dc_inst.x5.net6 0.02471f
C2516 dc_inst.x7.net7 dc_inst.x6.net15 0
C2517 dc_inst.x4.x4/a_27_47# path_sel[2] 0
C2518 shadow_q _23_/a_448_47# 0
C2519 dc_inst.x8/a_750_97# delay_sel[0] 0.01114f
C2520 dc_inst.x4.net12 dc_inst.x5.net15 0.0029f
C2521 _03_ clkbuf_1_0__f_clk/a_110_47# 0.01636f
C2522 dc_inst.net2 dc_inst.x3.net4 0
C2523 dc_inst.x9/a_277_47# _25_/a_543_47# 0
C2524 dc_inst.x4.net12 dc_inst.x4.x18/a_27_47# 0.01151f
C2525 dc_inst.in dc_inst.x1.x9/a_27_47# 0
C2526 clknet_1_0__leaf_clk _01_ 0
C2527 dc_inst.x5.net6 dc_inst.x5.net9 0.04481f
C2528 _04_ dc_inst.x1.net2 0.00119f
C2529 delay_sel[2] _25_/a_543_47# 0
C2530 _02_ _00_ 0.09234f
C2531 _13_/a_470_297# _24_/a_1108_47# 0
C2532 _23_/a_27_47# _23_/a_193_47# -0.04261f
C2533 dc_inst.x5.net1 dc_inst.x5.x10/a_27_47# 0.00105f
C2534 path_sel[1] dc_inst.x5.net7 0.05363f
C2535 dc_inst.x1.net1 path[3] 0
C2536 _20_/a_384_47# _15_/a_27_47# 0
C2537 dc_inst.x1.net10 _10_ 0
C2538 dc_inst.x1.x13/a_27_47# dc_inst.x1.net16 0
C2539 dc_inst.x8/a_668_97# dc_inst.x9/a_1290_413# 0
C2540 dc_inst.x4.x2/a_27_47# dc_inst.x4.net5 0.0255f
C2541 dc_inst.x6.x20/a_27_47# delay_sel[1] 0.00214f
C2542 _20_/a_79_21# dc_inst.x3.net6 0
C2543 dc_inst.x2.x16/a_27_47# path_sel[2] 0.01151f
C2544 dc_inst.x3.x7/a_27_47# _02_ 0
C2545 dc_inst.net3 _15_/a_27_47# 0
C2546 dc_inst.x4.x1/a_27_47# dc_inst.x8/a_757_363# 0
C2547 dc_inst.x2.net7 path_sel[0] 0.00121f
C2548 dc_inst.x4.net5 dc_inst.x1.x17/a_27_47# 0.00333f
C2549 dc_inst.net5 _25_/a_193_47# 0
C2550 dc_inst.x2.x20/a_27_47# dc_inst.in 0.05418f
C2551 dc_inst.x4.net18 dc_inst.x5.net12 0.04961f
C2552 dc_inst.x7.net9 dc_inst.x7.x8/a_27_47# 0.00325f
C2553 dc_inst.x2.net10 path_sel[0] 0
C2554 dc_inst.x1.net9 dc_inst.x2.net14 0.04266f
C2555 _00_ _25_/a_448_47# 0.01459f
C2556 dc_inst.x7.net19 dc_inst.x7.net3 0.23399f
C2557 dc_inst.x7.net7 dc_inst.x7.x6/a_27_47# 0.04269f
C2558 dc_inst.x7.net17 _25_/a_543_47# 0
C2559 dc_inst.x3.x20/a_27_47# dc_inst.x3.x3/a_27_47# 0.01191f
C2560 dc_inst.x7.net12 _00_ 0
C2561 dc_inst.x3.x6/a_27_47# _02_ 0
C2562 dc_inst.x5.net12 dc_inst.x2.net6 0.03666f
C2563 dc_inst.x1.net15 path_sel[2] 0.06904f
C2564 dc_inst.x3.net13 dc_inst.x3.net12 0.16698f
C2565 dc_inst.x3.net14 dc_inst.x3.net11 0
C2566 dc_inst.x4.net13 dc_inst.x2.x12/a_27_47# 0
C2567 VPWR dc_inst.x3.x12/a_27_47# 0.0415f
C2568 path_sel[1] dc_inst.x2.x15/a_27_47# 0.00273f
C2569 dc_inst.x1.x4/a_27_47# _20_/a_384_47# 0
C2570 _15_/a_788_316# _10_ 0
C2571 dc_inst.x7.net1 clk 0.2107f
C2572 dc_inst.x7.net4 dc_inst.x2.net19 0
C2573 dc_inst.x6.x9/a_27_47# dc_inst.x4.x19/a_27_47# 0
C2574 dc_inst.x6.x17/a_27_47# dc_inst.x6.net2 0
C2575 dc_inst.x7.net4 dc_inst.x8/a_1478_413# 0
C2576 path[5] dc_inst.x3.x5/a_27_47# 0.00505f
C2577 dc_inst.x7.net5 clknet_0_clk 0
C2578 clknet_1_0__leaf_clk _25_/a_448_47# 0
C2579 path[0] dc_inst.x2.net10 0.00115f
C2580 path_sel[1] dc_inst.x1.x11/a_27_47# 0.01114f
C2581 dc_inst.x1.x15/a_27_47# dc_inst.x1.net8 0.00623f
C2582 clknet_1_0__leaf_clk dc_inst.x7.net12 0.3185f
C2583 dc_inst.net3 dc_inst.x1.x8/a_27_47# 0
C2584 dc_inst.x6.x19/a_27_47# delay_sel[1] 0.00746f
C2585 dc_inst.x7.net5 dc_inst.x6.net19 0.00388f
C2586 VPWR dc_inst.x4.net9 0.0923f
C2587 dc_inst.x3.net1 _06_ 0
C2588 dc_inst.x3.net5 _23_/a_27_47# 0
C2589 dc_inst.x2.net3 path_sel[2] 0
C2590 dc_inst.x6.net9 dc_inst.x6.net4 0
C2591 path_sel[1] dc_inst.x6.net14 0
C2592 dc_inst.x1.net5 dc_inst.x1.net2 0.02033f
C2593 dc_inst.net1 dc_inst.x2.net19 0
C2594 _25_/a_27_47# _25_/a_761_289# -0.01661f
C2595 dc_inst.x5.x5/a_27_47# dc_inst.x1.x19/a_27_47# 0
C2596 VPWR dc_inst.x1.x15/a_27_47# -0.00177f
C2597 _24_/a_761_289# rst 0
C2598 dc_inst.x6.x20/a_27_47# dc_inst.x9/a_757_363# 0
C2599 dc_inst.x2.net14 dc_inst.x2.net6 0
C2600 dc_inst.x4.x6/a_27_47# dc_inst.x4.x5/a_27_47# 0.02448f
C2601 dc_inst.x6.net1 dc_inst.x1.net19 0
C2602 dc_inst.x7.net2 _25_/a_1108_47# 0
C2603 dc_inst.x3.net1 tdi 0
C2604 dc_inst.x6.net9 dc_inst.x5.net19 0.00899f
C2605 dc_inst.x2.x1/a_27_47# path_sel[2] 0.0041f
C2606 _13_/a_112_47# dc_inst.x3.x3/a_27_47# 0
C2607 dc_inst.x1.net9 dc_inst.x1.net7 0.00621f
C2608 dc_inst.net4 dc_inst.x6.x16/a_27_47# 0.001f
C2609 dc_inst.x7.net4 dc_inst.x4.x4/a_27_47# 0
C2610 dc_inst.x2.net11 dc_inst.x5.net10 0
C2611 dc_inst.x5.net12 dc_inst.x2.net12 0.07285f
C2612 _20_/a_79_21# _04_ 0.05999f
C2613 dc_inst.x7.net1 _25_/a_1108_47# 0.0018f
C2614 dc_inst.x4.x4/a_27_47# dc_inst.x1.net17 0
C2615 dc_inst.x2.x20/a_27_47# path[6] 0
C2616 VPWR dc_inst.x7.net11 0.30887f
C2617 _03_ dc_inst.x9/a_750_97# 0
C2618 dc_inst.x7.net6 dc_inst.x7.net8 0
C2619 dc_inst.x9/a_27_47# delay_sel[1] 0.06914f
C2620 dc_inst.x4.x13/a_27_47# dc_inst.x6.x10/a_27_47# 0
C2621 _24_/a_761_289# clknet_1_1__leaf_clk 0.02999f
C2622 dc_inst.x3.net16 _00_ 0.00295f
C2623 dc_inst.x6.x17/a_27_47# dc_inst.x6.x1/a_27_47# 0.08729f
C2624 dc_inst.x3.x12/a_27_47# path[5] 0.00345f
C2625 dc_inst.x3.net14 _15_/a_1064_47# 0
C2626 dc_inst.x2.net6 dc_inst.x2.x8/a_27_47# 0.0178f
C2627 dc_inst.net2 path_sel[2] 0.00152f
C2628 dc_inst.net1 dc_inst.x4.x4/a_27_47# 0.00899f
C2629 dc_inst.x6.x15/a_27_47# dc_inst.x4.net5 0
C2630 dc_inst.net3 dc_inst.x6.net19 0
C2631 dc_inst.x3.x20/a_27_47# shadow_q 0
C2632 dc_inst.x7.net3 dc_inst.x3.net3 0
C2633 VPWR dc_inst.x6.x17/a_27_47# 0.0038f
C2634 dc_inst.x1.net13 dc_inst.x1.x14/a_27_47# 0.04661f
C2635 capture_d clkload0/X 0
C2636 dc_inst.x3.net16 dc_inst.x3.x7/a_27_47# 0
C2637 dc_inst.in _00_ 0
C2638 VPWR clkbuf_1_0__f_clk/a_110_47# 0.07073f
C2639 _19_/a_193_297# dc_inst.x1.x5/a_27_47# 0
C2640 dc_inst.x5.net5 dc_inst.x1.net17 0
C2641 dc_inst.x2.net14 dc_inst.x2.net12 0.04686f
C2642 dc_inst.x6.net5 dc_inst.x6.net2 0
C2643 dc_inst.x1.net7 dc_inst.x1.net3 0.00705f
C2644 _03_ _24_/a_448_47# 0
C2645 dc_inst.net9 dc_inst.x8/a_277_47# 0.10282f
C2646 dc_inst.x2.x4/a_27_47# dc_inst.x1.net18 0
C2647 dc_inst.x5.net12 dc_inst.x2.net13 0.0097f
C2648 dc_inst.x8/a_668_97# dc_inst.net8 0.04751f
C2649 dc_inst.x5.net7 dc_inst.x2.x14/a_27_47# 0
C2650 dc_inst.x7.net4 dc_inst.x1.net15 0
C2651 tdo dc_inst.x2.net7 0
C2652 path_sel[1] _06_ 0
C2653 dc_inst.x7.net9 dc_inst.x6.net2 0.05863f
C2654 dc_inst.x3.net1 rst 0.01237f
C2655 dc_inst.x3.x17/a_27_47# capture_q 0
C2656 dc_inst.x5.x4/a_27_47# dc_inst.x5.net1 0
C2657 dc_inst.x1.net15 dc_inst.x1.net17 0
C2658 dc_inst.x4.net7 dc_inst.x5.net12 0
C2659 dc_inst.x1.x20/a_27_47# dc_inst.x1.net19 0.01067f
C2660 dc_inst.net1 dc_inst.x2.x16/a_27_47# 0
C2661 clknet_1_0__leaf_clk dc_inst.in 0.00808f
C2662 dc_inst.x7.x9/a_27_47# dc_inst.x6.x2/a_27_47# 0
C2663 path_sel[1] dc_inst.x1.net19 0
C2664 dc_inst.x3.x15/a_27_47# clknet_1_1__leaf_clk 0
C2665 _20_/a_79_21# dc_inst.x1.net5 0.00211f
C2666 clknet_0_clk _23_/a_761_289# 0
C2667 dc_inst.x4.net12 dc_inst.x6.x6/a_27_47# 0
C2668 dc_inst.x7.x6/a_27_47# dc_inst.x6.net4 0
C2669 dc_inst.x2.x10/a_27_47# path_sel[2] 0
C2670 dc_inst.x8/a_750_97# dc_inst.x3.x20/a_27_47# 0
C2671 dc_inst.x4.x17/a_27_47# dc_inst.x5.net6 0
C2672 dc_inst.x1.net10 dc_inst.x1.net11 0
C2673 dc_inst.x2.x1/a_27_47# dc_inst.x6.net11 0
C2674 VPWR dc_inst.net9 0.02812f
C2675 dc_inst.x1.net4 dc_inst.x8/a_277_47# 0
C2676 dc_inst.x5.net6 dc_inst.x5.net12 0.00686f
C2677 dc_inst.x2.x8/a_27_47# dc_inst.x2.net12 0
C2678 dc_inst.x1.net15 dc_inst.net1 0
C2679 dc_inst.x2.net3 dc_inst.x1.net17 0
C2680 dc_inst.x2.x15/a_27_47# dc_inst.x2.x14/a_27_47# 0
C2681 dc_inst.x7.x6/a_27_47# dc_inst.x5.net19 0.00622f
C2682 dc_inst.x6.net5 dc_inst.x4.x20/a_27_47# 0
C2683 dc_inst.x2.x11/a_27_47# dc_inst.x5.net10 0.01151f
C2684 dc_inst.x1.net4 dc_inst.x1.net8 0.13142f
C2685 _13_/a_112_47# shadow_q 0.0111f
C2686 dc_inst.x2.net14 dc_inst.x2.net13 0.21645f
C2687 dc_inst.x5.net5 dc_inst.x5.x9/a_27_47# 0
C2688 path_sel[0] _19_/a_193_297# 0
C2689 path_sel[1] path[3] 0
C2690 dc_inst.x5.net19 dc_inst.x5.net7 0
C2691 VPWR dc_inst.x6.x13/a_27_47# 0.05573f
C2692 VPWR _14_/a_76_199# 0.00194f
C2693 dc_inst.x9/a_668_97# clknet_0_clk 0
C2694 _20_/a_79_21# dc_inst.x3.net14 0
C2695 _15_/a_788_316# dc_inst.x1.net11 0
C2696 dc_inst.x2.x1/a_27_47# dc_inst.x1.net17 0.00206f
C2697 dc_inst.x5.net12 _18_/a_218_47# 0
C2698 dc_inst.net1 dc_inst.x2.net3 0
C2699 dc_inst.x4.net16 dc_inst.x6.x14/a_27_47# 0
C2700 _00_ path[6] 0.05611f
C2701 dc_inst.x3.net12 dc_inst.x3.net9 0.05878f
C2702 dc_inst.x9/a_1290_413# dc_inst.x8/a_247_21# 0.00111f
C2703 dc_inst.x9/a_750_97# dc_inst.x8/a_277_47# 0
C2704 dc_inst.x1.net13 dc_inst.x1.x8/a_27_47# 0
C2705 dc_inst.net5 dc_inst.x7.net10 0.26382f
C2706 dc_inst.x1.net4 VPWR 0.55318f
C2707 dc_inst.x3.net19 _15_/a_27_47# 0
C2708 dc_inst.x2.x6/a_27_47# path_sel[0] 0.00192f
C2709 _24_/a_1283_21# _00_ 0.03905f
C2710 dc_inst.x2.net5 dc_inst.x2.net15 0
C2711 dc_inst.x7.net9 dc_inst.x6.x1/a_27_47# 0
C2712 dc_inst.net8 dc_inst.x1.x1/a_27_47# 0
C2713 delay_sel[0] _24_/a_543_47# 0
C2714 dc_inst.x2.net2 dc_inst.x2.net3 0.01447f
C2715 VPWR dc_inst.x6.net5 0.06342f
C2716 path_sel[1] _19_/a_27_47# 0.03996f
C2717 dc_inst.net1 dc_inst.x2.x1/a_27_47# 0.03078f
C2718 dc_inst.x2.net18 dc_inst.x1.net16 0
C2719 dc_inst.x6.x10/a_27_47# dc_inst.x4.x18/a_27_47# 0
C2720 dc_inst.x5.net6 dc_inst.x2.net14 0.01821f
C2721 dc_inst.x9/a_750_97# dc_inst.x6.x1/a_27_47# 0
C2722 dc_inst.x4.net5 dc_inst.x8/a_757_363# 0
C2723 dc_inst.x3.x7/a_27_47# path[6] 0.00219f
C2724 _08_ path_sel[0] 0.11966f
C2725 dc_inst.x2.net16 dc_inst.x2.x18/a_27_47# 0.01149f
C2726 _03_ dc_inst.x9/a_277_47# 0
C2727 dc_inst.x7.net4 dc_inst.net2 0.02595f
C2728 path_sel[2] dc_inst.x7.net10 0.00341f
C2729 VPWR dc_inst.x7.net9 0.08931f
C2730 _03_ delay_sel[2] 0
C2731 dc_inst.net3 dc_inst.x2.net19 0.00532f
C2732 dc_inst.x6.net12 dc_inst.x1.x20/a_27_47# 0
C2733 dc_inst.x4.net4 dc_inst.x2.net18 0.00542f
C2734 dc_inst.net3 dc_inst.x8/a_1478_413# 0.05782f
C2735 _07_ path[7] 0
C2736 dc_inst.x2.net2 dc_inst.x2.x1/a_27_47# 0.01547f
C2737 dc_inst.x6.x15/a_27_47# capture_d 0
C2738 dc_inst.x6.net2 dc_inst.x6.net7 0
C2739 dc_inst.net1 dc_inst.x5.net9 0
C2740 path_sel[1] dc_inst.x6.net12 0.00101f
C2741 dc_inst.x1.net9 dc_inst.x2.net17 0.06166f
C2742 VPWR dc_inst.x9/a_750_97# -0.2198f
C2743 dc_inst.x1.net10 dc_inst.x1.net14 0
C2744 VPWR se 0.26683f
C2745 VPWR _14_/a_535_374# -0
C2746 dc_inst.x1.x4/a_27_47# dc_inst.x3.net19 0
C2747 VPWR dc_inst.x4.x14/a_27_47# 0.05988f
C2748 dc_inst.x6.net10 dc_inst.x2.x1/a_27_47# 0
C2749 _13_/a_27_297# clknet_1_1__leaf_clk 0
C2750 _15_/a_288_47# path[4] 0
C2751 dc_inst.x6.net14 dc_inst.x6.net4 0
C2752 _23_/a_1283_21# shadow_q 0.00954f
C2753 dc_inst.x3.net17 dc_inst.x3.x7/a_27_47# 0.01151f
C2754 dc_inst.x3.net3 dc_inst.x3.x2/a_27_47# 0.00213f
C2755 dc_inst.x2.x20/a_27_47# _15_/a_600_345# 0
C2756 dc_inst.x2.net2 dc_inst.x5.net9 0
C2757 path[0] _08_ 0
C2758 dc_inst.x3.x10/a_27_47# dc_inst.x3.net18 0
C2759 dc_inst.x4.x9/a_27_47# dc_inst.x4.net12 0
C2760 dc_inst.x5.net6 dc_inst.x2.x8/a_27_47# 0.01883f
C2761 _03_ dc_inst.x7.net17 0
C2762 dc_inst.x3.net17 dc_inst.x3.x6/a_27_47# 0.03206f
C2763 dc_inst.x6.net14 dc_inst.x5.net19 0
C2764 dc_inst.x5.net9 dc_inst.x5.x9/a_27_47# 0.05201f
C2765 dc_inst.x6.x5/a_27_47# dc_inst.net5 0
C2766 dc_inst.x6.net6 dc_inst.x6.x13/a_27_47# 0
C2767 dc_inst.x4.x17/a_27_47# path_sel[2] 0.00231f
C2768 _14_/a_76_199# dc_inst.x3.x5/a_27_47# 0
C2769 dc_inst.net4 dc_inst.x6.net13 0.00139f
C2770 _14_/a_76_199# path[5] 0
C2771 dc_inst.x3.net19 dc_inst.x3.x18/a_27_47# 0
C2772 dc_inst.x1.x7/a_27_47# _19_/a_27_47# 0.00168f
C2773 dc_inst.x4.net3 dc_inst.x8/a_750_97# 0
C2774 dc_inst.x5.net12 path_sel[2] 0.00119f
C2775 _23_/a_543_47# _01_ 0
C2776 _23_/a_1108_47# rst 0
C2777 dc_inst.x4.x20/a_27_47# dc_inst.x6.net7 0.00127f
C2778 VPWR _24_/a_448_47# 0.00844f
C2779 dc_inst.x1.net4 path[5] 0.0152f
C2780 dc_inst.x2.net17 dc_inst.x1.net3 0
C2781 _05_ _00_ 0.00303f
C2782 dc_inst.x8/a_750_97# _23_/a_1283_21# 0
C2783 dc_inst.x4.x10/a_27_47# dc_inst.x5.net7 0.02914f
C2784 dc_inst.x6.x5/a_27_47# path_sel[2] 0.01084f
C2785 clkload0/a_27_47# _00_ 0
C2786 dc_inst.x6.x18/a_27_47# path_sel[2] 0.0023f
C2787 dc_inst.x2.x3/a_27_47# dc_inst.x2.x4/a_27_47# 0
C2788 dc_inst.x6.net5 dc_inst.x6.net6 0.2845f
C2789 _13_/a_470_47# dc_inst.x3.x19/a_27_47# 0
C2790 dc_inst.x4.net16 dc_inst.x5.net7 0.00155f
C2791 _16_/a_229_47# _09_ 0
C2792 dc_inst.x2.net11 dc_inst.x2.net15 0
C2793 dc_inst.x5.net12 dc_inst.x6.x7/a_27_47# 0.00148f
C2794 dc_inst.x1.net15 dc_inst.x4.x3/a_27_47# 0
C2795 _05_ dc_inst.x3.x7/a_27_47# 0.00119f
C2796 dc_inst.x1.x5/a_27_47# dc_inst.in 0
C2797 _23_/a_543_47# _02_ 0.00248f
C2798 dc_inst.net3 dc_inst.x2.x16/a_27_47# 0
C2799 _04_ dc_inst.x1.net6 0
C2800 se dc_inst.x3.x5/a_27_47# 0
C2801 dc_inst.x7.x16/a_27_47# rst 0
C2802 dc_inst.x6.net2 dc_inst.x7.net17 0
C2803 se path[5] 0.00218f
C2804 dc_inst.x5.net5 dc_inst.x5.x8/a_27_47# 0
C2805 VPWR dc_inst.x6.net7 0.05224f
C2806 _15_/a_193_47# path_sel[2] 0
C2807 _14_/a_535_374# path[5] 0
C2808 dc_inst.x2.net14 path_sel[2] 0.00395f
C2809 dc_inst.x10/a_76_199# dc_inst.x7.net19 0.01257f
C2810 path_sel[1] dc_inst.x5.x5/a_27_47# 0.0015f
C2811 delay_sel[0] dc_inst.x6.net16 0
C2812 dc_inst.x3.net9 shadow_q 0
C2813 _09_ path[7] 0
C2814 dc_inst.x2.x10/a_27_47# dc_inst.x5.x9/a_27_47# 0.01224f
C2815 tdo _01_ 0
C2816 dc_inst.net3 dc_inst.x1.net15 0
C2817 dc_inst.x4.x2/a_27_47# dc_inst.x2.net4 0
C2818 dc_inst.x1.x16/a_27_47# dc_inst.x1.x20/a_27_47# 0.03129f
C2819 dc_inst.x7.net4 dc_inst.x7.net10 0.10381f
C2820 dc_inst.x3.net14 _13_/a_470_47# 0
C2821 clkbuf_1_0__f_clk/a_110_47# dc_inst.x7.net11 0.01092f
C2822 tdo dc_inst.x2.x6/a_27_47# 0
C2823 dc_inst.net8 dc_inst.x8/a_247_21# 0.02309f
C2824 delay_sel[2] dc_inst.x8/a_277_47# 0
C2825 dc_inst.net4 dc_inst.x4.net5 0
C2826 path_sel[1] dc_inst.x1.x16/a_27_47# 0
C2827 _23_/a_1283_21# dc_inst.x3.x1/a_27_47# 0.00964f
C2828 _24_/a_193_47# _24_/a_651_413# -0.00701f
C2829 dc_inst.x2.x17/a_27_47# dc_inst.x2.x18/a_27_47# 0
C2830 dc_inst.x1.net4 dc_inst.x3.x12/a_27_47# 0
C2831 dc_inst.x9/a_277_47# dc_inst.x6.x1/a_27_47# 0
C2832 dc_inst.x1.net15 dc_inst.x1.x18/a_27_47# 0
C2833 dc_inst.x3.net13 dc_inst.x3.net6 0.09908f
C2834 _03_ _25_/a_1283_21# 0.05581f
C2835 dc_inst.x4.x15/a_27_47# path_sel[0] 0.00256f
C2836 _10_ _07_ 0
C2837 dc_inst.x7.x12/a_27_47# dc_inst.x7.net1 0.00161f
C2838 _13_/a_470_47# dc_inst.x3.x8/a_27_47# 0
C2839 dc_inst.x2.x8/a_27_47# path_sel[2] 0
C2840 tdo _02_ 0
C2841 path_sel[0] dc_inst.in 0.01291f
C2842 dc_inst.x10/a_505_21# _23_/a_193_47# 0
C2843 VPWR dc_inst.x9/a_277_47# -0.0319f
C2844 dc_inst.x9/a_193_47# dc_inst.x7.net13 0
C2845 VPWR delay_sel[2] 0.55262f
C2846 _23_/a_27_47# shadow_q 0
C2847 dc_inst.x6.x5/a_27_47# dc_inst.x6.net11 0.001f
C2848 _15_/a_600_345# dc_inst.x3.x7/a_27_47# 0
C2849 dc_inst.x5.net5 dc_inst.x2.net9 0
C2850 dc_inst.x7.net2 dc_inst.x6.net16 0.06556f
C2851 dc_inst.x6.x12/a_27_47# dc_inst.x6.net13 0.03174f
C2852 dc_inst.x1.net2 dc_inst.x3.net3 0.00271f
C2853 dc_inst.x4.x3/a_27_47# dc_inst.net2 0
C2854 dc_inst.net4 dc_inst.x9/a_27_413# 0.00212f
C2855 path_sel[1] dc_inst.x1.x19/a_27_47# 0
C2856 dc_inst.net6 dc_inst.x6.x5/a_27_47# 0
C2857 dc_inst.net6 dc_inst.x6.x18/a_27_47# 0
C2858 dc_inst.x1.net13 dc_inst.x8/a_1478_413# 0
C2859 dc_inst.x3.net10 path[6] 0
C2860 tdo _25_/a_448_47# 0
C2861 dc_inst.x1.net7 path_sel[2] 0.16364f
C2862 dc_inst.x1.net5 dc_inst.x1.net6 0.00759f
C2863 dc_inst.x7.x17/a_27_47# dc_inst.x7.net15 0
C2864 dc_inst.x8/a_750_97# dc_inst.x2.net15 0
C2865 _15_/a_872_316# _07_ 0
C2866 dc_inst.x6.net6 dc_inst.x6.net7 0.00299f
C2867 dc_inst.x5.net11 dc_inst.x2.net12 0.02031f
C2868 dc_inst.x7.net4 dc_inst.x6.x5/a_27_47# 0
C2869 dc_inst.x5.net9 dc_inst.x5.x8/a_27_47# 0.00115f
C2870 dc_inst.x2.x9/a_27_47# dc_inst.x2.net9 0.12862f
C2871 dc_inst.x2.x1/a_27_47# dc_inst.x1.x18/a_27_47# 0
C2872 dc_inst.x7.net4 dc_inst.x6.x18/a_27_47# 0.01831f
C2873 dc_inst.x5.net7 dc_inst.x2.net5 0
C2874 VPWR dc_inst.x7.net17 0.00696f
C2875 _23_/a_193_47# rst 0.00584f
C2876 dc_inst.x6.x18/a_27_47# dc_inst.x1.net17 0
C2877 dc_inst.x8/a_750_97# _23_/a_27_47# 0
C2878 dc_inst.x3.net10 dc_inst.x3.net17 0
C2879 dc_inst.x5.x17/a_27_47# dc_inst.x6.net8 0.03581f
C2880 dc_inst.net3 dc_inst.net2 0.10781f
C2881 dc_inst.x3.net19 dc_inst.x3.x4/a_27_47# 0.00448f
C2882 dc_inst.x6.net12 dc_inst.x6.net4 0
C2883 dc_inst.net4 dc_inst.x4.net17 0.06713f
C2884 dc_inst.x3.net16 _23_/a_543_47# 0
C2885 dc_inst.x2.x19/a_27_47# path_sel[2] 0
C2886 dc_inst.x4.net13 dc_inst.x4.net11 0.074f
C2887 dc_inst.x1.net9 dc_inst.x5.net1 0
C2888 dc_inst.x9/a_668_97# _25_/a_193_47# 0
C2889 dc_inst.x7.x7/a_27_47# dc_inst.x6.net16 0
C2890 dc_inst.net1 dc_inst.x6.x18/a_27_47# 0.00843f
C2891 dc_inst.x8/a_1478_413# dc_inst.x3.net19 0
C2892 dc_inst.x2.net2 dc_inst.x5.net12 0
C2893 dc_inst.x3.net10 dc_inst.x3.x9/a_27_47# 0.0127f
C2894 dc_inst.x6.net12 dc_inst.x5.net19 0
C2895 _23_/a_193_47# clknet_1_1__leaf_clk 0
C2896 dc_inst.x7.net6 dc_inst.in 0
C2897 _24_/a_193_47# dc_inst.net8 0
C2898 _23_/a_543_47# dc_inst.in 0
C2899 dc_inst.x2.net14 dc_inst.x1.net17 0.0037f
C2900 dc_inst.x3.x16/a_27_47# dc_inst.x1.net2 0
C2901 dc_inst.x5.x17/a_27_47# dc_inst.x5.x19/a_27_47# 0
C2902 path_sel[1] dc_inst.x1.net1 0.0282f
C2903 dc_inst.x5.net11 dc_inst.x2.net13 0.00116f
C2904 dc_inst.x1.net12 dc_inst.x1.x5/a_27_47# 0.03188f
C2905 path_sel[0] path[6] 0.0757f
C2906 dc_inst.x5.net12 dc_inst.x5.x9/a_27_47# 0.01959f
C2907 dc_inst.x3.net1 dc_inst.x3.x15/a_27_47# 0
C2908 dc_inst.x4.x5/a_27_47# dc_inst.x5.net7 0
C2909 _10_ _09_ 0
C2910 dc_inst.net4 dc_inst.x9/a_193_413# 0.00266f
C2911 dc_inst.x6.net10 dc_inst.x6.x5/a_27_47# 0
C2912 dc_inst.x7.x20/a_27_47# delay_sel[1] 0
C2913 dc_inst.x2.net1 dc_inst.x2.net11 0.03371f
C2914 dc_inst.x4.net6 dc_inst.x5.x6/a_27_47# 0.03013f
C2915 dc_inst.net7 dc_inst.x7.x16/a_27_47# 0
C2916 dc_inst.x5.net9 dc_inst.x2.net9 0
C2917 dc_inst.x1.net16 dc_inst.x5.x3/a_27_47# 0
C2918 dc_inst.net4 dc_inst.x6.x4/a_27_47# 0.00584f
C2919 dc_inst.net1 dc_inst.x2.net14 0
C2920 _16_/a_229_47# _18_/a_76_199# 0
C2921 _16_/a_27_93# _18_/a_505_21# 0
C2922 dc_inst.x7.net5 dc_inst.x7.net10 0
C2923 dc_inst.x7.x2/a_27_47# delay_sel[1] 0.00424f
C2924 dc_inst.x3.net5 rst 0
C2925 dc_inst.x4.x1/a_27_47# dc_inst.x5.net6 0
C2926 dc_inst.x7.net9 clkbuf_1_0__f_clk/a_110_47# 0
C2927 dc_inst.x6.x17/a_27_47# dc_inst.x9/a_750_97# 0
C2928 dc_inst.x7.net3 _01_ 0.09865f
C2929 dc_inst.x3.net17 path_sel[0] 0
C2930 dc_inst.x7.net3 dc_inst.x10/a_439_47# 0
C2931 dc_inst.x1.net9 dc_inst.x4.net5 0.00828f
C2932 dc_inst.x3.net2 rst 0
C2933 dc_inst.x1.x2/a_27_47# dc_inst.x1.x5/a_27_47# 0
C2934 clkbuf_1_1__f_clk/a_110_47# dc_inst.x3.net4 0
C2935 dc_inst.x9/a_750_97# clkbuf_1_0__f_clk/a_110_47# 0
C2936 dc_inst.x4.x15/a_27_47# tdo 0
C2937 dc_inst.x2.net6 dc_inst.x5.net1 0
C2938 dc_inst.x4.x13/a_27_47# path_sel[0] 0
C2939 dc_inst.x2.net2 dc_inst.x2.net14 0
C2940 dc_inst.x5.net2 dc_inst.x4.net12 0
C2941 dc_inst.x1.net13 dc_inst.x1.net15 0.08151f
C2942 _23_/a_1217_47# shadow_q 0
C2943 dc_inst.x4.net9 dc_inst.x6.net7 0
C2944 dc_inst.x3.x9/a_27_47# path_sel[0] 0
C2945 dc_inst.x6.net8 dc_inst.x4.net17 0
C2946 VPWR _25_/a_1283_21# -0.00295f
C2947 tdo dc_inst.in 0.47942f
C2948 dc_inst.x6.net14 dc_inst.x8/a_27_413# 0
C2949 delay_sel[0] dc_inst.x7.net19 0
C2950 dc_inst.x1.net12 path_sel[0] 0.00112f
C2951 dc_inst.x7.net3 _02_ 0
C2952 dc_inst.x1.net8 dc_inst.x1.net16 0
C2953 dc_inst.net5 dc_inst.x6.x16/a_27_47# 0.0012f
C2954 dc_inst.x1.net7 dc_inst.x1.net17 0
C2955 dc_inst.x3.net14 dc_inst.x3.x20/a_27_47# 0
C2956 dc_inst.x1.net11 _07_ 0.00726f
C2957 _13_/a_27_297# dc_inst.x3.x15/a_27_47# 0
C2958 _25_/a_27_47# _24_/a_193_47# 0
C2959 dc_inst.x6.net14 dc_inst.x4.x5/a_27_47# 0
C2960 dc_inst.x9/a_1290_413# delay_sel[1] 0.08669f
C2961 dc_inst.x9/a_750_97# dc_inst.net9 0
C2962 dc_inst.x1.x10/a_27_47# dc_inst.x2.net13 0
C2963 dc_inst.x4.net4 dc_inst.x1.net8 0
C2964 dc_inst.x2.net11 dc_inst.x2.x15/a_27_47# 0
C2965 dc_inst.x3.net6 dc_inst.x3.net9 0
C2966 dc_inst.x1.x3/a_27_47# dc_inst.x1.net3 0.04921f
C2967 dc_inst.x6.x5/a_27_47# dc_inst.x7.net5 0
C2968 path_sel[2] dc_inst.x6.x16/a_27_47# 0.00663f
C2969 dc_inst.net4 dc_inst.x7.net13 0
C2970 dc_inst.x1.net15 dc_inst.x3.net19 0
C2971 dc_inst.x2.x12/a_27_47# dc_inst.x5.x4/a_27_47# 0
C2972 dc_inst.x7.x10/a_27_47# dc_inst.x9/a_247_21# 0.00279f
C2973 dc_inst.x7.net4 dc_inst.x2.x19/a_27_47# 0.0016f
C2974 dc_inst.x4.net16 dc_inst.x6.net12 0
C2975 VPWR dc_inst.x1.net16 0.05165f
C2976 dc_inst.x3.net1 _13_/a_27_297# 0
C2977 dc_inst.x5.x1/a_27_47# path_sel[0] 0
C2978 dc_inst.x5.net1 dc_inst.x2.net12 0
C2979 dc_inst.x3.net13 dc_inst.x3.net14 0.05916f
C2980 dc_inst.x5.x14/a_27_47# path_sel[0] 0.00271f
C2981 dc_inst.x4.x17/a_27_47# dc_inst.x4.x8/a_27_47# 0.04629f
C2982 dc_inst.x2.net17 path_sel[2] 0.02078f
C2983 _15_/a_600_345# dc_inst.x1.x5/a_27_47# 0
C2984 VPWR dc_inst.x4.net4 0.04813f
C2985 dc_inst.x2.net1 dc_inst.x2.x11/a_27_47# 0.12267f
C2986 se _14_/a_76_199# 0.04044f
C2987 dc_inst.x5.net12 dc_inst.x4.x8/a_27_47# 0
C2988 dc_inst.x4.net1 dc_inst.x2.net7 0.01355f
C2989 dc_inst.x7.net2 dc_inst.x7.net19 0.11611f
C2990 dc_inst.x6.net17 tdo 0.14197f
C2991 dc_inst.x4.net1 dc_inst.x2.net10 -0
C2992 _24_/a_448_47# dc_inst.net9 0
C2993 dc_inst.x7.net16 rst 0
C2994 dc_inst.net1 dc_inst.x2.x19/a_27_47# 0
C2995 path_sel[1] dc_inst.x6.net1 0.00239f
C2996 dc_inst.x7.net19 dc_inst.x7.net1 0.03427f
C2997 _06_ dc_inst.x3.net12 0
C2998 _20_/a_470_297# _10_ 0.00194f
C2999 dc_inst.x3.net14 _13_/a_112_47# 0
C3000 dc_inst.x5.net7 dc_inst.x4.x12/a_27_47# 0
C3001 dc_inst.x4.x1/a_27_47# path_sel[2] 0.00249f
C3002 dc_inst.x7.x17/a_27_47# clknet_1_0__leaf_clk 0.00122f
C3003 dc_inst.x7.net11 delay_sel[2] 0.00158f
C3004 _23_/a_1108_47# dc_inst.x3.x15/a_27_47# 0
C3005 _24_/a_1283_21# tdo 0
C3006 dc_inst.x5.net12 dc_inst.x5.x8/a_27_47# 0
C3007 dc_inst.x5.net11 path_sel[2] 0.0013f
C3008 dc_inst.x5.net4 path_sel[0] 0.00153f
C3009 path_sel[1] dc_inst.x5.x13/a_27_47# 0.00476f
C3010 dc_inst.x1.x13/a_27_47# dc_inst.x1.net10 0
C3011 tdi dc_inst.x3.net12 0
C3012 dc_inst.x5.net15 path_sel[0] 0
C3013 dc_inst.x4.net3 dc_inst.x1.net5 0
C3014 _13_/a_112_47# dc_inst.x3.x8/a_27_47# 0.00108f
C3015 dc_inst.net3 dc_inst.x6.x18/a_27_47# 0
C3016 se _14_/a_535_374# 0.00105f
C3017 dc_inst.x8/a_1290_413# dc_inst.x2.x18/a_27_47# 0
C3018 dc_inst.x5.net17 dc_inst.x6.net8 0.02608f
C3019 path_sel[0] dc_inst.x4.x18/a_27_47# 0.00209f
C3020 _23_/a_543_47# clkload0/a_27_47# 0
C3021 dc_inst.x1.x6/a_27_47# dc_inst.x1.net12 0
C3022 _15_/a_600_345# path_sel[0] -0.01126f
C3023 delay_sel[0] dc_inst.x3.net3 0
C3024 dc_inst.x4.net18 dc_inst.x4.net17 0.00442f
C3025 dc_inst.x7.x13/a_27_47# dc_inst.x7.x14/a_27_47# 0
C3026 dc_inst.x8/a_1290_413# dc_inst.x3.x2/a_27_47# 0
C3027 dc_inst.x8/a_834_97# dc_inst.x8/a_923_363# -0
C3028 dc_inst.x4.x5/a_27_47# dc_inst.x1.net19 0
C3029 dc_inst.x9/a_277_47# clkbuf_1_0__f_clk/a_110_47# 0
C3030 dc_inst.x5.net6 dc_inst.x6.net13 0.01358f
C3031 dc_inst.x1.net11 _09_ 0.35869f
C3032 dc_inst.x3.net16 dc_inst.x7.net3 0
C3033 dc_inst.x3.net19 dc_inst.net2 0
C3034 _03_ dc_inst.x6.x19/a_27_47# 0
C3035 dc_inst.x1.net13 dc_inst.x2.x10/a_27_47# 0
C3036 _10_ _18_/a_76_199# 0
C3037 dc_inst.net1 _24_/a_27_47# 0
C3038 dc_inst.x2.x20/a_27_47# _15_/a_27_47# 0
C3039 dc_inst.x4.net16 dc_inst.x5.x5/a_27_47# 0
C3040 dc_inst.x5.net6 dc_inst.x5.net1 0
C3041 dc_inst.x5.net17 dc_inst.x5.x19/a_27_47# 0.00453f
C3042 dc_inst.x4.net3 dc_inst.x6.net16 0
C3043 dc_inst.x7.net3 dc_inst.in 0.02796f
C3044 path_sel[1] dc_inst.x1.x20/a_27_47# 0
C3045 dc_inst.x1.x9/a_27_47# dc_inst.x1.x8/a_27_47# 0
C3046 dc_inst.x5.net12 dc_inst.x2.net9 0
C3047 VPWR dc_inst.x4.net6 0.04181f
C3048 dc_inst.x7.net19 dc_inst.x7.net18 0.54452f
C3049 clkbuf_1_0__f_clk/a_110_47# dc_inst.x7.net17 0.00496f
C3050 dc_inst.x9/a_277_47# dc_inst.net9 -0
C3051 _24_/a_543_47# _23_/a_27_47# 0.00651f
C3052 _24_/a_761_289# _23_/a_193_47# 0
C3053 dc_inst.net8 delay_sel[1] 0.00627f
C3054 delay_sel[2] dc_inst.net9 0.00232f
C3055 dc_inst.x3.net18 path[7] 0
C3056 dc_inst.x4.net7 dc_inst.x4.net5 0.00467f
C3057 dc_inst.x3.net12 rst 0
C3058 dc_inst.x5.x18/a_27_47# dc_inst.x5.net17 0.02051f
C3059 dc_inst.x7.net7 dc_inst.x5.x20/a_27_47# 0.01105f
C3060 dc_inst.x1.x10/a_27_47# path_sel[2] 0.00221f
C3061 dc_inst.x7.x18/a_27_47# dc_inst.x7.net19 0.04258f
C3062 path_sel[0] _17_/a_174_21# 0.09483f
C3063 dc_inst.x2.x10/a_27_47# dc_inst.x5.x12/a_27_47# 0
C3064 VPWR dc_inst.x3.x17/a_27_47# 0.00493f
C3065 dc_inst.x5.net5 dc_inst.x2.x7/a_27_47# 0.01149f
C3066 shadow_q _24_/a_1217_47# 0
C3067 dc_inst.x5.net6 dc_inst.x4.net5 0.27167f
C3068 dc_inst.net1 dc_inst.x2.net17 0.00695f
C3069 dc_inst.x7.net4 dc_inst.x4.x1/a_27_47# 0.00964f
C3070 dc_inst.x3.x3/a_27_47# rst 0
C3071 dc_inst.x3.net11 _02_ 0.00405f
C3072 dc_inst.x4.x3/a_27_47# dc_inst.x2.x19/a_27_47# 0
C3073 dc_inst.x4.x1/a_27_47# dc_inst.x1.net17 0
C3074 _15_/a_193_369# path_sel[2] 0
C3075 dc_inst.x6.x20/a_27_47# dc_inst.x6.x1/a_27_47# 0
C3076 path[0] _17_/a_174_21# 0.00959f
C3077 dc_inst.x6.net17 dc_inst.x7.net3 0
C3078 dc_inst.x1.x7/a_27_47# path_sel[1] 0.01867f
C3079 dc_inst.net7 dc_inst.x7.net16 0
C3080 _23_/a_193_47# dc_inst.x3.x15/a_27_47# 0
C3081 dc_inst.x3.net7 path[7] 0
C3082 VPWR dc_inst.x6.x20/a_27_47# -0.00427f
C3083 tdo dc_inst.x5.net4 0
C3084 dc_inst.x3.net14 dc_inst.x3.net9 0
C3085 dc_inst.x4.x1/a_27_47# dc_inst.net1 0.00194f
C3086 dc_inst.x5.net3 dc_inst.x4.net13 0.05337f
C3087 dc_inst.x6.net13 path_sel[2] 0.01705f
C3088 dc_inst.x1.x15/a_27_47# dc_inst.x1.net16 0
C3089 dc_inst.x9/a_750_97# dc_inst.x9/a_277_47# -0.05766f
C3090 dc_inst.x9/a_1290_413# dc_inst.x9/a_247_21# -0.00452f
C3091 _24_/a_1283_21# dc_inst.x7.net3 0
C3092 dc_inst.x5.x11/a_27_47# dc_inst.x2.net7 0
C3093 dc_inst.x2.x7/a_27_47# dc_inst.x2.net3 0
C3094 _17_/a_27_93# _18_/a_505_21# 0.00493f
C3095 dc_inst.x5.x11/a_27_47# dc_inst.x2.net10 0.03319f
C3096 dc_inst.net3 dc_inst.x2.x19/a_27_47# 0.00747f
C3097 se delay_sel[2] 0.05529f
C3098 tdo dc_inst.x4.x18/a_27_47# 0
C3099 dc_inst.x2.net9 dc_inst.x2.x8/a_27_47# 0.04368f
C3100 dc_inst.x5.net1 path_sel[2] 0
C3101 _25_/a_27_47# delay_sel[1] 0.00122f
C3102 dc_inst.x1.net13 dc_inst.x5.net12 0
C3103 dc_inst.x3.x8/a_27_47# dc_inst.x3.net9 0
C3104 clkbuf_1_0__f_clk/a_110_47# _25_/a_1283_21# 0
C3105 dc_inst.x2.net8 dc_inst.x2.net7 0.09584f
C3106 _02_ _24_/a_805_47# 0
C3107 dc_inst.x7.net3 dc_inst.x3.net17 0
C3108 dc_inst.x4.net15 dc_inst.x5.net7 0
C3109 dc_inst.x2.net8 dc_inst.x2.net10 0
C3110 _15_/a_397_47# dc_inst.x2.net19 0
C3111 dc_inst.x1.x16/a_27_47# dc_inst.x2.net5 0
C3112 dc_inst.x7.net15 dc_inst.x7.x15/a_27_47# 0.03582f
C3113 dc_inst.x5.net7 dc_inst.x5.net8 0.03435f
C3114 dc_inst.x2.x18/a_27_47# dc_inst.in 0.00317f
C3115 dc_inst.x9/a_750_97# dc_inst.x7.net17 0.00109f
C3116 _15_/a_27_47# dc_inst.x3.x7/a_27_47# 0
C3117 dc_inst.x4.net13 dc_inst.x4.net10 0
C3118 dc_inst.x5.net9 dc_inst.x2.x7/a_27_47# 0
C3119 VPWR dc_inst.x6.x19/a_27_47# 0.03288f
C3120 dc_inst.x5.net19 dc_inst.x6.net1 0
C3121 dc_inst.in dc_inst.x3.x2/a_27_47# 0
C3122 dc_inst.x4.net5 dc_inst.net5 0
C3123 delay_sel[2] _24_/a_448_47# 0.00145f
C3124 _15_/a_27_47# dc_inst.x3.x6/a_27_47# 0
C3125 delay_sel[0] dc_inst.x7.x14/a_27_47# 0
C3126 dc_inst.x3.net5 dc_inst.x3.x15/a_27_47# 0
C3127 tdo dc_inst.x4.x7/a_27_47# 0.01292f
C3128 dc_inst.x7.net14 dc_inst.x7.net19 0.10072f
C3129 dc_inst.x6.x6/a_27_47# path_sel[0] 0
C3130 delay_sel[0] dc_inst.x7.net8 0
C3131 dc_inst.x3.net2 dc_inst.x3.x15/a_27_47# 0
C3132 dc_inst.x10/a_76_199# _01_ 0
C3133 dc_inst.x10/a_218_374# rst 0.00116f
C3134 shadow_q rst 0
C3135 path_sel[1] dc_inst.x2.x14/a_27_47# 0.00593f
C3136 dc_inst.x4.net5 path_sel[2] 0.05034f
C3137 dc_inst.x1.net11 _18_/a_76_199# 0.00188f
C3138 dc_inst.net3 _24_/a_27_47# 0
C3139 dc_inst.x4.x4/a_27_47# dc_inst.x1.net18 0
C3140 dc_inst.x3.net5 dc_inst.x3.net1 0
C3141 dc_inst.x5.x12/a_27_47# dc_inst.x5.net12 0.00338f
C3142 dc_inst.x5.x17/a_27_47# path_sel[2] 0.00228f
C3143 dc_inst.x3.x20/a_27_47# dc_inst.x3.net3 0.04329f
C3144 dc_inst.x4.net19 dc_inst.x4.x15/a_27_47# 0.11159f
C3145 dc_inst.x4.x16/a_27_47# path_sel[0] 0.00239f
C3146 dc_inst.x1.net10 dc_inst.x2.x13/a_27_47# 0.00479f
C3147 dc_inst.x6.net13 dc_inst.x6.net11 0.01085f
C3148 dc_inst.x8/a_247_21# dc_inst.x8/a_757_363# -0.0033f
C3149 dc_inst.x5.net18 dc_inst.x7.net8 0
C3150 VPWR dc_inst.x9/a_27_47# -0.00178f
C3151 _20_/a_79_21# _19_/a_193_297# 0
C3152 dc_inst.net5 dc_inst.x9/a_27_413# 0.00554f
C3153 dc_inst.x8/a_193_413# delay_sel[0] 0.05138f
C3154 dc_inst.x5.x17/a_27_47# dc_inst.x6.x7/a_27_47# 0
C3155 dc_inst.x4.net6 dc_inst.x4.net9 0.00134f
C3156 dc_inst.x6.net17 dc_inst.x2.x18/a_27_47# 0
C3157 dc_inst.x4.x3/a_27_47# dc_inst.x2.net17 0.0026f
C3158 shadow_q clknet_1_1__leaf_clk 0.00165f
C3159 rst clk 0
C3160 _24_/a_193_47# dc_inst.x7.x3/a_27_47# 0
C3161 dc_inst.x5.net19 dc_inst.x5.x20/a_27_47# 0.03436f
C3162 dc_inst.x3.x7/a_27_47# dc_inst.x3.x18/a_27_47# 0
C3163 dc_inst.x8/a_750_97# rst 0
C3164 path_sel[1] dc_inst.x6.net4 0
C3165 dc_inst.x5.net5 dc_inst.x1.net18 0
C3166 dc_inst.x9/a_27_413# path_sel[2] 0
C3167 dc_inst.x7.net2 dc_inst.x7.net8 0
C3168 clknet_0_clk _00_ 0.03682f
C3169 dc_inst.x6.net13 dc_inst.x1.net17 0
C3170 dc_inst.x3.x6/a_27_47# dc_inst.x3.x18/a_27_47# 0
C3171 _24_/a_27_47# _23_/a_761_289# 0
C3172 dc_inst.x5.x12/a_27_47# dc_inst.x2.net14 0
C3173 VPWR dc_inst.x3.x13/a_27_47# -0.01042f
C3174 path_sel[1] dc_inst.x5.net19 0.00134f
C3175 dc_inst.x1.net15 dc_inst.x1.net18 0
C3176 dc_inst.x3.x2/a_27_47# path[6] 0.00344f
C3177 dc_inst.x2.x20/a_27_47# dc_inst.x2.net19 0.12175f
C3178 VPWR dc_inst.x8/a_923_363# -0
C3179 dc_inst.x6.x14/a_27_47# dc_inst.x6.net16 0
C3180 dc_inst.net5 dc_inst.x4.net17 0
C3181 dc_inst.net3 dc_inst.x2.net17 0
C3182 _20_/a_79_21# _08_ 0
C3183 dc_inst.x8/a_1478_413# dc_inst.x2.x20/a_27_47# 0
C3184 dc_inst.x1.net13 dc_inst.x1.net7 0.00382f
C3185 dc_inst.x8/a_750_97# clknet_1_1__leaf_clk 0
C3186 dc_inst.x3.x20/a_27_47# dc_inst.x3.x16/a_27_47# 0
C3187 _13_/a_112_47# dc_inst.x3.net3 0
C3188 dc_inst.x7.x13/a_27_47# dc_inst.x7.net12 0.01455f
C3189 dc_inst.net1 dc_inst.x6.net13 0
C3190 dc_inst.x7.x19/a_27_47# dc_inst.x7.net13 0
C3191 clkbuf_0_clk/a_110_47# _00_ 0.0016f
C3192 clknet_1_0__leaf_clk clknet_0_clk 0.06645f
C3193 _23_/a_1108_47# _23_/a_193_47# 0
C3194 dc_inst.x3.x14/a_27_47# dc_inst.x1.net3 0.03048f
C3195 dc_inst.x1.net4 dc_inst.x4.net4 0
C3196 path[5] _15_/a_1279_413# 0
C3197 path[4] _15_/a_1060_369# 0.00105f
C3198 dc_inst.x2.net4 dc_inst.x2.net6 0
C3199 dc_inst.x4.x9/a_27_47# path_sel[0] 0
C3200 path_sel[2] dc_inst.x4.net17 0.00119f
C3201 dc_inst.x2.x12/a_27_47# dc_inst.x2.net6 0.00546f
C3202 dc_inst.x4.net5 dc_inst.x6.net11 0
C3203 rst _25_/a_1108_47# 0.00256f
C3204 dc_inst.x2.net3 dc_inst.x1.net18 0
C3205 dc_inst.x6.net16 dc_inst.x6.net15 0.03371f
C3206 dc_inst.x4.net8 tdo 0.04786f
C3207 dc_inst.x9/a_193_413# dc_inst.net5 0
C3208 path_sel[1] dc_inst.x3.net5 0
C3209 dc_inst.x7.x7/a_27_47# dc_inst.x7.net8 0.04365f
C3210 dc_inst.x3.x1/a_27_47# rst 0
C3211 dc_inst.x4.x1/a_27_47# dc_inst.net3 0.01798f
C3212 clknet_1_0__leaf_clk clkbuf_0_clk/a_110_47# 0
C3213 dc_inst.x9/a_277_47# dc_inst.x7.net17 0.00111f
C3214 dc_inst.x7.net7 dc_inst.x5.net19 0.01108f
C3215 dc_inst.net6 dc_inst.x4.net5 0
C3216 path_sel[1] dc_inst.x3.net2 0.01443f
C3217 dc_inst.x6.x7/a_27_47# dc_inst.x4.net17 0
C3218 dc_inst.net5 dc_inst.x6.x4/a_27_47# 0
C3219 delay_sel[2] dc_inst.x7.net17 0
C3220 dc_inst.x2.x1/a_27_47# dc_inst.x1.net18 0.0073f
C3221 dc_inst.x7.net4 dc_inst.x4.net5 0
C3222 dc_inst.x9/a_193_413# path_sel[2] 0
C3223 dc_inst.x6.x5/a_27_47# dc_inst.x6.net3 0
C3224 dc_inst.x1.net3 path[7] 0.03857f
C3225 dc_inst.x1.net2 dc_inst.in 0.03106f
C3226 dc_inst.x3.net11 path[6] 0.00212f
C3227 clknet_1_1__leaf_clk _25_/a_1108_47# 0.0038f
C3228 dc_inst.x5.net1 dc_inst.x5.x9/a_27_47# 0.02523f
C3229 dc_inst.x7.x1/a_27_47# dc_inst.x6.x5/a_27_47# 0
C3230 dc_inst.x4.net5 dc_inst.x1.net17 0.22053f
C3231 dc_inst.x5.net9 dc_inst.x1.net18 0
C3232 dc_inst.x6.x4/a_27_47# path_sel[2] 0.01402f
C3233 dc_inst.x3.x1/a_27_47# clknet_1_1__leaf_clk 0
C3234 dc_inst.x7.x14/a_27_47# dc_inst.x7.net18 0.03732f
C3235 _13_/a_112_47# dc_inst.x3.x16/a_27_47# 0
C3236 tdi dc_inst.x3.net6 0
C3237 dc_inst.x7.net8 dc_inst.x7.net18 0
C3238 dc_inst.x7.x6/a_27_47# dc_inst.x6.net16 0
C3239 _15_/a_27_47# dc_inst.x1.x5/a_27_47# 0
C3240 path[5] dc_inst.x3.x13/a_27_47# 0.01188f
C3241 dc_inst.x2.net4 dc_inst.x2.net12 0
C3242 dc_inst.x7.x17/a_27_47# tdo 0
C3243 dc_inst.x3.net5 _23_/a_1108_47# 0
C3244 dc_inst.x10/a_76_199# dc_inst.x3.net16 0
C3245 dc_inst.net1 dc_inst.x4.net5 0.22858f
C3246 dc_inst.x1.net15 dc_inst.x1.x9/a_27_47# 0
C3247 dc_inst.x3.net11 dc_inst.x3.net17 0
C3248 dc_inst.x5.net16 dc_inst.x6.net8 0.01238f
C3249 dc_inst.x4.x17/a_27_47# dc_inst.x4.net12 0
C3250 dc_inst.x4.net19 dc_inst.x4.x13/a_27_47# 0.00327f
C3251 dc_inst.x2.x12/a_27_47# dc_inst.x2.net12 0.00374f
C3252 dc_inst.x1.x16/a_27_47# dc_inst.x8/a_750_97# 0
C3253 _25_/a_27_47# dc_inst.x9/a_247_21# 0
C3254 dc_inst.x4.x16/a_27_47# tdo 0.00136f
C3255 path_sel[1] dc_inst.x4.x10/a_27_47# 0.01151f
C3256 dc_inst.x5.x11/a_27_47# _08_ 0
C3257 dc_inst.x4.net12 dc_inst.x5.net12 0
C3258 dc_inst.x2.net8 dc_inst.x2.x6/a_27_47# 0.01149f
C3259 dc_inst.x3.net8 _00_ 0
C3260 clknet_1_0__leaf_clk dc_inst.x7.x15/a_27_47# 0.00123f
C3261 dc_inst.x1.x2/a_27_47# dc_inst.x3.x2/a_27_47# 0
C3262 dc_inst.x5.net7 dc_inst.x6.net16 0
C3263 dc_inst.x5.net12 dc_inst.x2.x7/a_27_47# 0
C3264 dc_inst.x1.net9 dc_inst.x1.x1/a_27_47# 0.00115f
C3265 path_sel[1] dc_inst.x4.net16 0.04523f
C3266 dc_inst.x2.net2 dc_inst.x4.net5 0.01741f
C3267 dc_inst.x7.net19 _23_/a_27_47# 0
C3268 dc_inst.x10/a_76_199# dc_inst.in 0.02939f
C3269 dc_inst.x2.x3/a_27_47# dc_inst.x4.x4/a_27_47# 0
C3270 _19_/a_205_47# path_sel[2] 0
C3271 dc_inst.x3.net11 dc_inst.x3.x9/a_27_47# 0.0169f
C3272 dc_inst.x6.x20/a_27_47# dc_inst.x6.x17/a_27_47# 0
C3273 dc_inst.x1.net15 dc_inst.x2.x20/a_27_47# 0
C3274 dc_inst.x6.net10 dc_inst.x4.net5 0
C3275 dc_inst.x4.net6 dc_inst.x6.x13/a_27_47# 0.01154f
C3276 dc_inst.net5 dc_inst.x7.net13 0.00177f
C3277 dc_inst.x6.x20/a_27_47# clkbuf_1_0__f_clk/a_110_47# 0
C3278 dc_inst.x3.net8 dc_inst.x3.x7/a_27_47# 0.00374f
C3279 dc_inst.x5.x19/a_27_47# dc_inst.x5.net16 0.00133f
C3280 dc_inst.net7 dc_inst.x10/a_218_47# 0
C3281 delay_sel[0] _01_ 0
C3282 VPWR path[4] 0.25749f
C3283 dc_inst.x4.net13 dc_inst.x4.net14 0.00606f
C3284 dc_inst.x1.net9 _10_ 0
C3285 dc_inst.x8/a_1290_413# delay_sel[0] 0
C3286 dc_inst.x7.net13 path_sel[2] 0
C3287 dc_inst.x2.net7 dc_inst.x5.net10 0
C3288 dc_inst.x5.net17 path_sel[2] 0.00461f
C3289 _04_ _06_ 0.12587f
C3290 dc_inst.x1.net2 path[6] 0.10756f
C3291 dc_inst.x9/a_277_47# _25_/a_1283_21# 0
C3292 _15_/a_27_47# path_sel[0] -0.00469f
C3293 dc_inst.x2.net10 dc_inst.x5.net10 0
C3294 dc_inst.x2.x12/a_27_47# dc_inst.x2.net13 0.01152f
C3295 dc_inst.x3.net1 dc_inst.x3.net12 0.03178f
C3296 dc_inst.x3.x16/a_27_47# _23_/a_1283_21# 0.00795f
C3297 dc_inst.x9/a_247_21# dc_inst.x7.x4/a_27_47# 0
C3298 delay_sel[2] _25_/a_1283_21# 0
C3299 dc_inst.x3.net11 _05_ 0
C3300 dc_inst.x4.net19 dc_inst.x5.x1/a_27_47# 0.00624f
C3301 dc_inst.x7.x8/a_27_47# dc_inst.x6.x2/a_27_47# 0.01013f
C3302 _20_/a_79_21# dc_inst.in 0.00538f
C3303 delay_sel[0] _02_ 0
C3304 dc_inst.x5.net9 dc_inst.x1.x9/a_27_47# 0
C3305 _23_/a_448_47# _01_ 0
C3306 dc_inst.x4.x9/a_27_47# tdo 0.0177f
C3307 _13_/a_470_47# _02_ 0.07199f
C3308 dc_inst.x6.net11 dc_inst.x6.x4/a_27_47# 0
C3309 dc_inst.x6.net17 dc_inst.x10/a_76_199# 0
C3310 dc_inst.x1.net13 dc_inst.x2.net17 0.03783f
C3311 dc_inst.x6.net14 dc_inst.x6.net16 0
C3312 dc_inst.x7.net4 dc_inst.x9/a_193_413# 0.00144f
C3313 dc_inst.x3.net15 dc_inst.x3.net7 0
C3314 dc_inst.x5.net6 dc_inst.x2.net4 0.02217f
C3315 dc_inst.x6.x9/a_27_47# dc_inst.x6.x4/a_27_47# 0
C3316 dc_inst.x2.net16 dc_inst.x2.net15 0.0849f
C3317 _00_ _25_/a_651_413# 0.00153f
C3318 dc_inst.net7 _25_/a_1108_47# 0
C3319 _10_ dc_inst.x1.net3 0.01525f
C3320 dc_inst.x1.x4/a_27_47# path_sel[0] 0
C3321 delay_sel[0] dc_inst.x7.net12 0.04357f
C3322 path_sel[0] dc_inst.x1.x8/a_27_47# 0
C3323 dc_inst.x7.net4 dc_inst.x6.x4/a_27_47# 0
C3324 dc_inst.x6.x15/a_27_47# delay_sel[1] 0
C3325 dc_inst.x2.x8/a_27_47# dc_inst.x2.x7/a_27_47# 0
C3326 _04_ path[3] 0.0034f
C3327 dc_inst.x6.net4 dc_inst.x5.net19 0.00925f
C3328 dc_inst.x10/a_505_21# _24_/a_543_47# 0
C3329 dc_inst.x2.x3/a_27_47# dc_inst.x2.net3 0.12862f
C3330 _24_/a_761_289# shadow_q 0
C3331 dc_inst.x7.net4 dc_inst.x8/a_27_47# 0
C3332 dc_inst.x6.net10 dc_inst.x4.net17 0.00111f
C3333 dc_inst.x1.net12 dc_inst.x1.net2 0.08933f
C3334 _15_/a_788_316# dc_inst.x1.x12/a_27_47# 0
C3335 _03_ dc_inst.x7.x2/a_27_47# 0
C3336 path[5] path[4] 0.14555f
C3337 dc_inst.x2.x20/a_27_47# dc_inst.net2 0.00869f
C3338 delay_sel[1] dc_inst.x7.x3/a_27_47# 0
C3339 dc_inst.x5.net3 dc_inst.x1.x17/a_27_47# 0
C3340 dc_inst.x7.net14 dc_inst.x7.x14/a_27_47# 0.00301f
C3341 dc_inst.x4.net19 dc_inst.x5.net15 0
C3342 dc_inst.x1.x18/a_27_47# dc_inst.x6.net13 0.00102f
C3343 VPWR dc_inst.x7.x10/a_27_47# 0.00213f
C3344 dc_inst.net1 capture_d 0
C3345 dc_inst.x4.net19 dc_inst.x4.x18/a_27_47# 0
C3346 dc_inst.x7.net14 dc_inst.x7.net8 0
C3347 dc_inst.x7.net19 dc_inst.x6.net15 0
C3348 path_sel[1] dc_inst.x2.net5 0.00382f
C3349 _06_ dc_inst.x1.net5 0
C3350 _04_ _19_/a_27_47# 0
C3351 dc_inst.x3.net5 _23_/a_193_47# 0
C3352 dc_inst.x2.net18 dc_inst.net8 0
C3353 dc_inst.x9/a_27_47# clkbuf_1_0__f_clk/a_110_47# 0
C3354 dc_inst.x7.x16/a_27_47# dc_inst.x7.net16 0.03582f
C3355 dc_inst.x4.x3/a_27_47# dc_inst.x4.net5 0.00151f
C3356 dc_inst.in dc_inst.x7.x5/a_27_47# 0
C3357 _15_/a_872_316# dc_inst.x1.net3 0.00384f
C3358 dc_inst.x5.x1/a_27_47# dc_inst.x6.x11/a_27_47# 0
C3359 dc_inst.x2.x10/a_27_47# dc_inst.x1.x9/a_27_47# 0
C3360 _25_/a_27_47# _25_/a_543_47# -0.00454f
C3361 dc_inst.x8/a_27_47# dc_inst.net1 0.00127f
C3362 dc_inst.x7.x17/a_27_47# dc_inst.x7.net3 0
C3363 _24_/a_543_47# rst 0
C3364 path[2] _19_/a_193_297# 0.00103f
C3365 dc_inst.x5.net17 dc_inst.x6.net11 0
C3366 dc_inst.x6.x20/a_27_47# dc_inst.x9/a_750_97# 0
C3367 _00_ _25_/a_193_47# 0.54288f
C3368 dc_inst.x1.x2/a_27_47# dc_inst.x1.net2 0.01169f
C3369 dc_inst.net4 dc_inst.x4.net11 0
C3370 dc_inst.net6 dc_inst.x7.net13 0
C3371 _08_ dc_inst.x1.net6 0
C3372 dc_inst.x7.net1 _25_/a_448_47# 0.01331f
C3373 dc_inst.x5.x5/a_27_47# dc_inst.x5.net8 0
C3374 dc_inst.x7.net1 dc_inst.x7.net12 0.10592f
C3375 shadow_q dc_inst.x3.x15/a_27_47# 0.0043f
C3376 _03_ dc_inst.x9/a_1290_413# 0
C3377 dc_inst.x4.net19 dc_inst.x4.x7/a_27_47# 0
C3378 dc_inst.x5.x16/a_27_47# dc_inst.x6.x2/a_27_47# 0
C3379 dc_inst.x4.net5 dc_inst.x5.x8/a_27_47# 0
C3380 dc_inst.x9/a_193_47# delay_sel[1] 0
C3381 _24_/a_543_47# clknet_1_1__leaf_clk 0.03011f
C3382 clknet_1_0__leaf_clk _25_/a_193_47# 0.00367f
C3383 path_sel[1] dc_inst.x4.x5/a_27_47# 0.00225f
C3384 path[3] dc_inst.x1.net5 0
C3385 dc_inst.x1.net10 dc_inst.x1.net8 0.22069f
C3386 dc_inst.x3.x12/a_27_47# path[4] 0.01682f
C3387 dc_inst.x5.net2 path_sel[0] 0.00282f
C3388 dc_inst.x5.x12/a_27_47# dc_inst.x5.net11 0.01685f
C3389 _08_ path[2] 0.06259f
C3390 dc_inst.x6.x5/a_27_47# dc_inst.x1.net18 0
C3391 dc_inst.x10/a_76_199# clkload0/a_27_47# 0
C3392 dc_inst.x3.net1 shadow_q 0
C3393 dc_inst.x4.net5 dc_inst.x1.x18/a_27_47# 0
C3394 dc_inst.x3.net14 tdi 0
C3395 dc_inst.x3.x16/a_27_47# _23_/a_27_47# 0
C3396 dc_inst.x9/a_750_97# dc_inst.x6.x19/a_27_47# 0
C3397 dc_inst.x6.x2/a_27_47# dc_inst.x6.net2 0.02034f
C3398 dc_inst.x2.net4 path_sel[2] 0.00225f
C3399 delay_sel[0] dc_inst.in 0.04701f
C3400 dc_inst.x2.x12/a_27_47# path_sel[2] 0
C3401 dc_inst.x3.net10 dc_inst.x3.net8 0
C3402 dc_inst.x3.net5 dc_inst.x3.net2 0
C3403 _19_/a_27_47# dc_inst.x1.net5 0
C3404 delay_sel[1] dc_inst.x8/a_757_363# 0.00836f
C3405 VPWR dc_inst.x1.net10 0.24587f
C3406 _20_/a_79_21# dc_inst.x1.net12 0
C3407 tdi dc_inst.x3.x8/a_27_47# 0
C3408 dc_inst.x8/a_834_97# dc_inst.net8 0.03005f
C3409 path_sel[1] dc_inst.x2.net11 0.03421f
C3410 dc_inst.x2.x17/a_27_47# dc_inst.x2.net15 0.01158f
C3411 _15_/a_600_345# dc_inst.x1.net2 0.00449f
C3412 dc_inst.x2.net14 dc_inst.x1.net18 0
C3413 dc_inst.x3.net16 _23_/a_448_47# 0
C3414 dc_inst.x6.net10 dc_inst.x5.net17 0
C3415 dc_inst.net2 _00_ 0
C3416 dc_inst.x4.x8/a_27_47# dc_inst.x4.net17 0
C3417 clknet_0_clk _23_/a_543_47# 0
C3418 dc_inst.x8/a_1290_413# dc_inst.x3.x20/a_27_47# 0
C3419 path_sel[2] path[7] 0.00128f
C3420 dc_inst.x7.net6 dc_inst.x6.net19 0
C3421 _23_/a_448_47# dc_inst.in 0.0151f
C3422 VPWR _15_/a_788_316# 0.02184f
C3423 dc_inst.x3.x17/a_27_47# delay_sel[2] 0
C3424 dc_inst.x7.net12 dc_inst.x7.net18 0.02486f
C3425 VPWR dc_inst.x7.x20/a_27_47# 0.06129f
C3426 dc_inst.x7.net2 dc_inst.in 0
C3427 dc_inst.x5.net12 dc_inst.x1.x9/a_27_47# 0
C3428 _13_/a_27_297# shadow_q 0.00283f
C3429 dc_inst.x3.net14 rst 0
C3430 VPWR dc_inst.x7.x2/a_27_47# 0.00454f
C3431 dc_inst.x1.x10/a_27_47# dc_inst.x5.x12/a_27_47# 0.04629f
C3432 dc_inst.x6.net12 dc_inst.x6.net16 0
C3433 dc_inst.x1.net11 dc_inst.x1.net3 0.00128f
C3434 dc_inst.x6.net17 delay_sel[0] 0
C3435 dc_inst.x4.net1 dc_inst.x4.x7/a_27_47# 0
C3436 VPWR _14_/a_505_21# 0.04283f
C3437 dc_inst.x9/a_834_97# clknet_0_clk 0
C3438 dc_inst.x2.net10 dc_inst.x2.net15 0
C3439 dc_inst.x3.x4/a_27_47# path_sel[0] 0
C3440 dc_inst.x2.net5 dc_inst.x2.x14/a_27_47# 0.00125f
C3441 dc_inst.x4.net19 dc_inst.x4.net8 0
C3442 dc_inst.x4.net4 dc_inst.x1.net16 0.00146f
C3443 dc_inst.x9/a_1290_413# dc_inst.x8/a_277_47# 0
C3444 dc_inst.x3.x8/a_27_47# rst 0
C3445 se dc_inst.x3.x13/a_27_47# 0
C3446 dc_inst.x9/a_1478_413# dc_inst.x8/a_247_21# 0
C3447 dc_inst.x6.x20/a_27_47# dc_inst.x9/a_277_47# 0
C3448 path_sel[0] dc_inst.x2.net19 0.00107f
C3449 VPWR dc_inst.x6.x2/a_27_47# 0.04774f
C3450 _24_/a_1108_47# _00_ 0.05433f
C3451 dc_inst.x5.x13/a_27_47# dc_inst.x5.x15/a_27_47# 0
C3452 dc_inst.x1.net7 dc_inst.x1.net18 0
C3453 dc_inst.x3.net14 clknet_1_1__leaf_clk 0
C3454 tdo clknet_0_clk 0
C3455 dc_inst.x1.net9 dc_inst.x1.net14 0.03965f
C3456 _13_/a_470_47# path[6] 0.01322f
C3457 dc_inst.x4.x19/a_27_47# path_sel[0] 0.00266f
C3458 path_sel[1] _19_/a_109_297# 0.00916f
C3459 dc_inst.x6.net18 dc_inst.x7.net19 0
C3460 dc_inst.x7.x11/a_27_47# clk 0.05703f
C3461 tdo dc_inst.x6.net19 0.00314f
C3462 dc_inst.x6.net17 _23_/a_448_47# 0
C3463 dc_inst.x4.net19 dc_inst.x6.x6/a_27_47# 0.0218f
C3464 dc_inst.x2.net14 dc_inst.x1.x9/a_27_47# 0.00484f
C3465 dc_inst.x5.net3 dc_inst.x5.x4/a_27_47# 0
C3466 path_sel[1] dc_inst.x4.x12/a_27_47# 0.01137f
C3467 path_sel[1] dc_inst.x2.x11/a_27_47# 0.01299f
C3468 tdo clkbuf_0_clk/a_110_47# 0
C3469 VPWR dc_inst.x9/a_1290_413# -0.0265f
C3470 dc_inst.x6.x20/a_27_47# dc_inst.x7.net17 0
C3471 dc_inst.x2.net4 dc_inst.x1.net17 0
C3472 _13_/a_112_47# _02_ 0.09469f
C3473 VPWR _14_/a_218_47# -0
C3474 dc_inst.x7.net2 dc_inst.x6.net17 0.00527f
C3475 _15_/a_788_316# path[5] 0.03056f
C3476 _23_/a_1108_47# shadow_q 0
C3477 dc_inst.x2.net16 dc_inst.x2.x15/a_27_47# 0.01151f
C3478 dc_inst.net4 delay_sel[1] 0.04274f
C3479 dc_inst.x1.net11 dc_inst.x2.net12 0
C3480 dc_inst.x1.net13 dc_inst.x4.net5 0
C3481 path_sel[2] dc_inst.x1.x1/a_27_47# 0.00257f
C3482 dc_inst.x1.net15 dc_inst.x1.x5/a_27_47# 0
C3483 dc_inst.x4.net19 dc_inst.x4.x16/a_27_47# 0
C3484 dc_inst.x4.x11/a_27_47# dc_inst.x4.net11 0.04349f
C3485 dc_inst.x3.net19 dc_inst.x3.x10/a_27_47# 0
C3486 dc_inst.x5.x13/a_27_47# dc_inst.x5.net14 0.02399f
C3487 path_sel[1] dc_inst.x5.x15/a_27_47# 0.01258f
C3488 capture_d _23_/a_761_289# 0.00601f
C3489 _14_/a_505_21# path[5] 0.00215f
C3490 VPWR _24_/a_651_413# -0.00409f
C3491 _23_/a_1283_21# _01_ 0.01276f
C3492 dc_inst.x2.net2 dc_inst.x2.net4 0
C3493 _10_ path_sel[2] 0
C3494 dc_inst.x6.net6 dc_inst.x6.x2/a_27_47# 0
C3495 dc_inst.x1.net4 path[4] 0.00167f
C3496 dc_inst.x2.net11 dc_inst.x2.x14/a_27_47# 0
C3497 dc_inst.x8/a_1290_413# _23_/a_1283_21# 0
C3498 clknet_1_0__leaf_clk dc_inst.x7.net10 0
C3499 tdo dc_inst.x7.x15/a_27_47# 0
C3500 dc_inst.x8/a_668_97# dc_inst.x7.net4 0.00755f
C3501 dc_inst.x3.net6 dc_inst.x3.x15/a_27_47# 0
C3502 dc_inst.x4.net2 dc_inst.in 0.04686f
C3503 dc_inst.x3.net19 dc_inst.x1.x3/a_27_47# 0.00125f
C3504 dc_inst.x1.net7 dc_inst.x1.x9/a_27_47# 0.00182f
C3505 dc_inst.x7.net14 dc_inst.x7.net12 0.04327f
C3506 dc_inst.x5.net5 path_sel[0] 0.00234f
C3507 dc_inst.x4.net1 dc_inst.x4.net8 0
C3508 dc_inst.x9/a_277_47# dc_inst.x9/a_27_47# -0.00845f
C3509 dc_inst.x2.net14 dc_inst.x2.x3/a_27_47# 0
C3510 dc_inst.x1.net11 dc_inst.x2.net13 0
C3511 _25_/a_27_47# _03_ -0
C3512 _13_/a_470_297# _24_/a_193_47# 0
C3513 dc_inst.x5.net3 dc_inst.x5.x7/a_27_47# 0.03316f
C3514 _23_/a_1283_21# _02_ 0.0012f
C3515 dc_inst.x3.x12/a_27_47# _15_/a_788_316# 0
C3516 dc_inst.x5.net16 path_sel[2] 0.00135f
C3517 dc_inst.x4.x2/a_27_47# dc_inst.x2.net18 0
C3518 dc_inst.x1.net15 path_sel[0] 0
C3519 dc_inst.x3.net1 dc_inst.x3.net6 0.17106f
C3520 dc_inst.x3.x20/a_27_47# dc_inst.in 0
C3521 VPWR dc_inst.x4.net13 0.46863f
C3522 dc_inst.x1.x15/a_27_47# dc_inst.x1.net10 0
C3523 dc_inst.x2.net18 dc_inst.x1.x17/a_27_47# 0
C3524 dc_inst.net4 dc_inst.x9/a_757_363# 0.00906f
C3525 dc_inst.x3.net12 dc_inst.x3.net2 0
C3526 path_sel[1] dc_inst.x5.net14 0.02997f
C3527 dc_inst.x5.net2 dc_inst.x6.x8/a_27_47# 0
C3528 dc_inst.net7 dc_inst.x6.net16 0
C3529 clkload0/a_27_47# _23_/a_448_47# 0
C3530 dc_inst.x2.net8 dc_inst.x2.x4/a_27_47# 0
C3531 dc_inst.x5.net16 dc_inst.x6.x7/a_27_47# 0.01547f
C3532 dc_inst.x1.net14 dc_inst.x2.net12 0
C3533 dc_inst.x5.net18 dc_inst.x5.x14/a_27_47# 0
C3534 dc_inst.x6.net13 dc_inst.x6.net3 0
C3535 dc_inst.x3.net5 dc_inst.x3.x3/a_27_47# 0
C3536 tdo dc_inst.x2.net19 0
C3537 dc_inst.net8 dc_inst.x8/a_277_47# 0.59274f
C3538 dc_inst.x7.x9/a_27_47# dc_inst.net5 0.00148f
C3539 dc_inst.x4.net15 dc_inst.x5.x13/a_27_47# 0
C3540 capture_d dc_inst.x10/a_535_374# 0
C3541 dc_inst.x4.net10 dc_inst.x5.x7/a_27_47# 0.01107f
C3542 dc_inst.x3.net2 dc_inst.x3.x3/a_27_47# 0.0017f
C3543 dc_inst.x4.x19/a_27_47# tdo 0
C3544 dc_inst.x2.x20/a_27_47# dc_inst.x2.x19/a_27_47# 0.00104f
C3545 dc_inst.x2.net1 dc_inst.x2.net7 0
C3546 dc_inst.x4.net2 dc_inst.x6.net17 0
C3547 dc_inst.x7.net19 rst 0.00614f
C3548 dc_inst.x2.net1 dc_inst.x2.net10 0.11946f
C3549 dc_inst.x1.x12/a_27_47# _07_ 0.00699f
C3550 dc_inst.x7.x9/a_27_47# path_sel[2] 0.0027f
C3551 dc_inst.x7.net3 dc_inst.x6.net19 0
C3552 dc_inst.x1.net12 dc_inst.x1.net6 0.28932f
C3553 VPWR dc_inst.x9/a_923_363# -0
C3554 dc_inst.x2.net16 dc_inst.x1.net19 0
C3555 dc_inst.x5.net3 dc_inst.net4 0
C3556 dc_inst.x4.net2 path[6] 0
C3557 dc_inst.x2.x17/a_27_47# dc_inst.x2.x15/a_27_47# 0
C3558 _23_/a_193_47# shadow_q 0
C3559 VPWR dc_inst.net8 0.15121f
C3560 dc_inst.x9/a_668_97# dc_inst.x7.net13 0
C3561 dc_inst.x5.net9 path_sel[0] 0.00728f
C3562 dc_inst.x7.net3 clkbuf_0_clk/a_110_47# 0
C3563 path_sel[2] dc_inst.x8/a_247_21# 0
C3564 _15_/a_27_47# dc_inst.x3.x2/a_27_47# 0
C3565 dc_inst.x5.net18 dc_inst.x5.net15 0
C3566 dc_inst.x5.net7 dc_inst.x2.net7 0.03005f
C3567 dc_inst.x3.net9 _02_ 0.03393f
C3568 dc_inst.x4.net13 dc_inst.x6.net6 0
C3569 dc_inst.x8/a_1290_413# dc_inst.x2.net15 0
C3570 dc_inst.x3.x20/a_27_47# path[6] 0.01455f
C3571 dc_inst.net2 path_sel[0] 0
C3572 path_sel[1] dc_inst.x4.net15 0.00602f
C3573 dc_inst.x1.x2/a_27_47# dc_inst.x1.net6 0
C3574 path_sel[1] dc_inst.x3.net6 0
C3575 _23_/a_27_47# _01_ 0.00913f
C3576 path[0] dc_inst.x5.net9 0
C3577 path_sel[1] dc_inst.x5.net8 0.00487f
C3578 _16_/a_27_93# path_sel[0] 0.01196f
C3579 dc_inst.x5.x17/a_27_47# dc_inst.x6.net3 0
C3580 dc_inst.x7.x1/a_27_47# dc_inst.x4.net5 0
C3581 dc_inst.x2.x18/a_27_47# dc_inst.x1.x8/a_27_47# 0
C3582 dc_inst.x8/a_750_97# _23_/a_193_47# 0
C3583 dc_inst.x4.net1 dc_inst.x4.x9/a_27_47# 0.05137f
C3584 dc_inst.x6.net2 dc_inst.x7.x4/a_27_47# 0
C3585 dc_inst.x5.net6 dc_inst.x4.net11 0
C3586 dc_inst.x3.net16 _23_/a_1283_21# 0.00319f
C3587 dc_inst.x3.x20/a_27_47# dc_inst.x3.net17 0
C3588 dc_inst.x6.x15/a_27_47# dc_inst.x2.net18 0
C3589 dc_inst.x3.net13 path[6] 0
C3590 dc_inst.x9/a_834_97# _25_/a_193_47# 0
C3591 dc_inst.x5.net5 tdo 0
C3592 dc_inst.x4.x6/a_27_47# dc_inst.x6.net17 0
C3593 dc_inst.x2.net10 dc_inst.x2.x15/a_27_47# 0
C3594 dc_inst.x6.x12/a_27_47# dc_inst.x9/a_757_363# 0
C3595 dc_inst.x4.net3 dc_inst.in 0
C3596 dc_inst.x7.net3 dc_inst.x7.x15/a_27_47# 0
C3597 path[0] _16_/a_27_93# 0.01384f
C3598 dc_inst.x3.net5 shadow_q 0.0057f
C3599 _23_/a_27_47# _02_ 0
C3600 _15_/a_288_47# dc_inst.x1.net3 0.03122f
C3601 dc_inst.x2.net18 dc_inst.x7.x3/a_27_47# 0
C3602 dc_inst.x1.net15 tdo 0
C3603 _23_/a_1283_21# dc_inst.in 0
C3604 dc_inst.x1.net3 delay_sel[1] 0
C3605 dc_inst.x2.x10/a_27_47# path_sel[0] 0
C3606 dc_inst.x5.net3 dc_inst.x6.net8 0
C3607 dc_inst.x1.net11 path_sel[2] 0.03897f
C3608 tdo _25_/a_193_47# -0
C3609 dc_inst.x3.net2 shadow_q 0
C3610 dc_inst.x3.net6 _23_/a_1108_47# 0
C3611 dc_inst.x3.net13 dc_inst.x3.net17 0
C3612 dc_inst.x1.net4 dc_inst.x1.net10 0
C3613 _25_/a_27_47# VPWR 0.00359f
C3614 dc_inst.net4 dc_inst.x9/a_247_21# 0.22563f
C3615 dc_inst.x6.net12 dc_inst.x2.net16 0
C3616 dc_inst.x3.x20/a_27_47# dc_inst.x1.net12 0
C3617 dc_inst.x7.x20/a_27_47# dc_inst.net9 0
C3618 _07_ _17_/a_478_47# 0
C3619 _13_/a_112_47# path[6] 0.02507f
C3620 _13_/a_112_47# _24_/a_1283_21# 0.00337f
C3621 rst dc_inst.x3.net3 0
C3622 dc_inst.x5.net19 dc_inst.x5.x15/a_27_47# 0
C3623 dc_inst.net3 path[7] 0
C3624 dc_inst.x7.x2/a_27_47# dc_inst.net9 0
C3625 path[0] dc_inst.x2.x10/a_27_47# 0
C3626 dc_inst.x7.net4 dc_inst.x7.x9/a_27_47# 0
C3627 dc_inst.x3.net13 dc_inst.x3.x9/a_27_47# 0.12068f
C3628 dc_inst.x5.net3 dc_inst.x5.x19/a_27_47# 0
C3629 dc_inst.x2.x20/a_27_47# dc_inst.x2.net17 0.01105f
C3630 path_sel[1] _04_ 0.00118f
C3631 _13_/a_112_47# dc_inst.x3.net17 0
C3632 dc_inst.x3.net14 dc_inst.x3.x15/a_27_47# 0.02209f
C3633 dc_inst.x8/a_750_97# dc_inst.x3.net2 0
C3634 dc_inst.x8/a_668_97# dc_inst.net3 0.0011f
C3635 dc_inst.x4.net13 dc_inst.x4.net9 0.0023f
C3636 VPWR _07_ 0.22784f
C3637 dc_inst.x2.x1/a_27_47# tdo 0.00482f
C3638 _23_/a_1462_47# shadow_q 0
C3639 dc_inst.x7.net4 dc_inst.x8/a_247_21# 0.02842f
C3640 dc_inst.x2.x17/a_27_47# dc_inst.x1.net19 0
C3641 dc_inst.x4.net3 dc_inst.x6.net17 0.00309f
C3642 dc_inst.x2.net9 dc_inst.x2.x12/a_27_47# 0.00145f
C3643 VPWR dc_inst.x7.x4/a_27_47# -0.00939f
C3644 dc_inst.net7 dc_inst.x7.net19 0.0703f
C3645 dc_inst.x5.net9 tdo 0.00904f
C3646 dc_inst.x3.net1 dc_inst.x3.net14 0.02442f
C3647 VPWR _25_/a_1217_47# 0
C3648 _15_/a_27_47# dc_inst.x1.net2 0.10067f
C3649 dc_inst.x8/a_834_97# dc_inst.x7.x3/a_27_47# 0
C3650 _23_/a_1283_21# path[6] 0.00194f
C3651 dc_inst.x5.net19 dc_inst.x5.net14 0
C3652 dc_inst.x9/a_1478_413# delay_sel[1] 0.08285f
C3653 _24_/a_27_47# _00_ 0.03178f
C3654 dc_inst.x9/a_1290_413# dc_inst.net9 -0
C3655 dc_inst.net1 dc_inst.x8/a_247_21# 0.00179f
C3656 dc_inst.x1.net14 path_sel[2] 0.03358f
C3657 dc_inst.x3.x16/a_27_47# rst 0
C3658 _24_/a_1283_21# _23_/a_1283_21# 0.00264f
C3659 _24_/a_543_47# _23_/a_1108_47# 0
C3660 dc_inst.x6.x4/a_27_47# dc_inst.x6.net3 0
C3661 dc_inst.x4.net11 path_sel[2] 0
C3662 dc_inst.x3.net1 dc_inst.x3.x8/a_27_47# 0.03793f
C3663 dc_inst.x2.net18 dc_inst.x8/a_757_363# 0
C3664 dc_inst.x4.net16 dc_inst.x4.x12/a_27_47# 0.03296f
C3665 dc_inst.x4.net6 dc_inst.x6.x19/a_27_47# 0
C3666 dc_inst.x3.net5 dc_inst.x3.x1/a_27_47# 0
C3667 dc_inst.x7.x10/a_27_47# dc_inst.x9/a_277_47# 0
C3668 dc_inst.x4.net12 dc_inst.x4.net17 0.04896f
C3669 _05_ _13_/a_112_47# 0.02069f
C3670 dc_inst.x6.net13 dc_inst.x1.net18 0.00359f
C3671 dc_inst.x7.x11/a_27_47# dc_inst.x7.x12/a_27_47# 0.01013f
C3672 dc_inst.x3.net2 dc_inst.x3.x1/a_27_47# 0.00249f
C3673 dc_inst.x9/a_1290_413# dc_inst.x6.x13/a_27_47# 0
C3674 dc_inst.x2.net15 dc_inst.in 0
C3675 dc_inst.x3.net16 _23_/a_27_47# 0
C3676 dc_inst.x7.net9 dc_inst.x6.x2/a_27_47# 0
C3677 se _14_/a_505_21# 0.00766f
C3678 path_sel[1] dc_inst.x3.x19/a_27_47# 0
C3679 dc_inst.x5.net3 dc_inst.x4.x11/a_27_47# 0
C3680 path[2] _17_/a_174_21# 0.01057f
C3681 dc_inst.x1.x4/a_27_47# dc_inst.x1.net2 0
C3682 dc_inst.x5.net3 dc_inst.x4.net18 0.08807f
C3683 dc_inst.x5.net2 dc_inst.x4.net19 0.0331f
C3684 dc_inst.x1.x16/a_27_47# dc_inst.x2.net16 0.0013f
C3685 dc_inst.x1.net2 dc_inst.x1.x8/a_27_47# 0
C3686 path_sel[1] dc_inst.x1.net5 0.04464f
C3687 dc_inst.x7.x17/a_27_47# delay_sel[0] 0
C3688 dc_inst.x3.x16/a_27_47# clknet_1_1__leaf_clk 0
C3689 dc_inst.x5.net12 path_sel[0] 0.04941f
C3690 dc_inst.x7.net16 dc_inst.x10/a_218_47# 0
C3691 dc_inst.net3 dc_inst.x1.x1/a_27_47# 0
C3692 dc_inst.x5.net4 dc_inst.x5.net10 0.10069f
C3693 _15_/a_288_47# dc_inst.x3.net4 0
C3694 path[5] _07_ 0
C3695 dc_inst.x1.x13/a_27_47# dc_inst.x1.net9 0.00481f
C3696 _23_/a_27_47# dc_inst.in 0.08123f
C3697 dc_inst.x2.net1 _08_ 0
C3698 dc_inst.x5.net3 dc_inst.x2.net6 0.14692f
C3699 dc_inst.x6.net6 dc_inst.x7.x4/a_27_47# 0
C3700 dc_inst.net4 _25_/a_543_47# 0
C3701 dc_inst.x7.net6 dc_inst.x7.net10 0.0396f
C3702 _24_/a_1108_47# tdo 0
C3703 dc_inst.x5.net7 dc_inst.x2.x6/a_27_47# 0
C3704 VPWR _09_ 0.16016f
C3705 dc_inst.x7.x19/a_27_47# delay_sel[1] 0
C3706 dc_inst.x4.net10 dc_inst.x4.x11/a_27_47# 0.0022f
C3707 dc_inst.x9/a_750_97# dc_inst.x9/a_1290_413# -0.00475f
C3708 dc_inst.x2.x2/a_27_47# dc_inst.x5.x7/a_27_47# 0
C3709 _13_/a_27_297# dc_inst.x3.x8/a_27_47# 0
C3710 dc_inst.x7.net4 _24_/a_193_47# 0
C3711 path_sel[1] dc_inst.x3.net14 0
C3712 dc_inst.x6.x20/a_27_47# dc_inst.x6.x19/a_27_47# 0.00104f
C3713 dc_inst.x3.net9 path[6] 0.00197f
C3714 _15_/a_193_47# path_sel[0] -0
C3715 dc_inst.x8/a_834_97# dc_inst.x8/a_757_363# -0.00174f
C3716 dc_inst.x2.net14 path_sel[0] 0
C3717 dc_inst.x4.net5 dc_inst.x1.net18 0.26433f
C3718 _20_/a_79_21# _15_/a_27_47# 0
C3719 dc_inst.x4.net14 dc_inst.net4 0
C3720 dc_inst.x1.net7 dc_inst.x1.x5/a_27_47# 0.03139f
C3721 dc_inst.x7.x17/a_27_47# dc_inst.x7.net1 0.00383f
C3722 dc_inst.x4.net13 dc_inst.x6.x13/a_27_47# 0
C3723 dc_inst.x2.net15 dc_inst.x2.x5/a_27_47# 0
C3724 dc_inst.x3.net19 dc_inst.x3.x14/a_27_47# 0
C3725 VPWR dc_inst.x4.x2/a_27_47# 0.00316f
C3726 VPWR clkload0/X 0.01232f
C3727 VPWR dc_inst.x1.x17/a_27_47# 0.02165f
C3728 dc_inst.x1.x12/a_27_47# _18_/a_76_199# 0
C3729 dc_inst.x3.net5 dc_inst.x3.net6 0.00807f
C3730 dc_inst.x7.net7 dc_inst.x6.net16 0
C3731 dc_inst.x3.net11 dc_inst.x3.net8 0
C3732 dc_inst.x7.net6 dc_inst.x6.x5/a_27_47# 0
C3733 dc_inst.x2.x8/a_27_47# path_sel[0] 0
C3734 dc_inst.x3.x9/a_27_47# dc_inst.x3.net9 0.01236f
C3735 _23_/a_27_47# path[6] 0
C3736 dc_inst.x1.x4/a_27_47# _20_/a_79_21# 0
C3737 dc_inst.x3.x3/a_27_47# shadow_q 0.00146f
C3738 _24_/a_543_47# _23_/a_193_47# 0.00153f
C3739 dc_inst.x7.x20/a_27_47# dc_inst.x9/a_277_47# 0
C3740 clkbuf_1_1__f_clk/a_110_47# _00_ 0.03416f
C3741 dc_inst.x6.x15/a_27_47# dc_inst.x6.net2 0
C3742 _25_/a_27_47# dc_inst.x7.net11 0.0046f
C3743 dc_inst.net8 dc_inst.net9 0.20179f
C3744 dc_inst.x7.x20/a_27_47# delay_sel[2] 0
C3745 _09_ path[5] 0
C3746 dc_inst.net2 dc_inst.x7.net3 0.04682f
C3747 dc_inst.x3.net19 path[7] 0.00117f
C3748 dc_inst.x4.net19 dc_inst.x4.x19/a_27_47# 0.00318f
C3749 dc_inst.x4.net10 dc_inst.x2.net12 0
C3750 path_sel[0] _17_/a_27_93# 0.03636f
C3751 dc_inst.x9/a_277_47# dc_inst.x7.x2/a_27_47# 0
C3752 VPWR dc_inst.x5.x10/a_27_47# -0.00799f
C3753 dc_inst.x7.x2/a_27_47# delay_sel[2] 0
C3754 dc_inst.x4.net13 dc_inst.x4.x14/a_27_47# 0.01851f
C3755 dc_inst.x1.net7 path_sel[0] 0.00891f
C3756 dc_inst.net5 delay_sel[1] 0.03816f
C3757 shadow_q _24_/a_1462_47# 0
C3758 dc_inst.x8/a_750_97# dc_inst.x8/a_27_413# -0
C3759 dc_inst.x4.x17/a_27_47# tdo 0.00128f
C3760 _05_ dc_inst.x3.net9 0
C3761 dc_inst.x2.net15 dc_inst.x1.net12 0
C3762 dc_inst.net3 dc_inst.x8/a_247_21# 0.03314f
C3763 dc_inst.x5.net12 tdo 0.0699f
C3764 dc_inst.x5.net3 dc_inst.x4.net7 0
C3765 dc_inst.x4.net5 dc_inst.x1.x9/a_27_47# 0
C3766 _25_/a_27_47# clkbuf_1_0__f_clk/a_110_47# 0.0248f
C3767 dc_inst.x1.net4 dc_inst.net8 0
C3768 path[0] _17_/a_27_93# 0.0026f
C3769 _15_/a_288_47# path_sel[2] 0.00197f
C3770 dc_inst.x4.x10/a_27_47# dc_inst.x5.net8 0
C3771 dc_inst.x4.net16 dc_inst.x4.net15 0.00317f
C3772 dc_inst.x1.net15 dc_inst.x2.x18/a_27_47# 0
C3773 dc_inst.x7.x17/a_27_47# dc_inst.x7.net18 0.01802f
C3774 path_sel[2] delay_sel[1] 0.00158f
C3775 dc_inst.x6.x5/a_27_47# tdo 0
C3776 dc_inst.x7.x2/a_27_47# dc_inst.x7.net17 0.00184f
C3777 dc_inst.x6.x18/a_27_47# tdo 0.01108f
C3778 _13_/a_470_297# capture_q 0
C3779 dc_inst.x4.net16 dc_inst.x5.net8 0
C3780 dc_inst.x2.x19/a_27_47# path_sel[0] 0
C3781 VPWR _20_/a_470_297# -0
C3782 dc_inst.x5.net3 dc_inst.x5.net6 0.2731f
C3783 dc_inst.x1.net13 dc_inst.x1.x1/a_27_47# 0
C3784 dc_inst.x8/a_277_47# dc_inst.x7.x3/a_27_47# 0
C3785 dc_inst.x5.x5/a_27_47# dc_inst.x2.net7 0.12349f
C3786 dc_inst.x7.x17/a_27_47# dc_inst.x7.x18/a_27_47# 0.02448f
C3787 dc_inst.x9/a_750_97# dc_inst.x9/a_923_363# -0
C3788 dc_inst.x9/a_1290_413# dc_inst.x9/a_277_47# -0.00422f
C3789 dc_inst.x2.net11 dc_inst.x2.x11/a_27_47# 0.01506f
C3790 dc_inst.x6.x8/a_27_47# dc_inst.x7.net10 0
C3791 dc_inst.x4.net7 dc_inst.x4.net10 0
C3792 _23_/a_27_47# clkload0/a_27_47# 0
C3793 dc_inst.x2.net14 tdo 0
C3794 dc_inst.x6.net17 dc_inst.x6.net15 0.075f
C3795 dc_inst.x1.net2 dc_inst.x2.net19 0.00322f
C3796 _20_/a_384_47# dc_inst.x1.net11 0
C3797 VPWR dc_inst.x6.x15/a_27_47# 0.06584f
C3798 _02_ _24_/a_1217_47# 0
C3799 dc_inst.x4.x6/a_27_47# dc_inst.x4.net8 0
C3800 dc_inst.x5.x20/a_27_47# dc_inst.x7.net19 0
C3801 dc_inst.x3.net4 capture_q 0
C3802 dc_inst.x9/a_757_363# dc_inst.net5 0
C3803 dc_inst.x5.x4/a_27_47# dc_inst.x5.x3/a_27_47# 0.02448f
C3804 dc_inst.x4.net13 dc_inst.x6.net7 0
C3805 dc_inst.x5.net6 dc_inst.x4.net10 0
C3806 VPWR dc_inst.x7.x3/a_27_47# 0.01783f
C3807 VPWR _18_/a_76_199# 0.00146f
C3808 path[3] _19_/a_193_297# 0
C3809 dc_inst.net3 dc_inst.x3.net15 0
C3810 dc_inst.x2.x3/a_27_47# dc_inst.x4.net5 0
C3811 delay_sel[2] _24_/a_651_413# 0.0022f
C3812 dc_inst.x3.x15/a_27_47# dc_inst.x3.net3 0
C3813 dc_inst.x3.net14 _23_/a_193_47# 0
C3814 capture_d _24_/a_639_47# 0.00114f
C3815 dc_inst.x9/a_757_363# path_sel[2] 0
C3816 dc_inst.x2.net17 dc_inst.x1.x5/a_27_47# 0
C3817 dc_inst.x6.x10/a_27_47# dc_inst.x4.net17 0
C3818 dc_inst.x5.x6/a_27_47# dc_inst.net4 0.00358f
C3819 clknet_0_clk dc_inst.x7.x5/a_27_47# 0
C3820 dc_inst.x2.net7 dc_inst.x1.x19/a_27_47# 0
C3821 dc_inst.x1.x6/a_27_47# dc_inst.x1.net7 0.00914f
C3822 dc_inst.x5.net12 dc_inst.x6.x8/a_27_47# 0
C3823 dc_inst.x1.net9 dc_inst.x2.x13/a_27_47# 0.00192f
C3824 tdi _02_ 0.0433f
C3825 dc_inst.x10/a_505_21# _01_ 0.01367f
C3826 dc_inst.x1.net10 dc_inst.x1.net16 0
C3827 dc_inst.x7.x20/a_27_47# _25_/a_1283_21# 0
C3828 dc_inst.x6.net19 dc_inst.x7.x5/a_27_47# 0
C3829 dc_inst.x3.net5 dc_inst.x3.x19/a_27_47# 0.0172f
C3830 dc_inst.net2 dc_inst.x2.x18/a_27_47# 0.00127f
C3831 dc_inst.x1.net9 dc_inst.x2.net18 0
C3832 dc_inst.net3 _24_/a_193_47# 0
C3833 dc_inst.x5.net19 dc_inst.x6.net16 0
C3834 _08_ path[3] 0.16184f
C3835 dc_inst.x7.x2/a_27_47# _25_/a_1283_21# 0
C3836 dc_inst.x3.net2 dc_inst.x3.x19/a_27_47# 0
C3837 dc_inst.net6 delay_sel[1] 0.01759f
C3838 dc_inst.x4.net18 dc_inst.x4.net14 0.23747f
C3839 dc_inst.x6.net17 dc_inst.x5.net7 0
C3840 dc_inst.x8/a_277_47# dc_inst.x8/a_757_363# -0
C3841 dc_inst.x7.net4 delay_sel[1] 0.02068f
C3842 dc_inst.x6.net14 dc_inst.in 0.00437f
C3843 VPWR dc_inst.x9/a_193_47# -0
C3844 dc_inst.x3.net15 _23_/a_761_289# 0
C3845 rst _01_ 0.01251f
C3846 _03_ dc_inst.net4 0
C3847 VPWR dc_inst.x5.x4/a_27_47# -0.0102f
C3848 dc_inst.x5.net7 dc_inst.x2.x5/a_27_47# 0
C3849 _08_ _19_/a_27_47# 0.02116f
C3850 dc_inst.x3.x10/a_27_47# dc_inst.x3.x6/a_27_47# 0
C3851 dc_inst.x3.net5 dc_inst.x3.net14 0.09654f
C3852 dc_inst.x3.net12 dc_inst.x3.net6 0.03274f
C3853 dc_inst.x3.x16/a_27_47# dc_inst.x3.x15/a_27_47# 0
C3854 dc_inst.x6.net5 dc_inst.x7.x4/a_27_47# 0
C3855 dc_inst.x2.x13/a_27_47# dc_inst.x2.net6 0
C3856 dc_inst.x3.net14 dc_inst.x3.net2 0
C3857 dc_inst.net1 delay_sel[1] 0.10981f
C3858 _24_/a_27_47# _23_/a_543_47# 0.00148f
C3859 _24_/a_193_47# _23_/a_761_289# 0.00702f
C3860 delay_sel[0] clknet_0_clk 0
C3861 dc_inst.x5.net3 dc_inst.x6.x7/a_27_47# 0
C3862 dc_inst.x1.net15 dc_inst.x1.net2 0
C3863 _15_/a_27_47# dc_inst.x1.net6 0
C3864 dc_inst.x6.x18/a_27_47# dc_inst.x7.net3 0
C3865 dc_inst.x6.net18 dc_inst.in 0.02938f
C3866 dc_inst.x1.x3/a_27_47# dc_inst.x3.x7/a_27_47# 0
C3867 _25_/a_27_47# _24_/a_448_47# 0
C3868 dc_inst.x5.x6/a_27_47# dc_inst.x6.net8 0
C3869 VPWR dc_inst.x8/a_757_363# -0.00962f
C3870 dc_inst.x5.x19/a_27_47# dc_inst.x7.x8/a_27_47# 0
C3871 _02_ rst 0.06037f
C3872 clknet_1_1__leaf_clk _01_ 0
C3873 dc_inst.x9/a_1290_413# _25_/a_1283_21# 0
C3874 delay_sel[0] dc_inst.x6.net19 0
C3875 dc_inst.x3.x1/a_27_47# shadow_q 0
C3876 dc_inst.x2.x2/a_27_47# dc_inst.x2.net6 0
C3877 dc_inst.x7.x16/a_27_47# dc_inst.x7.net19 0.0345f
C3878 dc_inst.x9/a_757_363# dc_inst.x6.net11 0
C3879 dc_inst.x1.x20/a_27_47# dc_inst.x2.net16 0
C3880 _13_/a_27_297# dc_inst.x3.net3 0
C3881 dc_inst.x4.net10 path_sel[2] 0
C3882 dc_inst.x4.x1/a_27_47# path_sel[0] 0
C3883 dc_inst.x4.x5/a_27_47# dc_inst.x5.net8 0
C3884 path_sel[1] dc_inst.x2.net16 0
C3885 delay_sel[2] dc_inst.net8 0.00578f
C3886 path[4] _15_/a_1279_413# 0.00249f
C3887 dc_inst.x5.net11 path_sel[0] 0
C3888 dc_inst.net6 dc_inst.x9/a_757_363# 0.01284f
C3889 dc_inst.x6.net14 dc_inst.x6.net17 0.13692f
C3890 path_sel[1] dc_inst.x3.net3 0
C3891 dc_inst.x1.x13/a_27_47# path_sel[2] 0.01042f
C3892 dc_inst.net4 dc_inst.x6.net2 0.03476f
C3893 dc_inst.x9/a_247_21# dc_inst.net5 0
C3894 clknet_1_1__leaf_clk _02_ 0.00742f
C3895 clknet_0_clk _23_/a_448_47# 0
C3896 dc_inst.x9/a_923_363# dc_inst.x7.net17 0
C3897 _06_ dc_inst.in 0
C3898 dc_inst.x8/a_750_97# dc_inst.x3.x1/a_27_47# 0
C3899 _24_/a_27_47# tdo 0.01817f
C3900 dc_inst.x7.net2 clknet_0_clk 0.00158f
C3901 dc_inst.x2.x13/a_27_47# dc_inst.x2.net12 0.05855f
C3902 VPWR dc_inst.x5.x7/a_27_47# 0.00856f
C3903 path[0] dc_inst.x5.net11 0
C3904 dc_inst.x9/a_247_21# path_sel[2] 0.00144f
C3905 dc_inst.x6.net18 dc_inst.x6.net17 0.01281f
C3906 clknet_1_1__leaf_clk _25_/a_448_47# 0
C3907 dc_inst.x1.net13 dc_inst.x1.net11 0
C3908 dc_inst.x7.net2 dc_inst.x6.net19 0.04865f
C3909 clknet_0_clk dc_inst.x7.net1 0.07198f
C3910 dc_inst.x5.net3 dc_inst.x6.net11 0
C3911 dc_inst.x5.x19/a_27_47# dc_inst.x5.net13 0
C3912 _04_ dc_inst.x3.net12 0
C3913 dc_inst.x4.net2 _15_/a_27_47# 0
C3914 dc_inst.x2.x2/a_27_47# dc_inst.x2.net12 0
C3915 VPWR dc_inst.x3.net18 0
C3916 dc_inst.x5.x5/a_27_47# dc_inst.x2.x6/a_27_47# 0
C3917 dc_inst.x6.net19 dc_inst.x7.net1 0
C3918 _13_/a_27_297# dc_inst.x3.x16/a_27_47# 0
C3919 dc_inst.x4.net1 dc_inst.x5.net9 0
C3920 dc_inst.x7.net2 clkbuf_0_clk/a_110_47# 0
C3921 dc_inst.x5.net16 dc_inst.x6.net3 0
C3922 dc_inst.x5.net3 dc_inst.x6.x9/a_27_47# 0
C3923 dc_inst.net4 dc_inst.x4.x20/a_27_47# 0.02715f
C3924 dc_inst.x10/a_505_21# dc_inst.x3.net16 0
C3925 _15_/a_27_47# dc_inst.x3.x20/a_27_47# 0
C3926 dc_inst.net2 dc_inst.x1.net2 0
C3927 dc_inst.x7.net1 clkbuf_0_clk/a_110_47# 0.1085f
C3928 dc_inst.x5.net14 dc_inst.x5.x15/a_27_47# 0.01884f
C3929 _25_/a_27_47# delay_sel[2] 0
C3930 dc_inst.x2.net4 dc_inst.x1.net18 0.0012f
C3931 _18_/a_218_374# _07_ 0.00176f
C3932 dc_inst.x7.net5 delay_sel[1] 0
C3933 tdo dc_inst.x6.x16/a_27_47# 0.01039f
C3934 dc_inst.x10/a_505_21# dc_inst.in 0.00144f
C3935 capture_d _00_ 0.02085f
C3936 dc_inst.x1.x10/a_27_47# path_sel[0] 0
C3937 dc_inst.x2.x13/a_27_47# dc_inst.x2.net13 0.01506f
C3938 dc_inst.net4 dc_inst.x6.x1/a_27_47# 0.00628f
C3939 dc_inst.x1.x4/a_27_47# dc_inst.x4.net2 0
C3940 dc_inst.x1.net4 dc_inst.x4.x2/a_27_47# 0
C3941 dc_inst.x6.net2 dc_inst.x6.net8 0
C3942 dc_inst.x4.net2 dc_inst.x1.x8/a_27_47# 0
C3943 _13_/a_470_47# dc_inst.x3.net8 0.00311f
C3944 dc_inst.x5.x19/a_27_47# dc_inst.x5.x16/a_27_47# 0
C3945 dc_inst.x3.net6 shadow_q 0
C3946 dc_inst.x4.net14 dc_inst.x5.net6 0
C3947 dc_inst.net7 dc_inst.x10/a_439_47# 0
C3948 dc_inst.x3.net13 _15_/a_27_47# 0.00711f
C3949 dc_inst.x3.net16 rst 0
C3950 dc_inst.x5.net3 dc_inst.net1 0
C3951 dc_inst.x5.x12/a_27_47# dc_inst.x1.net11 0
C3952 dc_inst.x1.x2/a_27_47# dc_inst.x1.x11/a_27_47# 0
C3953 VPWR dc_inst.net4 0.4166f
C3954 _13_/a_470_47# dc_inst.x3.x4/a_27_47# 0
C3955 dc_inst.x4.x3/a_27_47# delay_sel[1] 0
C3956 _25_/a_27_47# dc_inst.x7.net17 0
C3957 dc_inst.x3.x20/a_27_47# dc_inst.x1.x8/a_27_47# 0
C3958 dc_inst.x8/a_1478_413# delay_sel[0] 0
C3959 dc_inst.x5.net7 dc_inst.x2.x4/a_27_47# 0
C3960 VPWR dc_inst.x3.net7 0.12389f
C3961 clkbuf_1_1__f_clk/a_110_47# _23_/a_543_47# 0
C3962 dc_inst.x5.x18/a_27_47# dc_inst.x5.x2/a_27_47# 0
C3963 dc_inst.x2.x2/a_27_47# dc_inst.x4.net7 0.0016f
C3964 dc_inst.x3.net10 dc_inst.x3.x10/a_27_47# 0.01674f
C3965 dc_inst.x7.net3 dc_inst.x2.x19/a_27_47# 0
C3966 dc_inst.x5.net3 dc_inst.x2.net2 0
C3967 dc_inst.x5.x19/a_27_47# dc_inst.x6.net2 0
C3968 dc_inst.x4.net10 dc_inst.x1.net17 0
C3969 dc_inst.in rst 0.02657f
C3970 dc_inst.x4.net15 dc_inst.x4.x12/a_27_47# 0.01149f
C3971 dc_inst.x3.x16/a_27_47# _23_/a_1108_47# 0.00179f
C3972 clknet_0_clk dc_inst.x7.net18 0.00144f
C3973 path_sel[1] dc_inst.x2.x17/a_27_47# 0
C3974 dc_inst.x5.net6 dc_inst.x2.x13/a_27_47# 0
C3975 _15_/a_397_47# path[7] 0
C3976 dc_inst.x7.x15/a_27_47# dc_inst.x7.net1 0.01839f
C3977 dc_inst.x5.net3 dc_inst.x6.net10 0
C3978 dc_inst.x1.net13 dc_inst.x1.net14 0.30267f
C3979 dc_inst.x3.net18 dc_inst.x3.x5/a_27_47# 0.01149f
C3980 dc_inst.x4.x20/a_27_47# dc_inst.x6.net8 0
C3981 dc_inst.x3.net16 clknet_1_1__leaf_clk 0
C3982 tdi path[6] 0.07185f
C3983 path[5] dc_inst.x3.net18 0.02311f
C3984 dc_inst.x4.net18 dc_inst.x5.net13 0.01027f
C3985 dc_inst.x2.net14 dc_inst.x2.x18/a_27_47# 0
C3986 dc_inst.net1 dc_inst.x4.net10 0
C3987 dc_inst.x4.net19 dc_inst.x4.x17/a_27_47# 0.00235f
C3988 dc_inst.x2.x2/a_27_47# dc_inst.x5.net6 0.00221f
C3989 dc_inst.net6 dc_inst.x9/a_247_21# -0
C3990 dc_inst.x2.x15/a_27_47# dc_inst.x5.net4 0
C3991 dc_inst.x7.x18/a_27_47# clknet_0_clk 0.01061f
C3992 dc_inst.x2.net16 dc_inst.x2.x14/a_27_47# 0
C3993 dc_inst.net3 delay_sel[1] 0.08258f
C3994 dc_inst.x4.net19 dc_inst.x5.net12 0.002f
C3995 dc_inst.x5.x18/a_27_47# dc_inst.x6.net2 0.01273f
C3996 dc_inst.x1.x3/a_27_47# dc_inst.x1.x5/a_27_47# 0
C3997 dc_inst.x7.net4 dc_inst.x9/a_247_21# 0.00222f
C3998 dc_inst.x9/a_757_363# dc_inst.x7.net5 0
C3999 _00_ _25_/a_1270_413# 0
C4000 clknet_1_1__leaf_clk dc_inst.in 0
C4001 delay_sel[0] dc_inst.x4.x4/a_27_47# 0.0012f
C4002 dc_inst.x2.net1 _17_/a_174_21# 0
C4003 dc_inst.x2.net2 dc_inst.x4.net10 0.01084f
C4004 dc_inst.x5.net7 dc_inst.x4.x7/a_27_47# 0.03348f
C4005 dc_inst.x5.net1 path_sel[0] 0.00252f
C4006 dc_inst.x4.net2 dc_inst.x6.net19 0.00188f
C4007 tdi dc_inst.x3.net17 0
C4008 dc_inst.x4.net19 dc_inst.x6.x5/a_27_47# 0
C4009 dc_inst.net7 dc_inst.x7.net12 0
C4010 dc_inst.x3.net14 dc_inst.x3.net12 0.04463f
C4011 dc_inst.x6.x15/a_27_47# dc_inst.net9 0
C4012 dc_inst.x1.x12/a_27_47# dc_inst.x1.net3 0
C4013 dc_inst.x5.x20/a_27_47# dc_inst.x7.net8 0
C4014 dc_inst.x5.net5 dc_inst.x2.net8 0
C4015 dc_inst.x1.x20/a_27_47# dc_inst.x2.net7 0
C4016 dc_inst.x6.net9 dc_inst.x6.x6/a_27_47# 0
C4017 path_sel[1] dc_inst.x2.net7 0.02503f
C4018 VPWR dc_inst.x6.net8 0.17991f
C4019 _24_/a_543_47# shadow_q 0
C4020 _24_/a_27_47# dc_inst.x7.net3 0
C4021 dc_inst.x7.net17 _25_/a_1217_47# 0
C4022 _09_ _18_/a_218_374# 0.00111f
C4023 path_sel[1] dc_inst.x2.net10 0.03703f
C4024 dc_inst.net4 dc_inst.x6.net6 0.65544f
C4025 dc_inst.x6.net17 rst 0
C4026 dc_inst.x3.net12 dc_inst.x3.x8/a_27_47# 0
C4027 clknet_1_0__leaf_clk dc_inst.x7.net13 0.00332f
C4028 dc_inst.x6.net12 dc_inst.x6.net17 0
C4029 dc_inst.x3.net7 dc_inst.x3.x5/a_27_47# 0.03566f
C4030 path[0] dc_inst.x5.net1 0
C4031 path[5] dc_inst.x3.net7 0.05009f
C4032 dc_inst.x1.net1 _08_ 0
C4033 dc_inst.x10/a_505_21# dc_inst.x3.net17 0
C4034 dc_inst.x6.x12/a_27_47# dc_inst.x6.x1/a_27_47# 0
C4035 dc_inst.x7.x15/a_27_47# dc_inst.x7.net18 0.01666f
C4036 rst path[6] 0.0423f
C4037 _13_/a_112_47# dc_inst.x3.x18/a_27_47# 0
C4038 VPWR dc_inst.x5.x19/a_27_47# 0.01014f
C4039 _24_/a_1283_21# rst 0
C4040 _24_/a_761_289# _01_ 0
C4041 dc_inst.x7.net2 dc_inst.x4.x4/a_27_47# 0
C4042 _00_ _25_/a_761_289# 0.04549f
C4043 dc_inst.x4.net15 dc_inst.x5.net14 0
C4044 VPWR dc_inst.x6.x12/a_27_47# 0.01172f
C4045 tdi _05_ 0.01865f
C4046 dc_inst.x4.net13 dc_inst.x4.net6 0
C4047 dc_inst.x8/a_193_413# dc_inst.x1.x20/a_27_47# 0
C4048 path[3] dc_inst.x1.net12 0
C4049 dc_inst.x1.net9 dc_inst.x1.net8 0.19881f
C4050 dc_inst.x7.net1 _25_/a_651_413# 0.00272f
C4051 dc_inst.x1.x4/a_27_47# dc_inst.x4.net3 0
C4052 dc_inst.x2.x20/a_27_47# path[7] 0
C4053 dc_inst.x3.net17 rst 0
C4054 dc_inst.x6.net14 dc_inst.x4.x7/a_27_47# 0
C4055 dc_inst.x4.net3 dc_inst.x1.x8/a_27_47# 0
C4056 dc_inst.x1.x16/a_27_47# dc_inst.in 0
C4057 dc_inst.x2.x13/a_27_47# path_sel[2] 0.00224f
C4058 _03_ dc_inst.x9/a_1478_413# 0
C4059 dc_inst.x2.net6 dc_inst.x5.x3/a_27_47# 0.00721f
C4060 dc_inst.x7.net7 dc_inst.x7.net8 0.03405f
C4061 dc_inst.x6.x5/a_27_47# dc_inst.x6.x11/a_27_47# 0
C4062 clknet_1_1__leaf_clk path[6] 0.03377f
C4063 clknet_1_0__leaf_clk _25_/a_761_289# 0
C4064 dc_inst.x9/a_668_97# delay_sel[1] 0.04573f
C4065 VPWR dc_inst.x5.x18/a_27_47# 0.07214f
C4066 dc_inst.x2.net18 path_sel[2] 0.00445f
C4067 _24_/a_1283_21# clknet_1_1__leaf_clk 0.00195f
C4068 _24_/a_761_289# _02_ 0
C4069 dc_inst.x5.net3 dc_inst.x4.x8/a_27_47# 0
C4070 dc_inst.x2.net4 dc_inst.x2.x3/a_27_47# 0.04368f
C4071 dc_inst.x7.net16 dc_inst.x7.net19 0.0612f
C4072 dc_inst.x2.x2/a_27_47# path_sel[2] 0
C4073 VPWR dc_inst.x1.net9 0.16492f
C4074 dc_inst.x3.x19/a_27_47# shadow_q 0
C4075 dc_inst.x4.net18 dc_inst.x4.x20/a_27_47# 0
C4076 dc_inst.x5.net9 dc_inst.x2.net8 0
C4077 dc_inst.x3.x9/a_27_47# rst 0
C4078 dc_inst.x6.net6 dc_inst.x6.net8 0.04306f
C4079 dc_inst.x3.net5 dc_inst.x3.net3 0
C4080 dc_inst.x3.x16/a_27_47# _23_/a_193_47# 0
C4081 dc_inst.x1.x2/a_27_47# path[3] 0
C4082 dc_inst.x5.x6/a_27_47# dc_inst.x5.net6 0.0495f
C4083 dc_inst.x9/a_1290_413# dc_inst.x6.x19/a_27_47# 0
C4084 delay_sel[2] clkload0/X 0.00363f
C4085 dc_inst.x3.x15/a_27_47# _01_ 0
C4086 dc_inst.x3.net2 dc_inst.x3.net3 0.39317f
C4087 dc_inst.net7 dc_inst.in 0
C4088 dc_inst.x1.x14/a_27_47# dc_inst.x2.net15 0.00332f
C4089 dc_inst.x4.net8 dc_inst.x5.net7 0.11063f
C4090 _19_/a_109_297# dc_inst.x1.net5 0
C4091 _15_/a_788_316# dc_inst.x3.x13/a_27_47# 0
C4092 dc_inst.x5.net3 dc_inst.x5.x8/a_27_47# 0.04831f
C4093 dc_inst.x6.x3/a_27_47# dc_inst.x7.net10 0
C4094 dc_inst.x2.x17/a_27_47# dc_inst.x2.x14/a_27_47# 0
C4095 _06_ _15_/a_600_345# 0
C4096 dc_inst.x4.net2 dc_inst.x2.net19 0.00548f
C4097 dc_inst.net4 dc_inst.x4.net9 0
C4098 tdo dc_inst.x6.net13 0.0056f
C4099 _15_/a_193_47# dc_inst.x1.net2 0.00186f
C4100 dc_inst.x7.net1 _25_/a_193_47# 0.03814f
C4101 _05_ rst 0.09197f
C4102 dc_inst.x3.net16 _23_/a_651_413# 0
C4103 dc_inst.x7.x12/a_27_47# clk 0
C4104 dc_inst.x9/a_247_21# dc_inst.x7.net5 0.00748f
C4105 VPWR dc_inst.x4.x11/a_27_47# -0.00819f
C4106 clkload0/a_27_47# rst 0.0703f
C4107 dc_inst.x3.net14 shadow_q 0
C4108 dc_inst.x4.net18 VPWR -0.00265f
C4109 dc_inst.x6.x18/a_27_47# dc_inst.x10/a_76_199# 0.00121f
C4110 dc_inst.x6.x12/a_27_47# dc_inst.x6.net6 0
C4111 dc_inst.x3.x15/a_27_47# _02_ 0
C4112 VPWR dc_inst.x1.net3 0.18499f
C4113 path_sel[0] dc_inst.x4.net17 0.00142f
C4114 dc_inst.x2.x10/a_27_47# dc_inst.x5.x11/a_27_47# 0
C4115 dc_inst.x1.x1/a_27_47# dc_inst.x1.x9/a_27_47# 0
C4116 dc_inst.x8/a_1478_413# dc_inst.x3.x20/a_27_47# 0.01731f
C4117 delay_sel[0] dc_inst.net2 0
C4118 dc_inst.x4.net15 dc_inst.x5.net8 0
C4119 VPWR dc_inst.x2.net6 0.10127f
C4120 dc_inst.x3.net13 dc_inst.x3.net8 0
C4121 dc_inst.x1.net4 dc_inst.x8/a_757_363# 0
C4122 dc_inst.x3.x17/a_27_47# dc_inst.net8 0
C4123 dc_inst.x4.net10 dc_inst.x5.x8/a_27_47# 0
C4124 dc_inst.x3.x8/a_27_47# shadow_q 0
C4125 dc_inst.x1.net15 dc_inst.x1.net6 0
C4126 dc_inst.x3.net1 _02_ 0.09102f
C4127 _05_ clknet_1_1__leaf_clk 0
C4128 clkload0/a_27_47# clknet_1_1__leaf_clk 0.02666f
C4129 dc_inst.x3.net5 dc_inst.x3.x16/a_27_47# 0
C4130 dc_inst.x2.x20/a_27_47# dc_inst.x1.x1/a_27_47# 0
C4131 dc_inst.x4.net2 dc_inst.x4.x4/a_27_47# 0.00704f
C4132 dc_inst.x2.net10 dc_inst.x2.x14/a_27_47# 0
C4133 dc_inst.x3.net2 dc_inst.x3.x16/a_27_47# 0
C4134 dc_inst.x7.net14 dc_inst.x7.x15/a_27_47# 0.02816f
C4135 dc_inst.x8/a_750_97# dc_inst.x3.net14 0
C4136 dc_inst.x4.net12 dc_inst.x4.net11 0.01589f
C4137 dc_inst.x5.net3 dc_inst.x2.net9 0.01298f
C4138 _13_/a_112_47# dc_inst.x3.net8 0.0255f
C4139 dc_inst.x3.x14/a_27_47# dc_inst.x3.x6/a_27_47# 0.01254f
C4140 dc_inst.x7.x8/a_27_47# path_sel[2] 0.00659f
C4141 dc_inst.x9/a_1478_413# dc_inst.x8/a_277_47# 0
C4142 dc_inst.net4 dc_inst.x6.x17/a_27_47# 0.0025f
C4143 dc_inst.x4.net5 tdo 0.01313f
C4144 dc_inst.x3.net19 _15_/a_288_47# 0
C4145 dc_inst.x3.net19 delay_sel[1] 0.00109f
C4146 _15_/a_600_345# _19_/a_27_47# 0
C4147 dc_inst.net4 clkbuf_1_0__f_clk/a_110_47# 0
C4148 dc_inst.x7.net4 dc_inst.x2.net18 0
C4149 dc_inst.x1.net7 dc_inst.x1.net2 0.00106f
C4150 path_sel[1] _19_/a_193_297# 0
C4151 dc_inst.x7.net18 _25_/a_193_47# 0
C4152 dc_inst.x2.net17 dc_inst.x2.x18/a_27_47# 0.02031f
C4153 _13_/a_470_47# _24_/a_1108_47# 0
C4154 VPWR dc_inst.x2.net12 0.11254f
C4155 dc_inst.x4.net18 dc_inst.x6.net6 0
C4156 dc_inst.x2.x2/a_27_47# dc_inst.x1.net17 0
C4157 dc_inst.x5.x6/a_27_47# path_sel[2] 0.00551f
C4158 dc_inst.x6.net10 dc_inst.x4.net14 0
C4159 path[5] dc_inst.x1.net3 0.20499f
C4160 path_sel[1] dc_inst.x2.x6/a_27_47# 0.00338f
C4161 VPWR dc_inst.x9/a_1478_413# 0
C4162 _04_ dc_inst.x3.net6 0
C4163 dc_inst.x5.net6 dc_inst.x5.x3/a_27_47# 0.00413f
C4164 dc_inst.x2.x19/a_27_47# dc_inst.x1.net2 0
C4165 dc_inst.net1 dc_inst.x2.net18 0.00328f
C4166 VPWR _13_/a_470_297# -0
C4167 _13_/a_27_297# _02_ 0.00424f
C4168 VPWR _14_/a_439_47# -0
C4169 _15_/a_788_316# path[4] 0.03197f
C4170 path[3] _17_/a_174_21# 0.01068f
C4171 delay_sel[2] dc_inst.x7.x3/a_27_47# 0.0039f
C4172 dc_inst.x4.x9/a_27_47# dc_inst.x5.net7 0.00335f
C4173 dc_inst.x2.net2 dc_inst.x2.x13/a_27_47# 0
C4174 dc_inst.x2.x2/a_27_47# dc_inst.net1 0
C4175 path_sel[1] _08_ 0.00286f
C4176 dc_inst.x5.net19 dc_inst.x7.net8 0.05214f
C4177 dc_inst.x7.net6 dc_inst.x9/a_193_413# 0
C4178 dc_inst.x1.net15 dc_inst.x3.x20/a_27_47# 0
C4179 dc_inst.x2.x2/a_27_47# dc_inst.x2.net2 0.01582f
C4180 dc_inst.x3.net16 dc_inst.x3.x15/a_27_47# 0
C4181 capture_d _23_/a_543_47# 0.01569f
C4182 dc_inst.x5.net5 dc_inst.x5.net10 0
C4183 _17_/a_174_21# _19_/a_27_47# 0
C4184 delay_sel[0] dc_inst.x7.net10 0
C4185 dc_inst.x7.net6 dc_inst.x6.x4/a_27_47# 0.00132f
C4186 se dc_inst.x3.net18 0
C4187 VPWR dc_inst.x2.net13 0.01809f
C4188 dc_inst.x5.net12 dc_inst.x5.x11/a_27_47# 0.00659f
C4189 dc_inst.net4 dc_inst.x6.x13/a_27_47# 0
C4190 _23_/a_1108_47# _01_ 0.02042f
C4191 VPWR _24_/a_1270_413# -0
C4192 dc_inst.x7.x11/a_27_47# dc_inst.x7.net12 0
C4193 _14_/a_76_199# dc_inst.x3.net7 0
C4194 VPWR dc_inst.x3.net4 0.00211f
C4195 dc_inst.x8/a_1478_413# _23_/a_1283_21# 0
C4196 clknet_0_clk _23_/a_27_47# 0
C4197 tdo dc_inst.x4.net17 0
C4198 VPWR dc_inst.x4.net7 0.32286f
C4199 dc_inst.x1.net16 dc_inst.x1.x17/a_27_47# 0.05296f
C4200 dc_inst.x2.net1 dc_inst.x1.x14/a_27_47# 0
C4201 dc_inst.x8/a_834_97# dc_inst.x7.net4 0.0046f
C4202 dc_inst.x1.x12/a_27_47# path_sel[2] 0
C4203 dc_inst.x5.net12 dc_inst.x2.net8 0
C4204 _16_/a_27_93# path[2] 0.00562f
C4205 dc_inst.x4.x2/a_27_47# dc_inst.x4.net4 0.04972f
C4206 dc_inst.x1.net4 dc_inst.x3.net7 0
C4207 dc_inst.x5.net18 dc_inst.x7.net10 0
C4208 dc_inst.x9/a_247_21# dc_inst.x9/a_668_97# 0
C4209 dc_inst.net4 dc_inst.x6.net5 0.03609f
C4210 dc_inst.x5.x5/a_27_47# dc_inst.x5.net4 0
C4211 VPWR dc_inst.x7.x19/a_27_47# -0.00961f
C4212 dc_inst.x4.x15/a_27_47# dc_inst.x6.net1 0
C4213 dc_inst.x5.x16/a_27_47# path_sel[2] 0
C4214 _20_/a_79_21# dc_inst.x1.net7 0
C4215 _23_/a_1108_47# _02_ 0
C4216 dc_inst.net4 dc_inst.x7.net9 0
C4217 dc_inst.x1.x7/a_27_47# _08_ 0
C4218 VPWR dc_inst.x5.net6 0.69274f
C4219 _24_/a_761_289# path[6] 0
C4220 dc_inst.net5 dc_inst.x6.net2 0
C4221 dc_inst.x5.x6/a_27_47# dc_inst.x6.net11 0.00165f
C4222 _13_/a_470_297# dc_inst.x3.x5/a_27_47# 0
C4223 dc_inst.x4.net9 dc_inst.x4.x11/a_27_47# 0.00723f
C4224 _13_/a_470_297# path[5] 0.00129f
C4225 dc_inst.x1.x16/a_27_47# dc_inst.x2.x4/a_27_47# 0
C4226 dc_inst.x4.net3 dc_inst.x4.x4/a_27_47# 0.00221f
C4227 dc_inst.net4 dc_inst.x9/a_750_97# 0.02818f
C4228 _14_/a_439_47# path[5] 0
C4229 dc_inst.x4.net2 dc_inst.net2 0
C4230 tdo capture_d 0.09908f
C4231 dc_inst.x4.x10/a_27_47# dc_inst.x2.net7 0.00511f
C4232 dc_inst.x6.net2 path_sel[2] 0.06325f
C4233 se dc_inst.x3.net7 0
C4234 dc_inst.x3.x3/a_27_47# dc_inst.x3.net3 0.01688f
C4235 delay_sel[0] dc_inst.x6.x5/a_27_47# 0
C4236 dc_inst.x6.x18/a_27_47# delay_sel[0] 0
C4237 dc_inst.x4.net9 dc_inst.x2.net6 0
C4238 dc_inst.x1.net1 dc_inst.x1.net12 0
C4239 dc_inst.x7.net1 dc_inst.x7.net10 0.02482f
C4240 dc_inst.x4.net16 dc_inst.x2.net7 0.00178f
C4241 dc_inst.x8/a_27_47# tdo 0.0025f
C4242 dc_inst.x1.net13 dc_inst.x1.x13/a_27_47# 0.015f
C4243 dc_inst.x3.net8 dc_inst.x3.net9 0
C4244 dc_inst.x3.x20/a_27_47# dc_inst.net2 0.00281f
C4245 dc_inst.x10/a_76_199# _24_/a_27_47# 0
C4246 dc_inst.x5.net9 dc_inst.x5.net10 0.16917f
C4247 _10_ dc_inst.x3.x6/a_27_47# 0
C4248 dc_inst.x3.net14 dc_inst.x3.net6 0.13667f
C4249 dc_inst.x4.net3 dc_inst.x2.x16/a_27_47# 0
C4250 dc_inst.x2.net11 dc_inst.x2.net16 0
C4251 dc_inst.x2.net17 dc_inst.x1.net2 0
C4252 dc_inst.x5.net2 dc_inst.x6.net9 0
C4253 dc_inst.x4.x17/a_27_47# dc_inst.x7.net2 0
C4254 dc_inst.x3.x15/a_27_47# path[6] 0.02093f
C4255 dc_inst.x4.x3/a_27_47# dc_inst.x2.net18 0.03673f
C4256 dc_inst.x6.net12 dc_inst.x4.net8 0
C4257 dc_inst.x1.x2/a_27_47# dc_inst.x1.net1 0.00122f
C4258 _03_ _25_/a_1462_47# 0
C4259 dc_inst.x4.x20/a_27_47# path_sel[2] 0.00326f
C4260 dc_inst.x4.net14 dc_inst.x5.x8/a_27_47# 0
C4261 dc_inst.x4.net3 dc_inst.x1.net15 0
C4262 dc_inst.x9/a_834_97# dc_inst.x7.net13 0
C4263 dc_inst.x2.net8 dc_inst.x2.x8/a_27_47# 0.12504f
C4264 path_sel[2] dc_inst.x8/a_277_47# 0
C4265 dc_inst.x6.x14/a_27_47# dc_inst.x6.net19 0
C4266 dc_inst.x6.x1/a_27_47# dc_inst.net5 0.00956f
C4267 _15_/a_872_316# dc_inst.x3.x7/a_27_47# 0
C4268 dc_inst.x7.net4 _03_ 0
C4269 _16_/a_27_93# dc_inst.x5.net10 0
C4270 path_sel[1] dc_inst.x4.x15/a_27_47# 0.00482f
C4271 dc_inst.x5.net6 dc_inst.x6.net6 0
C4272 dc_inst.x3.net1 path[6] 0.00385f
C4273 dc_inst.x3.net10 path[7] 0
C4274 dc_inst.x3.net19 capture_q 0
C4275 dc_inst.x2.net15 dc_inst.x2.net19 0
C4276 dc_inst.x1.x20/a_27_47# dc_inst.in 0
C4277 dc_inst.x1.net7 dc_inst.x5.x11/a_27_47# 0
C4278 dc_inst.x7.x1/a_27_47# dc_inst.x9/a_757_363# 0
C4279 dc_inst.x1.net8 path_sel[2] 0.04512f
C4280 dc_inst.x3.x16/a_27_47# dc_inst.x3.x3/a_27_47# 0
C4281 dc_inst.x3.net17 dc_inst.x3.x15/a_27_47# 0
C4282 dc_inst.x4.net9 dc_inst.x2.net12 0
C4283 dc_inst.x6.net10 dc_inst.x5.x6/a_27_47# 0.01301f
C4284 dc_inst.x4.x1/a_27_47# dc_inst.x1.net2 0
C4285 _04_ dc_inst.x1.net5 0.06555f
C4286 VPWR dc_inst.net5 0.32552f
C4287 path_sel[1] dc_inst.in 0.0228f
C4288 dc_inst.x4.x20/a_27_47# dc_inst.x6.x7/a_27_47# 0.03129f
C4289 dc_inst.x6.x1/a_27_47# path_sel[2] 0.00583f
C4290 dc_inst.x1.x13/a_27_47# dc_inst.x5.x12/a_27_47# 0
C4291 dc_inst.net4 dc_inst.x6.net7 0
C4292 _23_/a_193_47# _01_ 0.00841f
C4293 dc_inst.net3 dc_inst.x2.net18 0.11773f
C4294 _16_/a_229_47# path_sel[0] 0.02224f
C4295 dc_inst.x4.net4 dc_inst.x6.x15/a_27_47# 0
C4296 dc_inst.x3.x14/a_27_47# path_sel[0] 0
C4297 dc_inst.x6.x12/a_27_47# dc_inst.x6.net5 0.00124f
C4298 dc_inst.x7.net10 dc_inst.x7.net18 0
C4299 dc_inst.x2.x12/a_27_47# path_sel[0] 0
C4300 dc_inst.x7.x17/a_27_47# rst 0
C4301 dc_inst.x3.net1 dc_inst.x3.net17 0
C4302 dc_inst.x7.net19 _25_/a_1108_47# 0
C4303 VPWR path_sel[2] 1.09194f
C4304 dc_inst.x6.net11 dc_inst.x6.net2 0.00264f
C4305 dc_inst.x3.net16 _23_/a_1108_47# 0
C4306 dc_inst.x1.net4 dc_inst.x1.net9 0.0021f
C4307 dc_inst.x9/a_668_97# _25_/a_543_47# 0
C4308 dc_inst.x1.net14 dc_inst.x1.x9/a_27_47# 0
C4309 dc_inst.x3.net14 _04_ 0
C4310 dc_inst.x6.x9/a_27_47# dc_inst.x6.net2 0
C4311 dc_inst.x6.x12/a_27_47# dc_inst.x9/a_750_97# 0
C4312 dc_inst.net6 dc_inst.x6.net2 0.1245f
C4313 dc_inst.x3.net1 dc_inst.x3.x9/a_27_47# 0.00293f
C4314 shadow_q dc_inst.x3.net3 0
C4315 _23_/a_193_47# _02_ 0
C4316 VPWR dc_inst.x6.x7/a_27_47# 0.02279f
C4317 _15_/a_372_413# dc_inst.x1.net3 0.00127f
C4318 _23_/a_1108_47# dc_inst.in 0
C4319 dc_inst.x7.net4 dc_inst.x6.net2 0
C4320 dc_inst.x5.net12 path[2] 0
C4321 tdo _25_/a_761_289# 0
C4322 path_sel[0] path[7] 0.28433f
C4323 dc_inst.x8/a_834_97# dc_inst.x4.x3/a_27_47# 0
C4324 dc_inst.net4 dc_inst.x9/a_277_47# 0.07913f
C4325 dc_inst.x2.net5 dc_inst.x2.net10 0
C4326 dc_inst.x1.x7/a_27_47# dc_inst.in 0
C4327 _13_/a_27_297# path[6] 0.0075f
C4328 path[4] dc_inst.net8 0
C4329 dc_inst.x6.x13/a_27_47# dc_inst.x4.x11/a_27_47# 0
C4330 dc_inst.x8/a_750_97# dc_inst.x2.net16 0
C4331 dc_inst.x4.net9 dc_inst.x4.net7 0
C4332 _13_/a_27_297# _24_/a_1283_21# 0
C4333 _13_/a_112_47# _24_/a_1108_47# 0
C4334 dc_inst.x7.net3 capture_d 0.03558f
C4335 dc_inst.x4.net5 dc_inst.x2.x18/a_27_47# 0
C4336 dc_inst.x4.net3 dc_inst.net2 0
C4337 dc_inst.x3.net5 _01_ 0
C4338 dc_inst.x5.net7 dc_inst.x6.net19 0
C4339 dc_inst.x3.net1 _05_ 0
C4340 dc_inst.net2 _23_/a_1283_21# 0.01304f
C4341 dc_inst.x7.x20/a_27_47# dc_inst.x7.x2/a_27_47# 0.02448f
C4342 dc_inst.x6.net6 dc_inst.net5 0
C4343 dc_inst.x2.x16/a_27_47# dc_inst.x2.net15 0.03309f
C4344 dc_inst.x8/a_750_97# dc_inst.x3.net3 0
C4345 dc_inst.x1.x3/a_27_47# dc_inst.x3.x2/a_27_47# 0
C4346 dc_inst.x6.net8 dc_inst.x6.net7 0.00418f
C4347 dc_inst.x4.x19/a_27_47# dc_inst.x6.net9 0
C4348 path_sel[1] dc_inst.x2.x5/a_27_47# 0
C4349 dc_inst.x1.net4 dc_inst.x1.net3 0.06563f
C4350 path_sel[1] path[6] 0.06396f
C4351 dc_inst.x1.x14/a_27_47# dc_inst.x1.net19 0
C4352 dc_inst.x3.net2 _01_ 0.00127f
C4353 dc_inst.x4.net9 dc_inst.x5.net6 0
C4354 dc_inst.x1.x10/a_27_47# dc_inst.x1.net2 0
C4355 dc_inst.x5.net17 dc_inst.x6.x8/a_27_47# 0
C4356 dc_inst.x8/a_1290_413# dc_inst.x3.net2 0.00282f
C4357 dc_inst.x8/a_834_97# dc_inst.net3 0.00515f
C4358 dc_inst.x5.net3 dc_inst.x4.net12 0
C4359 dc_inst.x6.x1/a_27_47# dc_inst.x6.net11 0.01149f
C4360 dc_inst.x5.net3 dc_inst.x2.x7/a_27_47# 0
C4361 dc_inst.x6.net6 path_sel[2] 0.01359f
C4362 dc_inst.x7.net4 dc_inst.x8/a_277_47# 0.02539f
C4363 dc_inst.x2.net14 path[2] 0
C4364 dc_inst.x1.net15 dc_inst.x2.net15 0.11039f
C4365 dc_inst.x3.x16/a_27_47# shadow_q 0.03509f
C4366 dc_inst.x3.x10/a_27_47# dc_inst.x3.net11 0.01938f
C4367 dc_inst.x2.x9/a_27_47# dc_inst.x2.net15 0
C4368 dc_inst.net6 dc_inst.x6.x1/a_27_47# 0.03087f
C4369 dc_inst.x3.net5 _02_ 0
C4370 dc_inst.x6.net17 dc_inst.x7.net7 0
C4371 dc_inst.x4.net2 dc_inst.x6.x18/a_27_47# 0
C4372 dc_inst.x3.net14 dc_inst.x3.x19/a_27_47# 0
C4373 path_sel[1] dc_inst.x3.net17 0
C4374 VPWR dc_inst.x6.net11 0.01358f
C4375 _10_ dc_inst.x1.x5/a_27_47# 0.00482f
C4376 dc_inst.x3.net2 _02_ 0
C4377 dc_inst.x4.x11/a_27_47# dc_inst.x4.x14/a_27_47# 0.01224f
C4378 dc_inst.x1.net8 dc_inst.x1.net17 0
C4379 dc_inst.x7.net4 dc_inst.x6.x1/a_27_47# 0
C4380 _15_/a_27_47# _06_ 0.00619f
C4381 path_sel[1] dc_inst.x4.x13/a_27_47# 0.01316f
C4382 _23_/a_805_47# capture_d 0
C4383 dc_inst.x6.net6 dc_inst.x6.x7/a_27_47# 0.00336f
C4384 dc_inst.x3.net15 dc_inst.x3.x7/a_27_47# 0
C4385 VPWR dc_inst.net6 0.13831f
C4386 dc_inst.x6.x9/a_27_47# VPWR 0.00645f
C4387 VPWR _25_/a_1462_47# 0
C4388 dc_inst.x5.x13/a_27_47# dc_inst.x5.x14/a_27_47# 0.02448f
C4389 _23_/a_1108_47# path[6] 0
C4390 dc_inst.x9/a_1478_413# dc_inst.net9 0.00163f
C4391 _24_/a_193_47# _00_ 0.54768f
C4392 dc_inst.net1 dc_inst.x8/a_277_47# 0.00166f
C4393 dc_inst.x7.x20/a_27_47# dc_inst.x9/a_1290_413# 0.00361f
C4394 dc_inst.x4.net12 dc_inst.x4.net10 0.00791f
C4395 _24_/a_1108_47# _23_/a_1283_21# 0.00515f
C4396 _24_/a_1283_21# _23_/a_1108_47# 0.00363f
C4397 delay_sel[0] _24_/a_27_47# 0
C4398 dc_inst.x4.net10 dc_inst.x2.x7/a_27_47# 0.00164f
C4399 dc_inst.x7.net4 VPWR 1.74164f
C4400 dc_inst.x4.net19 dc_inst.x5.x17/a_27_47# 0
C4401 dc_inst.x3.x1/a_27_47# dc_inst.x3.net3 0
C4402 dc_inst.x5.net12 dc_inst.x5.net10 0.02632f
C4403 dc_inst.x2.net11 dc_inst.x2.net7 0
C4404 dc_inst.x4.net2 _15_/a_193_47# 0
C4405 path_sel[1] dc_inst.x1.net12 0.02839f
C4406 dc_inst.x1.x7/a_27_47# path[6] 0
C4407 VPWR dc_inst.x1.net17 0.23121f
C4408 dc_inst.x8/a_668_97# _23_/a_543_47# 0
C4409 _13_/a_470_47# _24_/a_27_47# 0
C4410 path_sel[0] dc_inst.x1.x1/a_27_47# 0.0322f
C4411 dc_inst.x2.net11 dc_inst.x2.net10 0.22941f
C4412 dc_inst.x1.net7 dc_inst.x1.net6 0.08005f
C4413 dc_inst.x7.net14 dc_inst.x7.net10 0
C4414 _05_ _13_/a_27_297# 0
C4415 dc_inst.x6.net10 dc_inst.x4.x20/a_27_47# 0
C4416 clkbuf_1_0__f_clk/a_110_47# dc_inst.x7.x19/a_27_47# 0.01024f
C4417 dc_inst.x1.x4/a_27_47# _06_ 0
C4418 _15_/a_872_316# dc_inst.x1.x5/a_27_47# 0
C4419 _14_/a_76_199# _13_/a_470_297# 0
C4420 dc_inst.x3.net16 _23_/a_193_47# 0
C4421 path[2] _17_/a_27_93# 0.00611f
C4422 dc_inst.x1.net13 dc_inst.x2.x13/a_27_47# 0
C4423 dc_inst.x7.x17/a_27_47# dc_inst.net7 0
C4424 VPWR dc_inst.net1 0.55524f
C4425 dc_inst.x5.net9 dc_inst.x2.net15 0
C4426 dc_inst.x1.net7 path[2] 0
C4427 dc_inst.x7.net16 dc_inst.x10/a_439_47# 0
C4428 dc_inst.x6.net10 dc_inst.x6.x1/a_27_47# 0
C4429 dc_inst.x4.x4/a_27_47# dc_inst.x6.net15 0
C4430 _10_ path_sel[0] 0.08546f
C4431 path_sel[1] dc_inst.x1.x2/a_27_47# 0.0034f
C4432 _23_/a_193_47# dc_inst.in 0.09912f
C4433 path_sel[1] dc_inst.x5.x1/a_27_47# 0.01196f
C4434 dc_inst.x6.net18 dc_inst.x6.net19 0.01452f
C4435 VPWR dc_inst.x2.net2 0.20739f
C4436 dc_inst.x7.net5 dc_inst.x6.net2 0
C4437 path_sel[1] dc_inst.x5.x14/a_27_47# 0.00509f
C4438 dc_inst.x2.net14 dc_inst.x5.net10 0
C4439 dc_inst.x6.net6 dc_inst.x6.net11 0.00118f
C4440 dc_inst.x4.x11/a_27_47# dc_inst.x6.net7 0
C4441 VPWR dc_inst.x6.net10 0.3752f
C4442 dc_inst.x4.net18 dc_inst.x6.net7 0
C4443 dc_inst.x5.net11 dc_inst.x5.x11/a_27_47# 0.00377f
C4444 dc_inst.x4.net9 path_sel[2] 0.00137f
C4445 VPWR dc_inst.x5.x9/a_27_47# 0.05231f
C4446 dc_inst.x6.x9/a_27_47# dc_inst.x6.net6 0.01336f
C4447 dc_inst.net6 dc_inst.x6.net6 0
C4448 dc_inst.x1.x7/a_27_47# dc_inst.x1.net12 0
C4449 dc_inst.x9/a_750_97# dc_inst.x9/a_1478_413# -0.00487f
C4450 dc_inst.x5.net16 path_sel[0] 0
C4451 se _13_/a_470_297# 0.00102f
C4452 dc_inst.x1.x15/a_27_47# path_sel[2] 0.00974f
C4453 tdi dc_inst.x3.x18/a_27_47# 0
C4454 dc_inst.x7.net4 dc_inst.x6.net6 0
C4455 dc_inst.x1.net4 dc_inst.x3.net4 0.00146f
C4456 _15_/a_872_316# path_sel[0] -0.00688f
C4457 dc_inst.x4.net19 dc_inst.x4.net17 0.0365f
C4458 dc_inst.x5.x12/a_27_47# dc_inst.x2.x13/a_27_47# 0
C4459 dc_inst.x6.net6 dc_inst.x1.net17 0
C4460 dc_inst.x3.net5 dc_inst.x3.net16 0
C4461 dc_inst.x2.x5/a_27_47# dc_inst.x2.x14/a_27_47# 0.04629f
C4462 path_sel[1] dc_inst.x5.net4 0.00522f
C4463 dc_inst.x5.net6 dc_inst.x6.x13/a_27_47# 0
C4464 dc_inst.x2.net7 dc_inst.x4.x12/a_27_47# 0
C4465 dc_inst.x3.net2 dc_inst.x3.net16 0.07201f
C4466 dc_inst.x4.x1/a_27_47# delay_sel[0] 0.00925f
C4467 path_sel[1] dc_inst.x5.net15 0.04004f
C4468 dc_inst.x2.x20/a_27_47# _15_/a_288_47# 0
C4469 path_sel[1] dc_inst.x2.x4/a_27_47# 0.00643f
C4470 dc_inst.x2.x11/a_27_47# dc_inst.x2.net7 0
C4471 dc_inst.x2.x20/a_27_47# delay_sel[1] 0.00775f
C4472 dc_inst.x7.net2 dc_inst.x6.x16/a_27_47# 0
C4473 _03_ _23_/a_761_289# 0
C4474 path_sel[1] dc_inst.x4.x18/a_27_47# 0.00361f
C4475 dc_inst.x2.x11/a_27_47# dc_inst.x2.net10 0.0448f
C4476 dc_inst.x6.x17/a_27_47# dc_inst.net5 0.00594f
C4477 dc_inst.net1 dc_inst.x6.net6 0
C4478 dc_inst.x4.net2 dc_inst.x2.x19/a_27_47# 0.00142f
C4479 dc_inst.net5 clkbuf_1_0__f_clk/a_110_47# 0.00146f
C4480 path_sel[1] _15_/a_600_345# 0.00569f
C4481 dc_inst.x3.net2 dc_inst.in 0.00405f
C4482 dc_inst.x5.net3 dc_inst.x1.net18 0
C4483 _23_/a_193_47# path[6] 0
C4484 dc_inst.x4.x3/a_27_47# dc_inst.x8/a_277_47# 0
C4485 dc_inst.x6.x17/a_27_47# path_sel[2] 0.00664f
C4486 dc_inst.x6.net10 dc_inst.x6.net6 0.03245f
C4487 VPWR dc_inst.x7.net5 0.01619f
C4488 dc_inst.x10/a_505_21# clknet_0_clk 0
C4489 dc_inst.x1.x6/a_27_47# _10_ 0
C4490 path[1] _17_/a_174_21# 0.00321f
C4491 path_sel[0] _17_/a_574_297# 0.00143f
C4492 dc_inst.x7.x10/a_27_47# dc_inst.x7.x4/a_27_47# 0.08729f
C4493 dc_inst.x5.net6 dc_inst.x4.x14/a_27_47# 0
C4494 path_sel[1] dc_inst.x4.x7/a_27_47# 0.00638f
C4495 dc_inst.x1.net11 dc_inst.x1.x5/a_27_47# 0.03018f
C4496 dc_inst.x5.net5 dc_inst.x5.net7 0
C4497 dc_inst.x8/a_750_97# dc_inst.x8/a_193_413# -0
C4498 dc_inst.x4.net16 dc_inst.x4.x15/a_27_47# 0
C4499 dc_inst.x4.net10 dc_inst.x1.net18 0
C4500 dc_inst.x3.net15 dc_inst.x3.net10 0
C4501 dc_inst.x6.net18 dc_inst.x2.net19 0
C4502 VPWR dc_inst.x4.x3/a_27_47# 0.01464f
C4503 dc_inst.net3 dc_inst.x8/a_277_47# 0.04768f
C4504 dc_inst.x3.x3/a_27_47# _01_ 0
C4505 dc_inst.x3.net12 _02_ 0
C4506 VPWR dc_inst.x4.x8/a_27_47# 0.00602f
C4507 dc_inst.x2.net17 dc_inst.x1.net6 0
C4508 clknet_0_clk rst 0.75023f
C4509 dc_inst.x3.x16/a_27_47# dc_inst.x3.net6 0
C4510 path_sel[1] _17_/a_174_21# 0
C4511 path[0] _17_/a_574_297# 0.0024f
C4512 path_sel[2] dc_inst.net9 0
C4513 dc_inst.x6.net14 dc_inst.x4.x4/a_27_47# 0.00118f
C4514 _15_/a_372_413# path_sel[2] 0
C4515 dc_inst.x1.x3/a_27_47# _20_/a_79_21# 0
C4516 dc_inst.net3 dc_inst.x1.net8 0
C4517 capture_d _24_/a_805_47# 0
C4518 dc_inst.x3.net5 path[6] 0.12873f
C4519 VPWR _20_/a_384_47# -0.00266f
C4520 dc_inst.x6.net12 dc_inst.x6.net19 0
C4521 dc_inst.x4.net19 dc_inst.x5.net17 0
C4522 dc_inst.x2.net9 dc_inst.x5.x3/a_27_47# 0
C4523 dc_inst.x3.x3/a_27_47# _02_ 0
C4524 dc_inst.x5.net7 dc_inst.x2.net3 0.02181f
C4525 dc_inst.x7.x9/a_27_47# dc_inst.x7.net6 0
C4526 dc_inst.x7.x13/a_27_47# dc_inst.x9/a_27_413# 0.01254f
C4527 dc_inst.x3.net2 path[6] 0.0291f
C4528 dc_inst.x7.net16 dc_inst.in 0
C4529 dc_inst.x2.net1 dc_inst.x5.net9 0
C4530 dc_inst.x9/a_1478_413# dc_inst.x9/a_277_47# -0.00848f
C4531 rst clkbuf_0_clk/a_110_47# 0.02343f
C4532 VPWR dc_inst.net3 0.76825f
C4533 VPWR dc_inst.x5.x8/a_27_47# 0.06584f
C4534 dc_inst.x1.net15 dc_inst.x2.x15/a_27_47# 0
C4535 dc_inst.x6.x13/a_27_47# path_sel[2] 0.01189f
C4536 dc_inst.x3.net2 _24_/a_1283_21# 0
C4537 _17_/a_478_47# _18_/a_505_21# 0
C4538 dc_inst.x9/a_1290_413# dc_inst.net8 0
C4539 clknet_0_clk clknet_1_1__leaf_clk 0.22218f
C4540 _13_/a_470_297# delay_sel[2] 0
C4541 dc_inst.x4.net6 dc_inst.net4 0
C4542 _23_/a_193_47# clkload0/a_27_47# 0
C4543 dc_inst.x1.net11 path_sel[0] 0.00231f
C4544 dc_inst.x4.net14 dc_inst.x4.net12 0
C4545 dc_inst.x7.net5 dc_inst.x6.net6 0
C4546 tdi dc_inst.x3.net8 0.00143f
C4547 dc_inst.x2.x1/a_27_47# dc_inst.x5.net7 0
C4548 dc_inst.x1.net10 _07_ 0
C4549 dc_inst.x5.x11/a_27_47# dc_inst.x5.net1 0.02031f
C4550 dc_inst.x1.net4 path_sel[2] 0.00964f
C4551 dc_inst.x3.net5 dc_inst.x3.net17 0.07253f
C4552 delay_sel[1] _00_ 0.00141f
C4553 dc_inst.x6.x3/a_27_47# dc_inst.x9/a_27_413# 0
C4554 VPWR dc_inst.x1.x18/a_27_47# 0.03774f
C4555 dc_inst.x7.net9 dc_inst.net5 0
C4556 _02_ _24_/a_1462_47# 0
C4557 dc_inst.x2.net2 dc_inst.x4.net9 0
C4558 dc_inst.x3.net2 dc_inst.x3.net17 0.00664f
C4559 dc_inst.x6.net5 path_sel[2] 0.02221f
C4560 dc_inst.x9/a_750_97# dc_inst.net5 0
C4561 dc_inst.net6 dc_inst.x6.x17/a_27_47# 0
C4562 clknet_1_1__leaf_clk clkbuf_0_clk/a_110_47# 0
C4563 dc_inst.x5.net7 dc_inst.x5.net9 0.04202f
C4564 dc_inst.x5.net11 path[2] 0
C4565 dc_inst.x4.net2 dc_inst.x2.net17 0.00393f
C4566 dc_inst.x1.net9 dc_inst.x1.net16 0.00426f
C4567 VPWR _18_/a_505_21# 0.11143f
C4568 dc_inst.x7.net9 path_sel[2] 0.00552f
C4569 dc_inst.x5.net4 dc_inst.x2.x14/a_27_47# 0
C4570 dc_inst.x7.net4 dc_inst.x6.x17/a_27_47# 0
C4571 clknet_1_0__leaf_clk delay_sel[1] 0.02463f
C4572 delay_sel[2] _24_/a_1270_413# 0
C4573 dc_inst.x9/a_750_97# path_sel[2] 0.0012f
C4574 dc_inst.x4.net4 dc_inst.x1.net9 0
C4575 dc_inst.x7.net4 clkbuf_1_0__f_clk/a_110_47# 0
C4576 dc_inst.x10/a_76_199# capture_d 0.01955f
C4577 dc_inst.x3.net4 delay_sel[2] 0
C4578 dc_inst.x7.x15/a_27_47# rst 0
C4579 dc_inst.x4.net3 dc_inst.x2.x19/a_27_47# 0
C4580 dc_inst.x5.x14/a_27_47# dc_inst.x5.net19 0
C4581 VPWR _23_/a_761_289# 0.0219f
C4582 _13_/a_112_47# _24_/a_27_47# 0
C4583 path_sel[1] dc_inst.x4.net8 0.00666f
C4584 dc_inst.x9/a_247_21# dc_inst.x7.net15 0
C4585 dc_inst.x1.x13/a_27_47# dc_inst.x1.x9/a_27_47# 0.01018f
C4586 dc_inst.x2.x19/a_27_47# _23_/a_1283_21# 0
C4587 dc_inst.x10/a_218_374# _01_ 0
C4588 dc_inst.x3.x19/a_27_47# dc_inst.x3.net3 0
C4589 VPWR dc_inst.x2.net9 0.03041f
C4590 shadow_q _01_ 0.00259f
C4591 dc_inst.x2.net1 dc_inst.x2.x10/a_27_47# 0.04368f
C4592 dc_inst.x4.x4/a_27_47# dc_inst.x1.net19 0
C4593 dc_inst.x4.x1/a_27_47# dc_inst.x4.net2 0.00325f
C4594 dc_inst.x8/a_27_47# dc_inst.x10/a_76_199# 0
C4595 _20_/a_470_297# path[4] 0.00114f
C4596 dc_inst.x5.net9 dc_inst.x2.x15/a_27_47# 0
C4597 dc_inst.x2.net14 dc_inst.x2.net15 0.00682f
C4598 dc_inst.x8/a_1290_413# shadow_q 0
C4599 dc_inst.x3.net5 _05_ 0
C4600 tdo dc_inst.x8/a_247_21# 0
C4601 dc_inst.x5.net8 dc_inst.x2.net7 0
C4602 dc_inst.x3.net8 rst 0
C4603 dc_inst.net6 dc_inst.net9 0
C4604 path_sel[1] dc_inst.x6.x6/a_27_47# 0.01154f
C4605 dc_inst.x4.net5 dc_inst.x2.net8 0
C4606 dc_inst.x3.net12 dc_inst.x3.net16 0
C4607 dc_inst.x4.net11 path_sel[0] 0
C4608 dc_inst.x1.net14 path_sel[0] 0.00102f
C4609 dc_inst.x7.net4 dc_inst.net9 0.00513f
C4610 dc_inst.x4.x6/a_27_47# dc_inst.x6.x16/a_27_47# 0
C4611 dc_inst.x7.x8/a_27_47# dc_inst.x6.net3 0
C4612 dc_inst.x6.net11 dc_inst.x6.x13/a_27_47# 0.00135f
C4613 VPWR dc_inst.x9/a_668_97# 0
C4614 dc_inst.x6.net6 dc_inst.x1.x18/a_27_47# 0
C4615 dc_inst.x2.net6 dc_inst.x1.net16 0.00272f
C4616 shadow_q _02_ 0.21563f
C4617 dc_inst.x3.net15 _23_/a_543_47# 0
C4618 _14_/a_218_374# _00_ 0
C4619 dc_inst.x7.net2 dc_inst.x6.net13 0
C4620 dc_inst.x6.x3/a_27_47# dc_inst.x6.x4/a_27_47# 0
C4621 dc_inst.x7.x19/a_27_47# dc_inst.x7.net17 0
C4622 dc_inst.x5.net19 dc_inst.x5.net15 0
C4623 dc_inst.x8/a_750_97# _01_ 0
C4624 dc_inst.x2.x16/a_27_47# dc_inst.x1.net19 0
C4625 dc_inst.x3.net14 dc_inst.x3.net3 0.00405f
C4626 dc_inst.x4.net4 dc_inst.x2.net6 0
C4627 dc_inst.x1.x6/a_27_47# dc_inst.x1.net11 0.03045f
C4628 dc_inst.x3.net16 dc_inst.x3.x3/a_27_47# 0.00372f
C4629 dc_inst.x8/a_750_97# dc_inst.x8/a_1290_413# -0.00475f
C4630 delay_sel[0] dc_inst.x4.net5 0
C4631 dc_inst.x1.net10 _09_ 0
C4632 dc_inst.x1.x10/a_27_47# path[2] 0
C4633 dc_inst.x8/a_27_413# dc_inst.in 0.01008f
C4634 dc_inst.x4.x16/a_27_47# path_sel[1] 0.00441f
C4635 dc_inst.x6.net5 dc_inst.x6.net11 0.04375f
C4636 _24_/a_193_47# _23_/a_543_47# 0
C4637 _24_/a_27_47# _23_/a_1283_21# 0.00302f
C4638 dc_inst.net7 clknet_0_clk 0.00615f
C4639 dc_inst.net1 dc_inst.net9 0.05897f
C4640 dc_inst.x6.x13/a_27_47# dc_inst.x1.net17 0
C4641 dc_inst.x3.x2/a_27_47# path[7] 0
C4642 dc_inst.x1.net15 dc_inst.x1.net19 0.02896f
C4643 dc_inst.net6 dc_inst.x6.net5 0.01048f
C4644 dc_inst.x6.x9/a_27_47# dc_inst.x6.net5 0
C4645 VPWR dc_inst.x10/a_535_374# 0.00112f
C4646 dc_inst.x9/a_1478_413# _25_/a_1283_21# 0
C4647 dc_inst.x6.net7 path_sel[2] 0.00152f
C4648 dc_inst.x1.net13 dc_inst.x1.net8 0.02218f
C4649 dc_inst.x3.x12/a_27_47# _20_/a_384_47# 0
C4650 dc_inst.x9/a_750_97# dc_inst.x6.net11 0
C4651 dc_inst.x1.net7 dc_inst.x2.net15 0
C4652 dc_inst.x7.x13/a_27_47# dc_inst.x7.net13 0.01486f
C4653 dc_inst.net6 dc_inst.x7.net9 0
C4654 dc_inst.x7.net4 dc_inst.x6.net5 0
C4655 dc_inst.x4.net9 dc_inst.x4.x8/a_27_47# 0.00325f
C4656 dc_inst.x7.x6/a_27_47# dc_inst.x7.net10 0
C4657 dc_inst.net7 clkbuf_0_clk/a_110_47# 0
C4658 dc_inst.x5.x17/a_27_47# dc_inst.x5.net18 0
C4659 dc_inst.net6 dc_inst.x9/a_750_97# 0.0899f
C4660 dc_inst.x7.net4 dc_inst.x7.net9 0
C4661 dc_inst.x6.x7/a_27_47# dc_inst.x6.net7 0.01976f
C4662 dc_inst.x6.net18 dc_inst.net2 0
C4663 clk _25_/a_448_47# 0
C4664 dc_inst.x2.net3 dc_inst.x1.net19 0
C4665 delay_sel[0] dc_inst.x9/a_27_413# 0.04291f
C4666 dc_inst.x7.net12 clk 0
C4667 dc_inst.x4.net3 dc_inst.x6.x16/a_27_47# 0
C4668 dc_inst.x1.net13 VPWR -0
C4669 dc_inst.x9/a_277_47# dc_inst.net5 -0
C4670 clknet_0_clk _23_/a_651_413# 0
C4671 dc_inst.x1.net10 dc_inst.x1.x17/a_27_47# 0
C4672 dc_inst.x3.x1/a_27_47# _01_ 0.00297f
C4673 dc_inst.x2.net5 dc_inst.x2.x5/a_27_47# 0.05029f
C4674 dc_inst.x3.net19 dc_inst.x8/a_277_47# 0
C4675 dc_inst.x7.net2 dc_inst.x4.net5 0
C4676 dc_inst.x8/a_1290_413# dc_inst.x3.x1/a_27_47# 0.00209f
C4677 dc_inst.x2.net15 dc_inst.x2.x19/a_27_47# 0
C4678 dc_inst.x4.net3 dc_inst.x2.net17 0.00676f
C4679 dc_inst.x2.x1/a_27_47# dc_inst.x1.net19 0.0013f
C4680 dc_inst.net4 dc_inst.x9/a_27_47# 0
C4681 dc_inst.x8/a_27_413# dc_inst.x6.net17 0
C4682 _24_/a_193_47# tdo 0.00235f
C4683 path_sel[1] dc_inst.x4.x9/a_27_47# 0.01052f
C4684 dc_inst.x9/a_277_47# path_sel[2] 0
C4685 dc_inst.x7.net5 clkbuf_1_0__f_clk/a_110_47# 0
C4686 dc_inst.x3.net12 path[6] 0
C4687 dc_inst.x3.net11 path[7] 0.03057f
C4688 dc_inst.x2.net1 dc_inst.x5.net12 0.02738f
C4689 dc_inst.x4.net6 dc_inst.x4.x11/a_27_47# 0
C4690 dc_inst.x7.x17/a_27_47# dc_inst.x7.x16/a_27_47# 0
C4691 clkbuf_1_1__f_clk/a_110_47# _13_/a_112_47# 0.00112f
C4692 dc_inst.x5.x12/a_27_47# dc_inst.x1.net8 0
C4693 dc_inst.net1 dc_inst.x9/a_750_97# 0
C4694 dc_inst.x6.net17 dc_inst.x4.x5/a_27_47# 0
C4695 dc_inst.net5 dc_inst.x7.net17 0
C4696 dc_inst.x3.x1/a_27_47# _02_ 0
C4697 dc_inst.net7 dc_inst.x7.x15/a_27_47# 0
C4698 capture_q _00_ 0.0384f
C4699 VPWR dc_inst.x3.net19 0.0214f
C4700 dc_inst.x3.net1 _15_/a_27_47# 0
C4701 dc_inst.x4.x17/a_27_47# dc_inst.x5.net7 0.00757f
C4702 dc_inst.x2.x2/a_27_47# dc_inst.x1.net18 0
C4703 dc_inst.x1.net15 dc_inst.x6.net12 0.00219f
C4704 dc_inst.x3.x3/a_27_47# path[6] 0.00791f
C4705 dc_inst.x4.net3 dc_inst.x4.x1/a_27_47# 0
C4706 dc_inst.x3.net12 dc_inst.x3.net17 0
C4707 dc_inst.x3.net16 shadow_q 0.06733f
C4708 dc_inst.x4.net16 dc_inst.x4.x18/a_27_47# 0
C4709 dc_inst.x3.net7 dc_inst.x3.x13/a_27_47# 0.01633f
C4710 dc_inst.x5.net12 dc_inst.x5.net7 0
C4711 VPWR dc_inst.x5.x12/a_27_47# 0.00741f
C4712 dc_inst.x7.net12 _25_/a_1108_47# 0
C4713 dc_inst.x7.net3 dc_inst.x8/a_247_21# 0
C4714 tdo dc_inst.x4.net11 0.00174f
C4715 dc_inst.x6.net2 dc_inst.x6.net3 0.01963f
C4716 dc_inst.x10/a_218_374# dc_inst.in 0
C4717 delay_sel[0] dc_inst.x9/a_193_413# 0.02625f
C4718 dc_inst.x7.net1 dc_inst.x9/a_27_413# 0.00337f
C4719 _24_/a_761_289# clknet_0_clk 0.00325f
C4720 dc_inst.x3.net12 dc_inst.x3.x9/a_27_47# 0.04418f
C4721 shadow_q dc_inst.in 0
C4722 dc_inst.x7.x1/a_27_47# dc_inst.x6.net2 0.03899f
C4723 dc_inst.x6.x9/a_27_47# dc_inst.x6.net7 0.0017f
C4724 _10_ dc_inst.x2.x18/a_27_47# 0
C4725 dc_inst.x3.net17 dc_inst.x3.x3/a_27_47# 0.1581f
C4726 delay_sel[0] dc_inst.x6.x4/a_27_47# 0
C4727 clknet_1_1__leaf_clk _25_/a_193_47# 0
C4728 dc_inst.x5.net6 dc_inst.x1.net16 0
C4729 dc_inst.x9/a_247_21# clknet_1_0__leaf_clk 0
C4730 shadow_q _23_/a_639_47# 0
C4731 _24_/a_27_47# _23_/a_27_47# 0
C4732 dc_inst.x8/a_750_97# dc_inst.x3.net16 0
C4733 path_sel[1] dc_inst.x1.x14/a_27_47# 0
C4734 dc_inst.x4.net16 dc_inst.x4.x7/a_27_47# 0
C4735 clkbuf_1_1__f_clk/a_110_47# _23_/a_1283_21# 0.00222f
C4736 dc_inst.x4.net4 dc_inst.x5.net6 0
C4737 dc_inst.x10/a_505_21# dc_inst.net2 0
C4738 dc_inst.x1.net2 path[7] 0.0178f
C4739 _16_/a_27_93# path[3] 0
C4740 dc_inst.x10/a_218_47# dc_inst.in 0.00162f
C4741 _15_/a_288_47# path_sel[0] -0.00951f
C4742 dc_inst.x2.net14 dc_inst.x5.net7 0.0018f
C4743 dc_inst.x5.net12 dc_inst.x1.x11/a_27_47# 0
C4744 _15_/a_1064_47# path[7] 0.00165f
C4745 capture_d _23_/a_448_47# 0.01304f
C4746 dc_inst.x8/a_750_97# dc_inst.in 0
C4747 dc_inst.x5.net1 dc_inst.x5.net10 0.23149f
C4748 dc_inst.x5.net8 dc_inst.x2.x6/a_27_47# 0
C4749 dc_inst.x4.net2 dc_inst.x4.net5 0.02578f
C4750 dc_inst.net6 dc_inst.x9/a_277_47# 0.03243f
C4751 dc_inst.x3.net19 path[5] 0.04528f
C4752 _23_/a_1270_413# _01_ 0
C4753 dc_inst.x4.x8/a_27_47# dc_inst.x6.x13/a_27_47# 0
C4754 dc_inst.x6.net16 dc_inst.x7.net8 0
C4755 dc_inst.x1.net4 dc_inst.x4.x3/a_27_47# 0
C4756 dc_inst.x7.net2 capture_d 0
C4757 dc_inst.net3 dc_inst.net9 0
C4758 dc_inst.x5.x5/a_27_47# dc_inst.x5.net5 0.01513f
C4759 dc_inst.x1.net10 _18_/a_76_199# 0
C4760 dc_inst.x7.net4 dc_inst.x9/a_277_47# 0
C4761 dc_inst.net2 rst 0
C4762 dc_inst.x1.x16/a_27_47# dc_inst.x2.x16/a_27_47# 0
C4763 dc_inst.x2.net17 dc_inst.x2.net15 0.00365f
C4764 dc_inst.x9/a_193_413# dc_inst.x7.net1 0.00847f
C4765 dc_inst.x9/a_750_97# dc_inst.x7.net5 0
C4766 dc_inst.x3.x10/a_27_47# dc_inst.x3.net13 0.0065f
C4767 path_sel[1] _15_/a_27_47# 0.0013f
C4768 dc_inst.x2.net1 _17_/a_27_93# 0
C4769 dc_inst.x3.net6 _02_ 0.00481f
C4770 dc_inst.x7.x1/a_27_47# dc_inst.x6.x1/a_27_47# 0.02448f
C4771 dc_inst.x6.net14 dc_inst.x6.x5/a_27_47# 0
C4772 dc_inst.x6.net14 dc_inst.x6.x18/a_27_47# 0.01273f
C4773 dc_inst.x7.net4 delay_sel[2] 0.0111f
C4774 dc_inst.x5.net7 dc_inst.x2.x8/a_27_47# 0
C4775 delay_sel[0] dc_inst.x7.net13 0.03281f
C4776 dc_inst.x2.net14 dc_inst.x2.x15/a_27_47# 0.02031f
C4777 dc_inst.x2.x20/a_27_47# dc_inst.x2.net18 0.04326f
C4778 dc_inst.x2.net5 dc_inst.x5.net4 0
C4779 VPWR dc_inst.x6.net3 0.12498f
C4780 shadow_q path[6] 0.10742f
C4781 dc_inst.x3.net16 dc_inst.x3.x1/a_27_47# 0.03591f
C4782 dc_inst.x2.net14 dc_inst.x1.x11/a_27_47# 0
C4783 dc_inst.x2.net5 dc_inst.x2.x4/a_27_47# 0.01506f
C4784 dc_inst.x1.x16/a_27_47# dc_inst.x1.net15 0.05244f
C4785 dc_inst.net6 dc_inst.x7.net17 0.00809f
C4786 _24_/a_1283_21# shadow_q 0.00395f
C4787 VPWR dc_inst.x7.x1/a_27_47# 0.01415f
C4788 _24_/a_193_47# dc_inst.x7.net3 0
C4789 _20_/a_79_21# dc_inst.x3.x14/a_27_47# 0
C4790 _09_ _18_/a_535_374# 0
C4791 dc_inst.net1 dc_inst.x9/a_277_47# 0
C4792 dc_inst.x1.net4 dc_inst.net3 0.02949f
C4793 dc_inst.net2 clknet_1_1__leaf_clk 0
C4794 dc_inst.x4.net19 dc_inst.x5.net16 0
C4795 dc_inst.x7.net4 dc_inst.x7.net17 0
C4796 dc_inst.x3.x1/a_27_47# dc_inst.in 0
C4797 dc_inst.net1 delay_sel[2] 0.00623f
C4798 dc_inst.x1.x3/a_27_47# dc_inst.x3.net13 0
C4799 dc_inst.x4.net6 dc_inst.x4.net7 0.2766f
C4800 dc_inst.x1.x18/a_27_47# dc_inst.x6.x13/a_27_47# 0.00308f
C4801 path_sel[1] dc_inst.x1.x8/a_27_47# 0
C4802 dc_inst.x1.x4/a_27_47# path_sel[1] 0.01131f
C4803 dc_inst.x6.net18 dc_inst.x6.x18/a_27_47# 0.02631f
C4804 dc_inst.x5.net18 dc_inst.x5.net17 0.02168f
C4805 dc_inst.x7.net6 delay_sel[1] 0
C4806 dc_inst.x4.x8/a_27_47# dc_inst.x4.x14/a_27_47# 0
C4807 dc_inst.x3.net17 shadow_q 0
C4808 dc_inst.x9/a_668_97# clkbuf_1_0__f_clk/a_110_47# 0
C4809 dc_inst.x5.net2 dc_inst.x6.net1 0
C4810 dc_inst.x3.net15 _23_/a_805_47# 0
C4811 dc_inst.x1.net13 dc_inst.x1.x15/a_27_47# 0.00124f
C4812 dc_inst.x4.x1/a_27_47# _23_/a_27_47# 0
C4813 dc_inst.x5.net5 dc_inst.x1.x19/a_27_47# 0
C4814 _24_/a_543_47# _01_ 0.00146f
C4815 _24_/a_1108_47# rst 0
C4816 dc_inst.x3.net19 dc_inst.x3.x12/a_27_47# 0
C4817 dc_inst.x8/a_750_97# path[6] 0
C4818 dc_inst.x1.x7/a_27_47# _15_/a_27_47# 0
C4819 dc_inst.x1.net2 dc_inst.x1.x1/a_27_47# 0.00213f
C4820 dc_inst.x1.net16 path_sel[2] 0.0128f
C4821 _00_ _25_/a_543_47# 0.03451f
C4822 _20_/a_79_21# path[7] 0
C4823 dc_inst.x4.net6 dc_inst.x5.net6 0.2803f
C4824 dc_inst.net7 _25_/a_193_47# 0
C4825 dc_inst.x3.x17/a_27_47# dc_inst.x3.net4 0.00117f
C4826 dc_inst.x5.net2 dc_inst.x5.x13/a_27_47# 0.00123f
C4827 dc_inst.x4.net16 dc_inst.x4.net8 0.04513f
C4828 dc_inst.x4.net4 path_sel[2] 0.00475f
C4829 dc_inst.x1.x3/a_27_47# _13_/a_112_47# 0
C4830 path_sel[1] dc_inst.x3.x18/a_27_47# 0
C4831 VPWR dc_inst.x4.net12 0.03013f
C4832 VPWR dc_inst.x2.x7/a_27_47# 0.03331f
C4833 dc_inst.x5.x8/a_27_47# dc_inst.x4.x14/a_27_47# 0.00381f
C4834 dc_inst.x2.x2/a_27_47# dc_inst.x2.x3/a_27_47# 0
C4835 dc_inst.x7.net1 _25_/a_1270_413# 0
C4836 dc_inst.x5.x5/a_27_47# dc_inst.x5.net9 0.03528f
C4837 dc_inst.x7.net1 dc_inst.x7.net13 0
C4838 dc_inst.x1.net7 dc_inst.x2.x15/a_27_47# 0
C4839 capture_d dc_inst.x7.net18 0.00223f
C4840 clknet_1_0__leaf_clk _25_/a_543_47# 0.00137f
C4841 dc_inst.x9/a_834_97# delay_sel[1] 0.03317f
C4842 _10_ dc_inst.x1.net2 0
C4843 dc_inst.x4.x13/a_27_47# dc_inst.x4.x12/a_27_47# 0.02448f
C4844 dc_inst.x5.x20/a_27_47# dc_inst.x6.net19 0
C4845 _24_/a_543_47# _02_ 0
C4846 _24_/a_1108_47# clknet_1_1__leaf_clk 0
C4847 dc_inst.x6.net6 dc_inst.x6.net3 0
C4848 dc_inst.x5.net3 path_sel[0] 0.00556f
C4849 dc_inst.x1.x7/a_27_47# dc_inst.x1.x4/a_27_47# 0
C4850 _10_ _15_/a_1064_47# 0
C4851 dc_inst.x3.net8 dc_inst.x3.x15/a_27_47# 0
C4852 dc_inst.x7.x1/a_27_47# dc_inst.x6.net6 0.00104f
C4853 _05_ shadow_q 0.00113f
C4854 dc_inst.x2.net11 dc_inst.x5.net4 0
C4855 tdo delay_sel[1] 0.0341f
C4856 dc_inst.x7.x18/a_27_47# capture_d 0
C4857 dc_inst.x9/a_1478_413# dc_inst.x6.x19/a_27_47# 0
C4858 dc_inst.x3.x4/a_27_47# dc_inst.x3.x15/a_27_47# 0
C4859 dc_inst.net8 clkload0/X 0
C4860 dc_inst.x7.x11/a_27_47# clkbuf_0_clk/a_110_47# 0.01702f
C4861 dc_inst.x6.net15 dc_inst.x6.x16/a_27_47# 0.12554f
C4862 dc_inst.x3.net1 dc_inst.x3.net8 0.04892f
C4863 dc_inst.x5.x6/a_27_47# dc_inst.x6.x10/a_27_47# 0.08729f
C4864 dc_inst.x4.x5/a_27_47# dc_inst.x4.x7/a_27_47# 0
C4865 dc_inst.x2.x1/a_27_47# dc_inst.x1.x19/a_27_47# 0.01126f
C4866 dc_inst.x7.x10/a_27_47# dc_inst.net4 0.00147f
C4867 dc_inst.x3.net16 dc_inst.x3.net6 0.00268f
C4868 _24_/a_1283_21# dc_inst.x3.x1/a_27_47# 0
C4869 dc_inst.x4.net15 dc_inst.x4.x15/a_27_47# 0.00786f
C4870 dc_inst.x5.net2 path_sel[1] 0.03192f
C4871 dc_inst.x4.x16/a_27_47# dc_inst.x4.net16 0.00892f
C4872 dc_inst.x3.x19/a_27_47# _01_ 0
C4873 dc_inst.x2.net4 dc_inst.x2.net8 0.01358f
C4874 dc_inst.x4.net3 dc_inst.x4.net5 0.00633f
C4875 _15_/a_872_316# dc_inst.x1.net2 0
C4876 dc_inst.x6.x20/a_27_47# dc_inst.x5.net6 0
C4877 dc_inst.x7.net1 _25_/a_761_289# 0.00399f
C4878 dc_inst.x4.net10 path_sel[0] 0
C4879 dc_inst.x2.net14 dc_inst.x1.net19 0
C4880 dc_inst.x9/a_277_47# dc_inst.x7.net5 0
C4881 dc_inst.x3.net16 _23_/a_1270_413# 0
C4882 dc_inst.x5.net9 dc_inst.x1.x19/a_27_47# 0
C4883 dc_inst.x7.net14 dc_inst.x9/a_27_413# 0
C4884 clknet_0_clk _23_/a_1108_47# 0
C4885 dc_inst.x7.x17/a_27_47# dc_inst.x7.net16 0.13602f
C4886 dc_inst.x3.net17 dc_inst.x3.x1/a_27_47# 0.00159f
C4887 dc_inst.x4.net12 dc_inst.x6.net6 0
C4888 dc_inst.x3.net11 dc_inst.x3.x11/a_27_47# 0.01744f
C4889 dc_inst.x1.x13/a_27_47# path_sel[0] 0
C4890 dc_inst.x9/a_757_363# dc_inst.x9/a_834_97# -0.00174f
C4891 dc_inst.x7.net13 dc_inst.x7.net18 0.01026f
C4892 dc_inst.x3.x19/a_27_47# _02_ 0
C4893 dc_inst.x4.x17/a_27_47# dc_inst.x6.net12 0
C4894 dc_inst.x3.x16/a_27_47# dc_inst.x3.net3 0.0013f
C4895 dc_inst.x4.net6 path_sel[2] 0.00584f
C4896 dc_inst.x7.net5 dc_inst.x7.net17 0
C4897 dc_inst.x3.net14 _01_ 0
C4898 dc_inst.x6.net18 dc_inst.x2.x19/a_27_47# 0
C4899 dc_inst.x6.net13 dc_inst.x2.net15 0
C4900 dc_inst.x1.net16 dc_inst.x1.net17 0.04556f
C4901 dc_inst.x8/a_1290_413# dc_inst.x3.net14 0
C4902 dc_inst.x4.x19/a_27_47# dc_inst.x5.x13/a_27_47# 0.04629f
C4903 _09_ _07_ 0.24016f
C4904 dc_inst.x3.x10/a_27_47# dc_inst.x3.net9 0.01149f
C4905 dc_inst.x7.net4 dc_inst.x4.net4 0
C4906 dc_inst.x6.net12 dc_inst.x6.x5/a_27_47# 0.00131f
C4907 _20_/a_79_21# _10_ 0.02305f
C4908 dc_inst.x5.net6 dc_inst.x6.x19/a_27_47# 0
C4909 dc_inst.x4.x9/a_27_47# dc_inst.x4.x10/a_27_47# 0.02448f
C4910 _13_/a_27_297# dc_inst.x3.net8 0
C4911 dc_inst.x3.net15 dc_inst.x3.net11 0
C4912 dc_inst.x4.net4 dc_inst.x1.net17 0
C4913 _06_ dc_inst.x1.net7 0
C4914 dc_inst.x4.net16 dc_inst.x4.x9/a_27_47# 0
C4915 dc_inst.x2.x17/a_27_47# dc_inst.x2.net16 0.12267f
C4916 dc_inst.x7.x12/a_27_47# dc_inst.x7.net12 0.00377f
C4917 dc_inst.x3.net19 _15_/a_372_413# 0
C4918 _15_/a_600_345# _19_/a_109_297# 0
C4919 dc_inst.net3 dc_inst.x9/a_277_47# 0
C4920 dc_inst.net1 dc_inst.x1.net16 0
C4921 dc_inst.x3.net14 _02_ 0
C4922 dc_inst.x2.net1 dc_inst.x5.net11 0.00916f
C4923 dc_inst.net1 dc_inst.x4.net4 0.0038f
C4924 dc_inst.x8/a_668_97# delay_sel[0] 0
C4925 dc_inst.x6.x20/a_27_47# dc_inst.net5 0.03857f
C4926 dc_inst.x7.net7 dc_inst.x7.x15/a_27_47# 0
C4927 _04_ dc_inst.in 0.15991f
C4928 dc_inst.x3.net6 path[6] 0.00232f
C4929 dc_inst.x3.x8/a_27_47# _02_ 0.04407f
C4930 path[4] dc_inst.x1.net3 0.00606f
C4931 path_sel[1] dc_inst.x2.net19 0
C4932 _20_/a_79_21# _15_/a_872_316# 0
C4933 dc_inst.x5.net3 tdo 0.03054f
C4934 dc_inst.x4.net8 dc_inst.x4.x5/a_27_47# 0
C4935 VPWR dc_inst.x1.net18 0.11811f
C4936 dc_inst.x1.net4 dc_inst.x3.net19 0.07622f
C4937 path[3] _17_/a_27_93# 0.00126f
C4938 dc_inst.x7.x13/a_27_47# dc_inst.x7.x9/a_27_47# 0
C4939 dc_inst.x10/a_76_199# dc_inst.x8/a_247_21# 0
C4940 dc_inst.net8 dc_inst.x7.x3/a_27_47# 0
C4941 dc_inst.x5.net15 dc_inst.x5.x15/a_27_47# 0.01506f
C4942 path_sel[1] dc_inst.x4.x19/a_27_47# 0.00506f
C4943 dc_inst.x2.net17 dc_inst.x2.x15/a_27_47# 0
C4944 dc_inst.x6.x20/a_27_47# path_sel[2] 0.0034f
C4945 dc_inst.x3.net5 _15_/a_27_47# 0
C4946 dc_inst.x5.x14/a_27_47# dc_inst.x5.net14 0.00266f
C4947 dc_inst.x1.net7 path[3] 0.04466f
C4948 dc_inst.x4.net9 dc_inst.x4.net12 0
C4949 dc_inst.x4.net5 dc_inst.x2.net15 0.01484f
C4950 dc_inst.x1.net4 dc_inst.x5.x12/a_27_47# 0
C4951 dc_inst.x7.net6 dc_inst.x9/a_247_21# 0
C4952 dc_inst.x7.net3 delay_sel[1] 0.00408f
C4953 dc_inst.x6.net14 dc_inst.x6.x16/a_27_47# 0
C4954 dc_inst.x3.net17 dc_inst.x3.net6 0.0137f
C4955 _15_/a_27_47# dc_inst.x3.net2 0
C4956 dc_inst.x4.net19 dc_inst.x4.net11 0
C4957 delay_sel[2] _23_/a_761_289# 0.0158f
C4958 dc_inst.x4.x13/a_27_47# dc_inst.x4.net15 0
C4959 dc_inst.x4.net6 dc_inst.x6.net11 0
C4960 dc_inst.x5.x5/a_27_47# dc_inst.x5.net12 0
C4961 _17_/a_27_93# _19_/a_27_47# 0
C4962 dc_inst.x7.x16/a_27_47# dc_inst.x7.x15/a_27_47# 0
C4963 dc_inst.x3.x14/a_27_47# dc_inst.x1.net6 0
C4964 dc_inst.x4.net10 tdo 0.02572f
C4965 dc_inst.x1.net7 _19_/a_27_47# 0.03117f
C4966 dc_inst.x1.x20/a_27_47# dc_inst.x4.x4/a_27_47# 0.00988f
C4967 dc_inst.x6.x19/a_27_47# dc_inst.net5 0
C4968 VPWR _24_/a_639_47# 0.00409f
C4969 _14_/a_505_21# dc_inst.x3.net7 0
C4970 clknet_0_clk _23_/a_193_47# 0.0014f
C4971 dc_inst.x6.x14/a_27_47# dc_inst.x6.net13 0.03794f
C4972 VPWR dc_inst.x7.net15 -0.00394f
C4973 _16_/a_229_47# path[2] 0
C4974 dc_inst.x7.net14 dc_inst.x7.net13 0.0035f
C4975 dc_inst.x6.net18 dc_inst.x6.x16/a_27_47# 0.01152f
C4976 dc_inst.x1.net8 dc_inst.x1.x9/a_27_47# 0.00597f
C4977 dc_inst.x3.net2 dc_inst.x1.x8/a_27_47# 0
C4978 dc_inst.x6.x19/a_27_47# path_sel[2] 0.00282f
C4979 dc_inst.x9/a_277_47# dc_inst.x9/a_668_97# -0.01493f
C4980 dc_inst.x4.net6 dc_inst.x1.net17 -0
C4981 dc_inst.x6.x1/a_27_47# dc_inst.x6.x10/a_27_47# 0
C4982 dc_inst.x5.net14 dc_inst.x5.net15 0.01842f
C4983 dc_inst.x1.net5 dc_inst.in 0.06056f
C4984 dc_inst.x1.net6 path[7] 0
C4985 dc_inst.x2.x20/a_27_47# dc_inst.x8/a_277_47# 0
C4986 _24_/a_543_47# path[6] 0
C4987 _03_ _00_ 0.09864f
C4988 dc_inst.x6.net6 dc_inst.x1.net18 0
C4989 dc_inst.x3.net5 dc_inst.x3.x18/a_27_47# 0
C4990 _05_ dc_inst.x3.net6 0
C4991 path_sel[1] dc_inst.x2.x16/a_27_47# 0
C4992 VPWR dc_inst.x6.x10/a_27_47# -0.00316f
C4993 dc_inst.x5.net2 dc_inst.x6.net4 0
C4994 VPWR dc_inst.x1.x9/a_27_47# 0.01697f
C4995 dc_inst.x7.net4 dc_inst.x3.x17/a_27_47# 0
C4996 dc_inst.x4.net6 dc_inst.net1 0
C4997 dc_inst.x5.net19 dc_inst.x6.net19 0
C4998 path_sel[1] dc_inst.x5.net5 0.00534f
C4999 dc_inst.x9/a_27_47# dc_inst.net5 0.00166f
C5000 dc_inst.x3.net14 dc_inst.x3.net16 0
C5001 dc_inst.x4.net15 dc_inst.x5.x14/a_27_47# 0
C5002 dc_inst.x5.net3 dc_inst.x6.x8/a_27_47# 0
C5003 dc_inst.x9/a_668_97# dc_inst.x7.net17 0.0023f
C5004 dc_inst.x4.net13 dc_inst.x5.x7/a_27_47# 0
C5005 dc_inst.x1.net15 dc_inst.x1.x20/a_27_47# 0.00182f
C5006 dc_inst.x4.net2 dc_inst.x2.net4 0
C5007 dc_inst.x5.net2 dc_inst.x5.net19 0
C5008 _03_ clknet_1_0__leaf_clk 0.05868f
C5009 dc_inst.x4.net6 dc_inst.x2.net2 0
C5010 VPWR _18_/a_439_47# -0
C5011 dc_inst.x4.x3/a_27_47# dc_inst.x1.net16 0
C5012 path_sel[1] dc_inst.x1.net15 0.01039f
C5013 dc_inst.x4.x1/a_27_47# dc_inst.x6.net18 0
C5014 VPWR dc_inst.x2.x20/a_27_47# -0.00539f
C5015 delay_sel[2] dc_inst.x10/a_535_374# 0
C5016 path_sel[1] dc_inst.x2.x9/a_27_47# 0.0139f
C5017 dc_inst.x1.net14 dc_inst.x1.net2 0.09651f
C5018 dc_inst.x10/a_505_21# _24_/a_27_47# 0
C5019 dc_inst.x3.net14 dc_inst.in 0
C5020 dc_inst.x4.net6 dc_inst.x6.net10 0.00979f
C5021 dc_inst.x6.x20/a_27_47# dc_inst.net6 0.01949f
C5022 dc_inst.x4.net14 path_sel[0] 0.00403f
C5023 dc_inst.x4.net4 dc_inst.x4.x3/a_27_47# 0.0092f
C5024 dc_inst.x1.net10 dc_inst.x1.net9 0.00338f
C5025 dc_inst.x4.net1 dc_inst.x4.net11 0.03134f
C5026 _20_/a_79_21# dc_inst.x1.net11 0
C5027 dc_inst.x4.x9/a_27_47# dc_inst.x4.x5/a_27_47# 0
C5028 dc_inst.x7.net4 dc_inst.x6.x20/a_27_47# 0.03111f
C5029 _07_ _18_/a_76_199# 0.02124f
C5030 dc_inst.x6.net5 dc_inst.x6.net3 0
C5031 dc_inst.x1.x20/a_27_47# dc_inst.x2.net3 0
C5032 dc_inst.x2.net17 dc_inst.x1.net19 0
C5033 path_sel[1] dc_inst.x2.net3 0.00783f
C5034 dc_inst.x2.net1 dc_inst.x5.net1 0.00118f
C5035 dc_inst.x7.x1/a_27_47# dc_inst.x6.net5 0
C5036 dc_inst.net3 dc_inst.x1.net16 0.00215f
C5037 dc_inst.x5.net9 path[1] 0
C5038 dc_inst.x1.x10/a_27_47# dc_inst.x1.x11/a_27_47# 0
C5039 dc_inst.x2.x13/a_27_47# path_sel[0] 0
C5040 dc_inst.x5.net8 dc_inst.x5.net4 0.00122f
C5041 _16_/a_229_47# dc_inst.x5.net10 0
C5042 dc_inst.x2.net14 dc_inst.x1.x19/a_27_47# 0
C5043 path_sel[2] dc_inst.x8/a_923_363# 0
C5044 dc_inst.x5.net7 dc_inst.x6.net13 0
C5045 dc_inst.x7.x1/a_27_47# dc_inst.x7.net9 0
C5046 _24_/a_27_47# rst 0.00746f
C5047 dc_inst.x3.x19/a_27_47# path[6] 0.00541f
C5048 dc_inst.x2.net18 path_sel[0] 0
C5049 dc_inst.x4.net15 dc_inst.x4.x18/a_27_47# 0.04066f
C5050 dc_inst.x5.net18 dc_inst.x5.net16 0.01044f
C5051 dc_inst.x4.net5 dc_inst.x6.net15 0
C5052 _15_/a_288_47# dc_inst.x3.x2/a_27_47# 0
C5053 delay_sel[1] dc_inst.x3.x2/a_27_47# 0
C5054 dc_inst.x1.net5 path[6] 0.00312f
C5055 dc_inst.x3.net13 dc_inst.x3.x14/a_27_47# 0.01907f
C5056 dc_inst.net3 dc_inst.x4.net4 0.00354f
C5057 path_sel[1] dc_inst.x2.x1/a_27_47# 0.00186f
C5058 dc_inst.x8/a_668_97# dc_inst.x4.net2 0
C5059 dc_inst.x5.net8 dc_inst.x4.x18/a_27_47# 0
C5060 dc_inst.x1.net1 dc_inst.x5.net12 0.00426f
C5061 capture_d _23_/a_27_47# 0.04554f
C5062 VPWR dc_inst.x2.x3/a_27_47# 0.03787f
C5063 dc_inst.x4.net13 dc_inst.net4 0
C5064 dc_inst.net6 dc_inst.x6.x19/a_27_47# 0
C5065 dc_inst.x1.x7/a_27_47# dc_inst.x1.net15 0
C5066 path_sel[1] dc_inst.x5.net9 0.01299f
C5067 dc_inst.x7.x9/a_27_47# delay_sel[0] 0
C5068 _16_/a_27_93# path[1] 0.02047f
C5069 dc_inst.x6.net17 dc_inst.x6.net16 0.28164f
C5070 dc_inst.x3.x19/a_27_47# dc_inst.x3.net17 0.04436f
C5071 dc_inst.x7.net4 dc_inst.x6.x19/a_27_47# 0.02961f
C5072 dc_inst.x1.net10 dc_inst.x2.net6 0
C5073 _24_/a_27_47# clknet_1_1__leaf_clk 0.44735f
C5074 dc_inst.x6.net10 dc_inst.x6.x20/a_27_47# 0
C5075 dc_inst.x7.net19 dc_inst.x7.net12 0.00567f
C5076 dc_inst.x4.x16/a_27_47# dc_inst.x4.x12/a_27_47# 0
C5077 dc_inst.x5.x18/a_27_47# dc_inst.x6.x2/a_27_47# 0
C5078 dc_inst.x3.net14 path[6] 0.03775f
C5079 dc_inst.x3.net13 path[7] 0
C5080 path_sel[1] dc_inst.net2 0
C5081 delay_sel[0] dc_inst.x8/a_247_21# 0.02439f
C5082 dc_inst.x6.x6/a_27_47# dc_inst.x5.x15/a_27_47# 0
C5083 _10_ dc_inst.x1.net6 0.03146f
C5084 dc_inst.x9/a_834_97# _25_/a_543_47# 0
C5085 dc_inst.x6.x16/a_27_47# rst 0
C5086 dc_inst.x6.net12 dc_inst.x6.x16/a_27_47# 0
C5087 dc_inst.x5.net8 dc_inst.x4.x7/a_27_47# 0
C5088 dc_inst.x2.net10 dc_inst.x2.net7 0.0091f
C5089 dc_inst.x2.net9 dc_inst.x1.net16 0
C5090 _15_/a_788_316# dc_inst.x1.net3 0.00737f
C5091 dc_inst.x1.net1 dc_inst.x2.net14 0
C5092 _15_/a_27_47# dc_inst.x3.net12 0
C5093 dc_inst.x3.x8/a_27_47# path[6] 0.00322f
C5094 tdo _25_/a_543_47# 0
C5095 dc_inst.x1.net7 dc_inst.x1.x19/a_27_47# 0
C5096 dc_inst.x1.net12 dc_inst.x1.net5 0.05871f
C5097 dc_inst.x4.net5 dc_inst.x5.net7 0
C5098 _10_ path[2] 0.00151f
C5099 clkbuf_1_1__f_clk/a_110_47# tdi 0
C5100 dc_inst.x6.net14 dc_inst.x6.net13 0.23201f
C5101 dc_inst.net4 dc_inst.x9/a_923_363# 0
C5102 dc_inst.x3.net5 dc_inst.x3.net8 0
C5103 dc_inst.x3.net14 dc_inst.x3.net17 0.02671f
C5104 dc_inst.x6.net9 dc_inst.x6.x4/a_27_47# 0.01152f
C5105 VPWR _00_ 2.27735f
C5106 dc_inst.x4.net6 dc_inst.x4.x8/a_27_47# 0
C5107 _09_ _18_/a_76_199# 0.01793f
C5108 dc_inst.x3.net5 dc_inst.x3.x4/a_27_47# 0.00241f
C5109 _01_ dc_inst.x3.net3 0
C5110 dc_inst.x4.net2 dc_inst.x1.x1/a_27_47# 0
C5111 tdo _25_/a_639_47# 0
C5112 _05_ dc_inst.x3.x19/a_27_47# 0
C5113 dc_inst.x1.net10 dc_inst.x2.net12 0.01883f
C5114 dc_inst.x3.net14 dc_inst.x3.x9/a_27_47# 0
C5115 dc_inst.x8/a_1290_413# dc_inst.x3.net3 0
C5116 dc_inst.net2 _23_/a_1108_47# 0
C5117 path_sel[1] dc_inst.x2.x10/a_27_47# 0.01183f
C5118 dc_inst.x7.x9/a_27_47# dc_inst.x7.net1 0
C5119 VPWR dc_inst.x3.x7/a_27_47# -0.01106f
C5120 _04_ _15_/a_600_345# 0
C5121 dc_inst.x3.net2 dc_inst.x3.x4/a_27_47# 0
C5122 dc_inst.x6.x6/a_27_47# dc_inst.x5.net14 0.01524f
C5123 dc_inst.x1.x2/a_27_47# dc_inst.x1.net5 0.03148f
C5124 dc_inst.x4.net14 tdo 0.00238f
C5125 VPWR clknet_1_0__leaf_clk 0.61327f
C5126 dc_inst.x8/a_1478_413# dc_inst.x3.net2 0.02979f
C5127 dc_inst.x3.net14 dc_inst.x1.net12 0
C5128 VPWR dc_inst.x3.x6/a_27_47# -0.00759f
C5129 dc_inst.x4.net5 dc_inst.x2.x15/a_27_47# 0
C5130 dc_inst.x7.net4 dc_inst.x8/a_923_363# 0
C5131 dc_inst.x6.x20/a_27_47# dc_inst.x7.net5 0.02481f
C5132 _02_ dc_inst.x3.net3 0
C5133 dc_inst.x3.x3/a_27_47# dc_inst.x1.x8/a_27_47# 0
C5134 dc_inst.x1.net1 dc_inst.x1.net7 0
C5135 dc_inst.x3.net14 _05_ 0
C5136 tdo dc_inst.x2.net18 0
C5137 dc_inst.x5.x20/a_27_47# dc_inst.x7.net10 0.15487f
C5138 clkbuf_1_1__f_clk/a_110_47# rst 0.24776f
C5139 dc_inst.net3 dc_inst.x3.x17/a_27_47# 0
C5140 _15_/a_288_47# dc_inst.x1.net2 0.02478f
C5141 dc_inst.x4.net12 dc_inst.x6.net7 0.00288f
C5142 dc_inst.x6.net14 dc_inst.x4.net5 0.00202f
C5143 dc_inst.x1.x12/a_27_47# dc_inst.x1.x5/a_27_47# 0.02448f
C5144 dc_inst.x1.net10 dc_inst.x2.net13 0.00245f
C5145 dc_inst.x2.x2/a_27_47# tdo 0.00181f
C5146 dc_inst.x1.x10/a_27_47# path[3] 0
C5147 dc_inst.x6.x5/a_27_47# dc_inst.x6.net1 0
C5148 dc_inst.x7.x20/a_27_47# dc_inst.x9/a_1478_413# 0
C5149 dc_inst.x3.x16/a_27_47# _01_ 0.00124f
C5150 delay_sel[0] _24_/a_193_47# 0
C5151 _05_ dc_inst.x3.x8/a_27_47# 0.0332f
C5152 dc_inst.x5.x13/a_27_47# dc_inst.x5.net12 0.01693f
C5153 dc_inst.x5.net7 dc_inst.x4.net17 0.00138f
C5154 dc_inst.x1.net13 dc_inst.x1.net16 0
C5155 _25_/a_27_47# dc_inst.net4 0
C5156 dc_inst.x7.net15 clkbuf_1_0__f_clk/a_110_47# 0.00603f
C5157 dc_inst.x7.net5 dc_inst.x6.x19/a_27_47# 0
C5158 dc_inst.x4.net8 dc_inst.x5.net8 0
C5159 dc_inst.x6.net13 dc_inst.x1.net19 0
C5160 dc_inst.x5.net13 path_sel[0] 0.00281f
C5161 dc_inst.x6.x13/a_27_47# dc_inst.x1.net18 0
C5162 clkbuf_1_1__f_clk/a_110_47# clknet_1_1__leaf_clk 0.22639f
C5163 _15_/a_600_345# dc_inst.x1.net5 0.00127f
C5164 dc_inst.x5.net9 dc_inst.x2.x14/a_27_47# 0
C5165 dc_inst.x3.x7/a_27_47# dc_inst.x3.x5/a_27_47# 0
C5166 path[2] _17_/a_574_297# 0.00116f
C5167 path[5] dc_inst.x3.x7/a_27_47# 0.01921f
C5168 dc_inst.x7.x6/a_27_47# dc_inst.x6.x4/a_27_47# 0
C5169 dc_inst.x1.x16/a_27_47# dc_inst.x2.net17 0
C5170 dc_inst.x3.x16/a_27_47# _02_ 0
C5171 dc_inst.x5.net3 dc_inst.x4.net19 0.07137f
C5172 dc_inst.x1.net10 dc_inst.x5.net6 0.00487f
C5173 dc_inst.x7.net6 dc_inst.x7.x8/a_27_47# 0
C5174 dc_inst.x1.x14/a_27_47# dc_inst.x2.x11/a_27_47# 0
C5175 dc_inst.x5.net12 path[1] 0
C5176 dc_inst.x3.x10/a_27_47# _06_ 0
C5177 dc_inst.x7.x10/a_27_47# dc_inst.net5 0.03054f
C5178 dc_inst.x1.net4 _15_/a_397_47# 0
C5179 dc_inst.x10/a_76_199# delay_sel[1] 0
C5180 _24_/a_27_47# _23_/a_651_413# 0
C5181 dc_inst.x4.net9 dc_inst.x2.x3/a_27_47# 0
C5182 path[5] dc_inst.x3.x6/a_27_47# 0.00457f
C5183 _15_/a_27_47# shadow_q 0
C5184 dc_inst.x6.net5 dc_inst.x1.net18 0
C5185 dc_inst.x5.x2/a_27_47# path_sel[0] 0.00273f
C5186 dc_inst.x1.x12/a_27_47# path_sel[0] 0.0021f
C5187 dc_inst.x4.x17/a_27_47# path_sel[1] 0.00661f
C5188 dc_inst.x4.net13 dc_inst.x4.x11/a_27_47# 0.02644f
C5189 dc_inst.x7.net7 dc_inst.x7.net10 0
C5190 dc_inst.x7.x10/a_27_47# path_sel[2] 0.00229f
C5191 dc_inst.x7.x13/a_27_47# delay_sel[1] 0.04372f
C5192 dc_inst.net4 dc_inst.x7.x4/a_27_47# 0.00781f
C5193 dc_inst.x3.net13 _15_/a_872_316# 0
C5194 dc_inst.x4.x1/a_27_47# dc_inst.x1.x16/a_27_47# 0
C5195 dc_inst.x5.x16/a_27_47# path_sel[0] 0
C5196 dc_inst.x4.x16/a_27_47# dc_inst.x4.net15 0.0185f
C5197 path_sel[1] dc_inst.x5.net12 0.0618f
C5198 dc_inst.x9/a_1290_413# dc_inst.x9/a_1478_413# -0.00734f
C5199 dc_inst.x4.net2 dc_inst.x8/a_247_21# 0
C5200 dc_inst.x4.x2/a_27_47# dc_inst.x8/a_757_363# 0
C5201 dc_inst.x1.net11 dc_inst.x1.net6 0.20078f
C5202 dc_inst.x2.x12/a_27_47# dc_inst.x2.net15 0
C5203 dc_inst.x1.net9 dc_inst.net8 0
C5204 dc_inst.x4.net13 dc_inst.x2.net6 0
C5205 dc_inst.x4.x16/a_27_47# dc_inst.x5.net8 0
C5206 dc_inst.x3.net9 path[7] 0
C5207 path_sel[1] dc_inst.x6.x5/a_27_47# 0
C5208 dc_inst.x4.net5 dc_inst.x1.net19 0.12096f
C5209 dc_inst.x3.net16 dc_inst.x3.net3 0.0221f
C5210 dc_inst.x2.net16 dc_inst.in 0
C5211 dc_inst.x3.x20/a_27_47# dc_inst.x8/a_247_21# 0
C5212 dc_inst.x5.x4/a_27_47# dc_inst.x5.x10/a_27_47# 0.08729f
C5213 dc_inst.x1.net11 path[2] 0.00189f
C5214 dc_inst.x6.net12 dc_inst.x6.net13 0.24025f
C5215 dc_inst.x4.net16 dc_inst.x5.net5 0
C5216 dc_inst.x2.net7 dc_inst.x2.x6/a_27_47# 0.00257f
C5217 dc_inst.in dc_inst.x3.net3 0
C5218 dc_inst.x5.x3/a_27_47# path_sel[0] 0
C5219 _03_ _23_/a_543_47# 0
C5220 _24_/a_761_289# _24_/a_27_47# -0.00784f
C5221 path_sel[1] _15_/a_193_47# 0
C5222 path_sel[1] dc_inst.x2.net14 0.01339f
C5223 dc_inst.x6.net14 capture_d 0
C5224 dc_inst.x5.x6/a_27_47# tdo 0.00331f
C5225 VPWR dc_inst.x3.net10 0.19681f
C5226 VPWR dc_inst.x1.x5/a_27_47# -0.01123f
C5227 dc_inst.x3.net12 dc_inst.x3.net8 0.0526f
C5228 dc_inst.x6.net14 dc_inst.x6.x4/a_27_47# 0
C5229 _08_ dc_inst.x2.net10 0
C5230 dc_inst.x3.x10/a_27_47# rst 0
C5231 dc_inst.x5.net3 dc_inst.x4.net1 0
C5232 dc_inst.x8/a_27_47# dc_inst.x6.net14 0
C5233 dc_inst.x2.net18 dc_inst.x7.net3 0
C5234 dc_inst.x4.x9/a_27_47# dc_inst.x5.net8 0.01107f
C5235 dc_inst.x1.net4 dc_inst.x2.x20/a_27_47# 0
C5236 dc_inst.x3.net5 dc_inst.net2 0
C5237 dc_inst.x1.net10 path_sel[2] 0.00385f
C5238 dc_inst.x8/a_668_97# _23_/a_27_47# 0
C5239 dc_inst.x7.net11 _00_ 0.00169f
C5240 path[1] _17_/a_27_93# 0
C5241 path_sel[0] _17_/a_478_47# 0.01432f
C5242 dc_inst.x3.net16 dc_inst.x3.x16/a_27_47# 0.00266f
C5243 dc_inst.x3.net2 dc_inst.net2 0.06877f
C5244 path_sel[1] dc_inst.x2.x8/a_27_47# 0.01054f
C5245 dc_inst.x1.x6/a_27_47# dc_inst.x1.x12/a_27_47# 0
C5246 dc_inst.x1.net8 path_sel[0] 0.00266f
C5247 dc_inst.x3.x4/a_27_47# dc_inst.x3.x3/a_27_47# 0
C5248 dc_inst.x2.x1/a_27_47# dc_inst.x4.x10/a_27_47# 0
C5249 _03_ tdo 0.00936f
C5250 dc_inst.x7.net6 dc_inst.x6.net2 0.02869f
C5251 dc_inst.net3 dc_inst.x8/a_923_363# 0.00151f
C5252 dc_inst.x3.net15 dc_inst.x3.x20/a_27_47# 0
C5253 clknet_1_0__leaf_clk dc_inst.x7.net11 0.02684f
C5254 dc_inst.x7.x14/a_27_47# dc_inst.x7.net12 0.02595f
C5255 dc_inst.x6.net12 dc_inst.x4.net5 0
C5256 dc_inst.x4.net1 dc_inst.x4.net10 0.30598f
C5257 dc_inst.x7.net4 dc_inst.x7.x10/a_27_47# 0.00958f
C5258 dc_inst.x1.x7/a_27_47# dc_inst.x2.net14 0.00114f
C5259 dc_inst.x7.net12 dc_inst.x7.net8 0
C5260 clknet_0_clk clk 0.00206f
C5261 dc_inst.x4.x10/a_27_47# dc_inst.x5.net9 0
C5262 path_sel[1] _17_/a_27_93# 0.03097f
C5263 path[0] _17_/a_478_47# 0.00332f
C5264 clkbuf_1_0__f_clk/a_110_47# _00_ 0.01666f
C5265 VPWR path_sel[0] 0.66682f
C5266 dc_inst.x1.net1 dc_inst.x5.net11 0.00128f
C5267 path_sel[1] dc_inst.x1.net7 0.10933f
C5268 dc_inst.x4.net16 dc_inst.x5.net9 0
C5269 dc_inst.x3.net3 path[6] 0.08039f
C5270 dc_inst.x3.net19 dc_inst.x3.x17/a_27_47# 0
C5271 dc_inst.x8/a_757_363# dc_inst.x7.x3/a_27_47# 0
C5272 dc_inst.x4.net13 dc_inst.x4.net7 0
C5273 dc_inst.x6.net4 dc_inst.x7.net10 0
C5274 dc_inst.x3.net10 path[5] 0.01399f
C5275 dc_inst.x3.net15 dc_inst.x3.net13 0
C5276 path[5] dc_inst.x1.x5/a_27_47# 0
C5277 clkbuf_0_clk/a_110_47# clk 0.00654f
C5278 clknet_1_0__leaf_clk clkbuf_1_0__f_clk/a_110_47# 0.29256f
C5279 path[0] VPWR 0.25473f
C5280 dc_inst.x1.x16/a_27_47# dc_inst.x6.net13 0
C5281 dc_inst.x2.x16/a_27_47# dc_inst.x2.net5 0
C5282 dc_inst.x5.net12 dc_inst.x2.x14/a_27_47# 0
C5283 dc_inst.x4.net3 dc_inst.x8/a_247_21# 0
C5284 dc_inst.x3.net17 dc_inst.x3.net3 0.09203f
C5285 dc_inst.x5.net5 dc_inst.x2.net5 0
C5286 dc_inst.x6.x2/a_27_47# path_sel[2] 0.01302f
C5287 dc_inst.x5.net19 dc_inst.x7.net10 0.14374f
C5288 _23_/a_543_47# dc_inst.x8/a_277_47# 0
C5289 dc_inst.x4.net13 dc_inst.x5.net6 0
C5290 tdo dc_inst.x6.net2 0
C5291 delay_sel[0] delay_sel[1] 0.48709f
C5292 dc_inst.x9/a_757_363# dc_inst.x7.x5/a_27_47# 0
C5293 dc_inst.x1.net15 dc_inst.x2.net5 0
C5294 dc_inst.x3.net15 _13_/a_112_47# 0
C5295 clknet_0_clk _25_/a_1108_47# 0.02283f
C5296 dc_inst.x2.x9/a_27_47# dc_inst.x2.net5 0.01154f
C5297 dc_inst.x7.net6 dc_inst.x6.x1/a_27_47# 0
C5298 tdo dc_inst.x5.x3/a_27_47# 0
C5299 dc_inst.x5.net2 dc_inst.x5.x15/a_27_47# 0.03049f
C5300 dc_inst.x2.net1 dc_inst.x2.x12/a_27_47# 0
C5301 dc_inst.x1.x7/a_27_47# dc_inst.x1.net7 0.03123f
C5302 clkbuf_1_1__f_clk/a_110_47# _24_/a_761_289# 0.00203f
C5303 _14_/a_76_199# _00_ 0.00228f
C5304 dc_inst.x9/a_1290_413# path_sel[2] 0
C5305 dc_inst.x3.net8 shadow_q 0.00737f
C5306 dc_inst.x3.x16/a_27_47# path[6] 0.00662f
C5307 delay_sel[2] _24_/a_639_47# 0.0015f
C5308 _15_/a_27_47# dc_inst.x3.net6 0
C5309 dc_inst.x2.net18 dc_inst.x2.x18/a_27_47# 0.00377f
C5310 dc_inst.x10/a_505_21# capture_d 0
C5311 VPWR dc_inst.x7.net6 0.00322f
C5312 VPWR _23_/a_543_47# 0.03776f
C5313 dc_inst.x6.net6 path_sel[0] 0
C5314 dc_inst.x6.net12 dc_inst.x4.net17 0
C5315 _13_/a_112_47# _24_/a_193_47# 0
C5316 dc_inst.x1.x10/a_27_47# dc_inst.x1.net1 0.04368f
C5317 clkbuf_0_clk/a_110_47# _25_/a_1108_47# 0.00531f
C5318 path[5] path_sel[0] 0.1188f
C5319 dc_inst.x2.net4 dc_inst.x5.net7 0.00194f
C5320 dc_inst.x2.net14 dc_inst.x2.x14/a_27_47# 0.01467f
C5321 dc_inst.x1.net10 dc_inst.x1.net17 0
C5322 dc_inst.x7.x13/a_27_47# dc_inst.x9/a_247_21# 0
C5323 _14_/a_76_199# dc_inst.x3.x7/a_27_47# 0
C5324 dc_inst.x5.x5/a_27_47# dc_inst.x4.net5 0
C5325 dc_inst.x6.x5/a_27_47# dc_inst.x6.net4 0
C5326 dc_inst.x3.x12/a_27_47# dc_inst.x3.net10 0.00194f
C5327 tdo dc_inst.x4.x20/a_27_47# 0
C5328 _20_/a_384_47# path[4] 0.00137f
C5329 dc_inst.x8/a_1478_413# shadow_q 0
C5330 dc_inst.x9/a_834_97# dc_inst.x6.x1/a_27_47# 0
C5331 tdo dc_inst.x8/a_277_47# 0
C5332 dc_inst.x3.net17 dc_inst.x3.x16/a_27_47# 0
C5333 dc_inst.x1.x16/a_27_47# dc_inst.x4.net5 0.01453f
C5334 dc_inst.x7.net2 delay_sel[1] 0.12681f
C5335 dc_inst.x6.x5/a_27_47# dc_inst.x5.net19 0.00181f
C5336 VPWR dc_inst.x1.x6/a_27_47# 0.03847f
C5337 dc_inst.net3 path[4] 0
C5338 dc_inst.x4.net19 dc_inst.x4.net14 0.03744f
C5339 capture_d rst 0.20933f
C5340 dc_inst.x5.net2 dc_inst.x5.net14 0.06817f
C5341 dc_inst.x7.net15 dc_inst.x7.net17 0.00128f
C5342 dc_inst.x7.net1 delay_sel[1] 0.03242f
C5343 VPWR dc_inst.x9/a_834_97# -0
C5344 dc_inst.x6.x1/a_27_47# tdo 0.00127f
C5345 se _00_ 0.33191f
C5346 _14_/a_535_374# _00_ 0
C5347 dc_inst.x3.net15 _23_/a_1283_21# 0.00116f
C5348 delay_sel[0] dc_inst.x9/a_757_363# 0.07377f
C5349 dc_inst.x5.net9 dc_inst.x2.net5 0
C5350 dc_inst.x6.net12 dc_inst.x6.x4/a_27_47# 0
C5351 clkbuf_1_1__f_clk/a_110_47# dc_inst.x3.x15/a_27_47# 0
C5352 dc_inst.x5.net5 dc_inst.x2.net11 0
C5353 _08_ _19_/a_193_297# 0.01026f
C5354 _03_ dc_inst.x7.net3 0
C5355 dc_inst.net4 dc_inst.x6.x15/a_27_47# 0
C5356 dc_inst.x7.x10/a_27_47# dc_inst.x7.net5 0
C5357 dc_inst.x8/a_750_97# dc_inst.x2.net19 0
C5358 se dc_inst.x3.x7/a_27_47# 0
C5359 VPWR tdo 0.52872f
C5360 dc_inst.x8/a_193_413# dc_inst.in 0.00118f
C5361 dc_inst.x8/a_750_97# dc_inst.x8/a_1478_413# -0.00487f
C5362 dc_inst.x1.net15 dc_inst.x2.net11 0
C5363 dc_inst.x1.net10 dc_inst.x5.x9/a_27_47# 0
C5364 dc_inst.x6.x8/a_27_47# dc_inst.x6.net2 0
C5365 capture_d clknet_1_1__leaf_clk 0.0319f
C5366 dc_inst.x3.net6 dc_inst.x3.x18/a_27_47# 0
C5367 dc_inst.x4.net19 dc_inst.x2.x2/a_27_47# 0
C5368 dc_inst.x2.net11 dc_inst.x2.x9/a_27_47# 0.03129f
C5369 dc_inst.x5.net3 dc_inst.x2.net8 0
C5370 _24_/a_193_47# _23_/a_1283_21# 0.0064f
C5371 _24_/a_27_47# _23_/a_1108_47# 0
C5372 dc_inst.x4.net5 dc_inst.x1.x19/a_27_47# 0.03981f
C5373 se dc_inst.x3.x6/a_27_47# 0
C5374 dc_inst.x2.x1/a_27_47# dc_inst.x4.x5/a_27_47# 0.08729f
C5375 dc_inst.x3.x12/a_27_47# path_sel[0] 0
C5376 dc_inst.x7.net6 dc_inst.x6.net6 0
C5377 dc_inst.x4.net13 path_sel[2] 0
C5378 _04_ _15_/a_27_47# 0
C5379 _02_ _01_ 0
C5380 dc_inst.x4.x2/a_27_47# dc_inst.x1.net9 0
C5381 _24_/a_448_47# _00_ 0.01619f
C5382 dc_inst.x1.x20/a_27_47# dc_inst.x2.net17 0
C5383 dc_inst.x3.x11/a_27_47# dc_inst.x3.net9 0.12033f
C5384 dc_inst.x1.net9 dc_inst.x1.x17/a_27_47# 0
C5385 dc_inst.x8/a_1290_413# _02_ 0
C5386 path_sel[1] dc_inst.x2.net17 0
C5387 dc_inst.net6 dc_inst.x9/a_1290_413# 0.00159f
C5388 dc_inst.x7.net2 dc_inst.x9/a_757_363# 0.00156f
C5389 dc_inst.x4.net14 dc_inst.x6.x11/a_27_47# 0
C5390 dc_inst.x4.net9 path_sel[0] 0
C5391 _03_ _23_/a_805_47# 0
C5392 dc_inst.x4.net10 dc_inst.x2.net8 0.00985f
C5393 dc_inst.x9/a_247_21# dc_inst.x7.x5/a_27_47# 0.00115f
C5394 dc_inst.net2 dc_inst.x3.x3/a_27_47# 0
C5395 dc_inst.x4.x17/a_27_47# dc_inst.x4.net16 0.0173f
C5396 dc_inst.x9/a_757_363# dc_inst.x7.net1 0
C5397 dc_inst.x7.net4 dc_inst.x9/a_1290_413# 0
C5398 dc_inst.x5.net12 dc_inst.x4.x10/a_27_47# 0
C5399 dc_inst.x7.net7 dc_inst.x6.x16/a_27_47# 0
C5400 dc_inst.x1.x4/a_27_47# _04_ 0
C5401 delay_sel[1] dc_inst.x7.net18 0
C5402 dc_inst.x1.x15/a_27_47# path_sel[0] 0
C5403 dc_inst.x5.net2 dc_inst.x4.net15 0
C5404 dc_inst.x4.net16 dc_inst.x5.net12 0
C5405 dc_inst.x1.net16 dc_inst.x1.net18 0.01639f
C5406 dc_inst.x8/a_1478_413# dc_inst.x3.x1/a_27_47# 0
C5407 dc_inst.x3.net15 dc_inst.x3.net9 0
C5408 dc_inst.net4 dc_inst.x9/a_193_47# 0
C5409 dc_inst.x9/a_923_363# path_sel[2] 0
C5410 dc_inst.x4.net4 dc_inst.x1.net18 0
C5411 dc_inst.x2.net11 dc_inst.x5.net9 0
C5412 path_sel[1] dc_inst.x5.net11 0.08975f
C5413 dc_inst.x6.net6 tdo 0
C5414 dc_inst.x4.x13/a_27_47# dc_inst.x2.net7 0
C5415 dc_inst.net8 path_sel[2] 0
C5416 dc_inst.net2 _24_/a_1462_47# 0
C5417 clkbuf_1_1__f_clk/a_110_47# _13_/a_27_297# 0.00102f
C5418 dc_inst.x7.x18/a_27_47# delay_sel[1] 0
C5419 dc_inst.x4.net2 _15_/a_288_47# 0
C5420 dc_inst.x4.net2 delay_sel[1] 0
C5421 dc_inst.x8/a_750_97# dc_inst.x2.x16/a_27_47# 0
C5422 dc_inst.net1 dc_inst.x9/a_1290_413# 0.00312f
C5423 dc_inst.x2.net6 dc_inst.x1.x17/a_27_47# 0.00189f
C5424 dc_inst.x2.net18 dc_inst.x1.net2 0
C5425 VPWR dc_inst.x6.x8/a_27_47# 0.00986f
C5426 dc_inst.x4.x19/a_27_47# dc_inst.x5.net14 0.00149f
C5427 _15_/a_27_47# dc_inst.x1.net5 0
C5428 dc_inst.x1.net15 dc_inst.x2.x11/a_27_47# 0
C5429 dc_inst.x1.net15 dc_inst.x8/a_750_97# 0
C5430 clk _25_/a_193_47# 0
C5431 dc_inst.x3.x20/a_27_47# delay_sel[1] 0
C5432 dc_inst.x7.net12 _25_/a_448_47# 0
C5433 dc_inst.x7.net3 dc_inst.x8/a_277_47# 0
C5434 dc_inst.x3.net15 _23_/a_27_47# 0
C5435 _18_/a_218_47# _07_ 0.0015f
C5436 delay_sel[0] dc_inst.x9/a_247_21# 0.03698f
C5437 _24_/a_543_47# clknet_0_clk 0.00372f
C5438 delay_sel[2] _00_ 0.03686f
C5439 dc_inst.net7 capture_d 0
C5440 dc_inst.x7.x17/a_27_47# dc_inst.x7.net19 0.03689f
C5441 dc_inst.x2.net6 dc_inst.x5.x10/a_27_47# 0.00132f
C5442 dc_inst.x1.x7/a_27_47# dc_inst.x5.net11 0
C5443 dc_inst.x1.x4/a_27_47# dc_inst.x1.net5 0.00202f
C5444 dc_inst.x3.net14 _15_/a_27_47# 0
C5445 dc_inst.x3.net16 _01_ 0.03127f
C5446 clknet_1_1__leaf_clk _25_/a_761_289# 0
C5447 dc_inst.x1.net5 dc_inst.x1.x8/a_27_47# 0
C5448 _25_/a_27_47# dc_inst.net5 0
C5449 _24_/a_27_47# _23_/a_193_47# 0
C5450 _24_/a_193_47# _23_/a_27_47# 0
C5451 dc_inst.x8/a_1290_413# dc_inst.x3.net16 0.00119f
C5452 clknet_1_0__leaf_clk delay_sel[2] 0
C5453 dc_inst.x3.net6 dc_inst.x3.net8 0.01852f
C5454 VPWR dc_inst.x7.net3 0.14144f
C5455 _06_ path[7] 0.08671f
C5456 dc_inst.x7.net17 _00_ 0
C5457 dc_inst.x1.net16 dc_inst.x1.x9/a_27_47# 0
C5458 path_sel[1] dc_inst.x1.x10/a_27_47# 0.02615f
C5459 dc_inst.x9/a_757_363# dc_inst.x7.x18/a_27_47# 0
C5460 dc_inst.x3.net1 dc_inst.x3.x10/a_27_47# 0.00215f
C5461 dc_inst.x10/a_439_47# dc_inst.in 0
C5462 dc_inst.net2 shadow_q 0.00255f
C5463 dc_inst.in _01_ 0.00794f
C5464 _16_/a_229_47# path[3] 0
C5465 _15_/a_1281_47# path[7] 0.00178f
C5466 _25_/a_1108_47# _25_/a_193_47# -0.00207f
C5467 dc_inst.x3.x19/a_27_47# dc_inst.x3.x18/a_27_47# 0
C5468 dc_inst.x8/a_1290_413# dc_inst.in 0
C5469 dc_inst.x9/a_923_363# dc_inst.x6.net11 0
C5470 capture_d _23_/a_651_413# 0.00353f
C5471 dc_inst.x5.net9 dc_inst.x2.x11/a_27_47# 0
C5472 dc_inst.x2.net15 dc_inst.x1.net14 0
C5473 tdi path[7] 0.08126f
C5474 dc_inst.x3.net16 _02_ 0
C5475 _20_/a_384_47# _15_/a_788_316# 0
C5476 dc_inst.x4.net19 dc_inst.x5.net13 0
C5477 dc_inst.x6.x8/a_27_47# dc_inst.x6.net6 0.00477f
C5478 dc_inst.x5.net12 dc_inst.x2.net5 0
C5479 dc_inst.x4.x19/a_27_47# dc_inst.x4.net15 0.00119f
C5480 dc_inst.x4.net9 tdo 0.18134f
C5481 dc_inst.net6 dc_inst.x9/a_923_363# 0
C5482 dc_inst.x7.net2 dc_inst.x9/a_247_21# 0
C5483 clknet_1_0__leaf_clk dc_inst.x7.net17 0
C5484 dc_inst.x3.net19 path[4] 0
C5485 dc_inst.x1.net10 _18_/a_505_21# 0
C5486 dc_inst.x3.net7 dc_inst.x3.net18 0.00283f
C5487 dc_inst.x5.x10/a_27_47# dc_inst.x2.net12 0
C5488 dc_inst.x2.net7 dc_inst.x5.net4 0
C5489 dc_inst.x9/a_247_21# dc_inst.x7.net1 0.0121f
C5490 dc_inst.x4.net13 dc_inst.x6.net10 0
C5491 dc_inst.x7.net6 clkbuf_1_0__f_clk/a_110_47# 0
C5492 dc_inst.net5 dc_inst.x7.x4/a_27_47# 0.06962f
C5493 dc_inst.x7.net14 delay_sel[1] 0
C5494 dc_inst.x2.net7 dc_inst.x2.x4/a_27_47# 0.00127f
C5495 dc_inst.x2.net10 dc_inst.x5.net4 0
C5496 dc_inst.net7 _25_/a_1270_413# 0
C5497 dc_inst.x7.net4 dc_inst.net8 0.05848f
C5498 path[3] path[7] 0.00296f
C5499 _07_ path_sel[2] 0
C5500 VPWR _23_/a_805_47# 0.00258f
C5501 dc_inst.x1.net4 path_sel[0] 0.03732f
C5502 dc_inst.x8/a_750_97# dc_inst.net2 0.03874f
C5503 dc_inst.net7 dc_inst.x7.net13 0
C5504 dc_inst.x1.x20/a_27_47# dc_inst.x6.net13 0
C5505 dc_inst.x3.net14 dc_inst.x3.x18/a_27_47# 0.01204f
C5506 path_sel[1] dc_inst.x6.net13 0
C5507 path_sel[2] dc_inst.x7.x4/a_27_47# 0.00196f
C5508 _24_/a_1108_47# shadow_q 0
C5509 dc_inst.x4.net19 dc_inst.x5.x16/a_27_47# 0
C5510 dc_inst.x6.x18/a_27_47# dc_inst.x8/a_27_413# 0
C5511 dc_inst.x5.net11 dc_inst.x2.x14/a_27_47# 0
C5512 dc_inst.x2.net14 dc_inst.x2.net5 0
C5513 path_sel[1] dc_inst.x5.net1 0.09645f
C5514 dc_inst.x4.net3 delay_sel[1] 0
C5515 dc_inst.x4.x2/a_27_47# dc_inst.x5.net6 0
C5516 dc_inst.x9/a_834_97# clkbuf_1_0__f_clk/a_110_47# 0
C5517 _24_/a_761_289# capture_d 0
C5518 dc_inst.x4.net4 dc_inst.x2.x3/a_27_47# 0
C5519 dc_inst.x2.x10/a_27_47# dc_inst.x2.x11/a_27_47# 0
C5520 rst path[7] 0.00125f
C5521 dc_inst.x3.net15 _23_/a_1217_47# 0
C5522 _01_ path[6] 0.01078f
C5523 _23_/a_1283_21# delay_sel[1] 0
C5524 _23_/a_543_47# dc_inst.net9 0
C5525 path_sel[0] dc_inst.x4.x14/a_27_47# 0.00261f
C5526 dc_inst.x5.net6 dc_inst.x1.x17/a_27_47# 0.00236f
C5527 dc_inst.x4.x1/a_27_47# _23_/a_193_47# 0
C5528 dc_inst.x2.net13 dc_inst.x5.x10/a_27_47# 0
C5529 dc_inst.x4.net19 dc_inst.x6.net2 0
C5530 dc_inst.x1.net8 dc_inst.x2.x18/a_27_47# 0
C5531 dc_inst.x6.x17/a_27_47# tdo 0.00353f
C5532 _24_/a_1283_21# _01_ 0.00174f
C5533 dc_inst.x8/a_1290_413# path[6] 0
C5534 _00_ _25_/a_1283_21# 0.04655f
C5535 dc_inst.x6.net16 dc_inst.x6.net19 0.01057f
C5536 dc_inst.x8/a_1290_413# _24_/a_1283_21# 0
C5537 dc_inst.net3 dc_inst.x9/a_1290_413# 0
C5538 dc_inst.net2 dc_inst.x3.x1/a_27_47# 0.04212f
C5539 dc_inst.x8/a_668_97# rst 0.00102f
C5540 dc_inst.x4.net6 dc_inst.x6.x10/a_27_47# 0
C5541 dc_inst.x7.x13/a_27_47# dc_inst.x7.x8/a_27_47# 0
C5542 dc_inst.x2.net11 dc_inst.x5.net12 0.00539f
C5543 dc_inst.x5.net5 dc_inst.x5.net8 0
C5544 dc_inst.x9/a_247_21# dc_inst.x7.net18 0
C5545 dc_inst.x3.net17 _01_ 0.00224f
C5546 VPWR dc_inst.x2.x18/a_27_47# 0.02005f
C5547 _06_ _10_ 0.01749f
C5548 _02_ path[6] 0.03484f
C5549 clknet_1_0__leaf_clk _25_/a_1283_21# 0
C5550 dc_inst.x2.net14 dc_inst.x4.x5/a_27_47# 0
C5551 dc_inst.x2.net10 _17_/a_174_21# 0
C5552 dc_inst.x1.x20/a_27_47# dc_inst.x4.net5 0.00872f
C5553 _24_/a_1283_21# _02_ 0.05984f
C5554 dc_inst.x9/a_1478_413# dc_inst.x6.x15/a_27_47# 0
C5555 dc_inst.x5.net6 dc_inst.x5.x10/a_27_47# 0
C5556 path_sel[1] dc_inst.x1.x3/a_27_47# 0.013f
C5557 path_sel[1] dc_inst.x4.net5 0.00224f
C5558 clkbuf_1_1__f_clk/a_110_47# _23_/a_193_47# 0
C5559 VPWR dc_inst.x3.x2/a_27_47# -0
C5560 dc_inst.x2.net6 dc_inst.x5.x4/a_27_47# 0.00259f
C5561 dc_inst.x6.net5 dc_inst.x7.net6 0
C5562 dc_inst.x3.net2 dc_inst.x2.net17 0
C5563 dc_inst.x1.x7/a_27_47# dc_inst.x5.net1 0
C5564 dc_inst.x8/a_668_97# clknet_1_1__leaf_clk 0
C5565 dc_inst.x1.x13/a_27_47# dc_inst.x3.x20/a_27_47# 0
C5566 dc_inst.x4.net19 dc_inst.x4.x20/a_27_47# 0.01436f
C5567 path_sel[1] dc_inst.x5.x17/a_27_47# 0.00658f
C5568 tdo dc_inst.net9 0.03396f
C5569 dc_inst.net4 dc_inst.x6.net8 0.00364f
C5570 _09_ path_sel[2] 0
C5571 dc_inst.x7.net9 dc_inst.x7.net6 0
C5572 dc_inst.x3.net17 _02_ 0
C5573 dc_inst.x5.x20/a_27_47# dc_inst.x9/a_27_413# 0
C5574 dc_inst.x3.net16 dc_inst.in 0
C5575 dc_inst.x5.x13/a_27_47# dc_inst.x4.net17 0
C5576 _06_ _15_/a_872_316# 0
C5577 dc_inst.x3.x19/a_27_47# dc_inst.x3.x4/a_27_47# 0.02448f
C5578 _24_/a_1108_47# dc_inst.x3.x1/a_27_47# 0
C5579 dc_inst.x6.x11/a_27_47# dc_inst.x6.net2 0
C5580 dc_inst.x2.net14 dc_inst.x2.net11 0.00141f
C5581 dc_inst.net6 dc_inst.x7.x4/a_27_47# 0
C5582 dc_inst.x6.net7 path_sel[0] 0
C5583 dc_inst.x6.x9/a_27_47# dc_inst.x7.x4/a_27_47# 0
C5584 tdo dc_inst.x6.x13/a_27_47# 0.00974f
C5585 _10_ path[3] 0.16291f
C5586 dc_inst.x7.net1 _25_/a_543_47# 0.01069f
C5587 dc_inst.x7.net4 dc_inst.x7.x4/a_27_47# 0.02609f
C5588 dc_inst.x4.net19 VPWR 0.17011f
C5589 dc_inst.x3.net4 dc_inst.x7.x3/a_27_47# 0
C5590 dc_inst.x4.net13 dc_inst.x5.x8/a_27_47# 0
C5591 dc_inst.x1.net11 dc_inst.x1.x11/a_27_47# 0.0032f
C5592 dc_inst.x4.net15 dc_inst.x5.net9 0
C5593 _18_/a_218_374# path_sel[0] 0
C5594 VPWR dc_inst.x3.net11 0.21192f
C5595 dc_inst.x1.x7/a_27_47# dc_inst.x4.net5 0
C5596 dc_inst.net4 dc_inst.x6.x12/a_27_47# 0.00629f
C5597 dc_inst.x4.x2/a_27_47# path_sel[2] 0.00628f
C5598 dc_inst.x7.net1 _25_/a_639_47# 0.00136f
C5599 dc_inst.x5.x4/a_27_47# dc_inst.x2.net12 0.00101f
C5600 dc_inst.x6.net5 tdo 0
C5601 dc_inst.x3.net14 dc_inst.x3.net8 0.08559f
C5602 dc_inst.x5.net8 dc_inst.x5.net9 0.23256f
C5603 dc_inst.x4.x17/a_27_47# dc_inst.x4.x12/a_27_47# 0
C5604 path_sel[2] dc_inst.x1.x17/a_27_47# 0
C5605 _10_ _19_/a_27_47# 0.0423f
C5606 dc_inst.x2.net15 delay_sel[1] 0
C5607 dc_inst.x9/a_750_97# dc_inst.x9/a_834_97# -0
C5608 dc_inst.x5.net6 dc_inst.x6.x15/a_27_47# 0
C5609 dc_inst.x5.net12 dc_inst.x4.x12/a_27_47# 0
C5610 _05_ _02_ 0.13601f
C5611 clkbuf_1_1__f_clk/a_110_47# dc_inst.x3.net2 0
C5612 _13_/a_112_47# capture_q 0.05301f
C5613 dc_inst.x3.net14 dc_inst.x3.x4/a_27_47# 0
C5614 dc_inst.x2.net4 dc_inst.x1.x19/a_27_47# 0
C5615 dc_inst.x5.net12 dc_inst.x2.x11/a_27_47# 0.01018f
C5616 dc_inst.x4.x3/a_27_47# dc_inst.net8 0
C5617 dc_inst.x3.x5/a_27_47# dc_inst.x3.x2/a_27_47# 0
C5618 dc_inst.x6.x11/a_27_47# dc_inst.x4.x20/a_27_47# 0.01198f
C5619 path[5] dc_inst.x3.x2/a_27_47# 0.00375f
C5620 dc_inst.x1.net10 dc_inst.x5.x12/a_27_47# 0.04222f
C5621 dc_inst.x9/a_750_97# tdo 0.00479f
C5622 dc_inst.x3.x8/a_27_47# dc_inst.x3.net8 0.01443f
C5623 path_sel[1] dc_inst.x4.net17 0.04393f
C5624 dc_inst.x5.net7 dc_inst.x4.net11 0
C5625 dc_inst.x1.x14/a_27_47# dc_inst.x2.net16 0.00145f
C5626 _23_/a_27_47# delay_sel[1] 0
C5627 dc_inst.x3.net18 dc_inst.x1.net3 0.0036f
C5628 dc_inst.x7.net7 dc_inst.x9/a_27_413# 0
C5629 tdo dc_inst.x4.x14/a_27_47# 0.00455f
C5630 _20_/a_79_21# dc_inst.x1.x12/a_27_47# 0
C5631 dc_inst.x6.net10 dc_inst.x7.x4/a_27_47# 0
C5632 dc_inst.x3.net16 path[6] 0.03352f
C5633 _15_/a_600_345# _19_/a_193_297# 0
C5634 dc_inst.x6.net17 dc_inst.in 0.02785f
C5635 dc_inst.x2.x6/a_27_47# dc_inst.x5.net4 0.00139f
C5636 dc_inst.x7.net6 dc_inst.x6.net7 0
C5637 dc_inst.x1.net8 dc_inst.x1.net2 0
C5638 VPWR _24_/a_805_47# 0
C5639 dc_inst.x7.x13/a_27_47# dc_inst.x6.net2 -0
C5640 _24_/a_1283_21# dc_inst.x3.net16 0.00161f
C5641 dc_inst.net3 dc_inst.net8 0.05004f
C5642 dc_inst.x5.x4/a_27_47# dc_inst.x2.net13 0
C5643 dc_inst.x2.x6/a_27_47# dc_inst.x2.x4/a_27_47# 0
C5644 dc_inst.x4.net13 dc_inst.x2.net9 0
C5645 dc_inst.x5.x19/a_27_47# dc_inst.x6.net8 0.01947f
C5646 VPWR dc_inst.x6.x11/a_27_47# -0.01017f
C5647 dc_inst.x4.net19 dc_inst.x6.net6 0.26049f
C5648 dc_inst.x2.net14 dc_inst.x2.x11/a_27_47# 0
C5649 tdo _24_/a_448_47# 0
C5650 dc_inst.in path[6] 0.00136f
C5651 dc_inst.x4.x16/a_27_47# dc_inst.x2.net7 0
C5652 path_sel[1] dc_inst.x6.x4/a_27_47# 0
C5653 dc_inst.x4.net18 dc_inst.net4 0
C5654 dc_inst.x3.net16 dc_inst.x3.net17 0.01003f
C5655 VPWR dc_inst.x1.net2 0.10141f
C5656 dc_inst.x6.x3/a_27_47# dc_inst.x6.net2 0
C5657 dc_inst.x3.net11 path[5] 0.04331f
C5658 dc_inst.x7.net19 clknet_0_clk 0
C5659 delay_sel[0] dc_inst.x7.x8/a_27_47# 0
C5660 dc_inst.x3.net7 dc_inst.x1.net3 0
C5661 _15_/a_27_47# dc_inst.x3.net3 0
C5662 VPWR dc_inst.x4.net1 0.10976f
C5663 tdi dc_inst.x3.x11/a_27_47# 0
C5664 dc_inst.x3.x17/a_27_47# _00_ 0
C5665 dc_inst.x5.net6 dc_inst.x5.x4/a_27_47# 0
C5666 dc_inst.x5.x18/a_27_47# dc_inst.x6.net8 0
C5667 dc_inst.x1.net15 dc_inst.x1.net5 0
C5668 dc_inst.x6.x15/a_27_47# dc_inst.net5 0
C5669 dc_inst.x1.net11 _06_ 0
C5670 dc_inst.x7.x12/a_27_47# _25_/a_193_47# 0
C5671 dc_inst.x7.net3 dc_inst.net9 0.06888f
C5672 dc_inst.x6.net14 dc_inst.x4.net11 0
C5673 dc_inst.x7.net6 dc_inst.x9/a_277_47# 0
C5674 dc_inst.x2.x13/a_27_47# path[2] 0
C5675 dc_inst.x7.net19 clkbuf_0_clk/a_110_47# 0
C5676 dc_inst.x5.net12 dc_inst.x5.net14 0.00373f
C5677 delay_sel[2] _23_/a_543_47# 0.00856f
C5678 capture_d _23_/a_1108_47# 0
C5679 tdo dc_inst.x6.net7 0
C5680 _17_/a_174_21# _19_/a_193_297# 0
C5681 dc_inst.x6.x14/a_27_47# delay_sel[1] 0
C5682 _13_/a_470_297# dc_inst.x3.net18 0
C5683 dc_inst.x5.net18 dc_inst.x7.x8/a_27_47# 0
C5684 dc_inst.x7.net4 dc_inst.x4.x2/a_27_47# 0
C5685 dc_inst.x6.x15/a_27_47# path_sel[2] 0.00505f
C5686 dc_inst.x1.net7 _19_/a_109_297# 0
C5687 dc_inst.x7.net5 dc_inst.x7.x4/a_27_47# 0.00873f
C5688 VPWR dc_inst.x10/a_76_199# 0.00631f
C5689 dc_inst.x5.x18/a_27_47# dc_inst.x5.x19/a_27_47# 0
C5690 dc_inst.x4.x2/a_27_47# dc_inst.x1.net17 0
C5691 rst dc_inst.x8/a_247_21# 0.01183f
C5692 dc_inst.x1.net12 dc_inst.in 0
C5693 dc_inst.x3.net3 dc_inst.x1.x8/a_27_47# 0
C5694 dc_inst.x1.net17 dc_inst.x1.x17/a_27_47# 0.00217f
C5695 path_sel[1] dc_inst.x5.net17 0.00636f
C5696 dc_inst.x4.x9/a_27_47# dc_inst.x2.net7 0
C5697 dc_inst.x6.net15 delay_sel[1] 0
C5698 dc_inst.x6.net6 dc_inst.x6.x11/a_27_47# 0.01335f
C5699 dc_inst.x7.x13/a_27_47# VPWR 0.02398f
C5700 dc_inst.x9/a_277_47# dc_inst.x9/a_834_97# -0.00465f
C5701 dc_inst.x7.net2 dc_inst.x7.x8/a_27_47# 0
C5702 dc_inst.x4.x2/a_27_47# dc_inst.net1 0.00213f
C5703 dc_inst.x7.x16/a_27_47# capture_d 0
C5704 dc_inst.x3.x12/a_27_47# dc_inst.x3.net11 0.03631f
C5705 _08_ _17_/a_174_21# 0.00485f
C5706 dc_inst.x1.net11 path[3] 0.01656f
C5707 dc_inst.x4.x15/a_27_47# dc_inst.x5.x1/a_27_47# 0
C5708 dc_inst.x6.net2 dc_inst.x7.x5/a_27_47# 0
C5709 clkload0/a_27_47# dc_inst.in 0.00159f
C5710 _24_/a_1283_21# path[6] 0.00126f
C5711 clknet_1_1__leaf_clk dc_inst.x8/a_247_21# 0
C5712 dc_inst.x4.net2 dc_inst.x2.net18 0.01468f
C5713 _03_ delay_sel[0] 0
C5714 dc_inst.x1.x14/a_27_47# dc_inst.x2.x17/a_27_47# 0
C5715 path[5] dc_inst.x1.net2 0
C5716 dc_inst.x3.x18/a_27_47# dc_inst.x3.net3 0
C5717 dc_inst.x9/a_277_47# tdo 0.00354f
C5718 dc_inst.x3.x11/a_27_47# rst 0.01185f
C5719 dc_inst.x7.net19 dc_inst.x7.x15/a_27_47# 0.14241f
C5720 dc_inst.x3.net4 dc_inst.x3.net18 0.01333f
C5721 dc_inst.x6.x20/a_27_47# clknet_1_0__leaf_clk 0
C5722 dc_inst.x4.net19 dc_inst.x4.net9 0
C5723 VPWR dc_inst.x6.x3/a_27_47# 0.01938f
C5724 tdo delay_sel[2] 0.00435f
C5725 dc_inst.x3.net9 capture_q 0
C5726 dc_inst.x7.net2 dc_inst.x5.x6/a_27_47# 0
C5727 dc_inst.x5.net6 dc_inst.x5.x7/a_27_47# 0.11197f
C5728 dc_inst.x1.net11 _19_/a_27_47# 0.02914f
C5729 VPWR _20_/a_79_21# 0.00677f
C5730 _13_/a_470_297# dc_inst.x3.net7 0
C5731 dc_inst.x8/a_750_97# dc_inst.x2.x19/a_27_47# 0
C5732 dc_inst.x6.net4 dc_inst.x9/a_27_413# 0
C5733 dc_inst.x9/a_834_97# dc_inst.x7.net17 0.00178f
C5734 dc_inst.x3.net17 path[6] 0.03175f
C5735 dc_inst.x4.x17/a_27_47# dc_inst.x4.net15 0
C5736 dc_inst.x4.net16 dc_inst.x6.net13 0
C5737 dc_inst.x4.net15 dc_inst.x5.net12 0.00119f
C5738 dc_inst.x1.x13/a_27_47# dc_inst.x2.net15 0
C5739 dc_inst.net8 dc_inst.x10/a_535_374# 0
C5740 dc_inst.x1.net14 dc_inst.x1.net19 0
C5741 dc_inst.x10/a_505_21# _24_/a_193_47# 0
C5742 dc_inst.x1.x3/a_27_47# dc_inst.x3.net2 0.03068f
C5743 dc_inst.x7.x7/a_27_47# dc_inst.x7.x8/a_27_47# 0
C5744 dc_inst.x3.net1 dc_inst.x3.x14/a_27_47# 0.00107f
C5745 dc_inst.x5.net12 dc_inst.x5.net8 0
C5746 tdo dc_inst.x7.net17 0
C5747 dc_inst.x3.x9/a_27_47# path[6] 0
C5748 _24_/a_27_47# shadow_q 0
C5749 dc_inst.x6.x2/a_27_47# dc_inst.x6.net3 0.02762f
C5750 _03_ _23_/a_448_47# 0
C5751 dc_inst.x3.net15 rst 0
C5752 dc_inst.x6.x8/a_27_47# dc_inst.x6.net7 0.01149f
C5753 dc_inst.x1.net12 path[6] 0
C5754 dc_inst.x5.net3 dc_inst.x6.net9 0
C5755 dc_inst.x4.x15/a_27_47# dc_inst.x4.x18/a_27_47# 0.02448f
C5756 dc_inst.net4 dc_inst.x4.net7 0
C5757 dc_inst.x1.net13 dc_inst.net8 0
C5758 dc_inst.x1.x14/a_27_47# dc_inst.x2.net10 0
C5759 _03_ dc_inst.x7.net2 0
C5760 delay_sel[0] dc_inst.x6.net2 0
C5761 dc_inst.x1.net9 dc_inst.x1.net3 0
C5762 dc_inst.x5.net18 dc_inst.x5.x16/a_27_47# 0
C5763 dc_inst.x5.x9/a_27_47# dc_inst.x5.x10/a_27_47# 0.02448f
C5764 path_sel[2] dc_inst.x8/a_757_363# 0
C5765 _03_ dc_inst.x7.net1 0.00313f
C5766 _24_/a_193_47# rst 0.00278f
C5767 dc_inst.x7.net4 dc_inst.x6.x15/a_27_47# 0
C5768 dc_inst.x3.net1 path[7] 0.00659f
C5769 _15_/a_600_345# dc_inst.in 0
C5770 _05_ path[6] 0.06774f
C5771 dc_inst.x3.net15 clknet_1_1__leaf_clk 0
C5772 dc_inst.x1.x16/a_27_47# dc_inst.x8/a_247_21# 0
C5773 dc_inst.net4 dc_inst.x5.net6 0.00209f
C5774 dc_inst.x6.x15/a_27_47# dc_inst.x1.net17 0
C5775 _05_ _24_/a_1283_21# 0
C5776 capture_d _23_/a_193_47# 0.04618f
C5777 VPWR dc_inst.x7.x5/a_27_47# 0.05328f
C5778 dc_inst.x4.x10/a_27_47# dc_inst.x4.net5 0
C5779 dc_inst.x2.net11 dc_inst.x5.net11 0
C5780 dc_inst.x6.x3/a_27_47# dc_inst.x6.net6 0
C5781 dc_inst.x9/a_193_413# dc_inst.x6.net4 0
C5782 dc_inst.x7.net4 dc_inst.x7.x3/a_27_47# 0.00296f
C5783 dc_inst.x5.net18 dc_inst.x6.net2 0
C5784 _16_/a_229_47# path[1] 0.00826f
C5785 _20_/a_79_21# path[5] 0.00636f
C5786 dc_inst.x1.net4 dc_inst.x2.x18/a_27_47# 0
C5787 dc_inst.x6.net4 dc_inst.x6.x4/a_27_47# 0.12862f
C5788 _24_/a_193_47# clknet_1_1__leaf_clk 0.42586f
C5789 dc_inst.x3.net19 dc_inst.net8 0
C5790 _05_ dc_inst.x3.net17 0
C5791 dc_inst.x4.net1 dc_inst.x4.net9 0.14755f
C5792 VPWR dc_inst.x5.x11/a_27_47# 0.06647f
C5793 dc_inst.net1 dc_inst.x6.x15/a_27_47# 0
C5794 dc_inst.x1.x15/a_27_47# dc_inst.x1.net2 0.00173f
C5795 dc_inst.x1.net4 dc_inst.x3.x2/a_27_47# 0.135f
C5796 delay_sel[0] dc_inst.x8/a_277_47# 0.00876f
C5797 dc_inst.x5.net19 dc_inst.x6.x4/a_27_47# 0.00617f
C5798 dc_inst.x6.net12 dc_inst.x4.net11 0
C5799 dc_inst.x7.net2 dc_inst.x6.net2 0.22749f
C5800 dc_inst.x4.x2/a_27_47# dc_inst.x4.x3/a_27_47# 0.02448f
C5801 dc_inst.x6.net14 delay_sel[1] 0
C5802 path_sel[1] dc_inst.x2.net4 0.00783f
C5803 VPWR dc_inst.x2.net8 0.00856f
C5804 dc_inst.x3.x7/a_27_47# dc_inst.x3.x13/a_27_47# 0
C5805 dc_inst.x4.x13/a_27_47# dc_inst.x5.x1/a_27_47# 0.08729f
C5806 dc_inst.x4.x3/a_27_47# dc_inst.x1.x17/a_27_47# 0
C5807 dc_inst.x1.x12/a_27_47# dc_inst.x1.net6 0.04038f
C5808 _24_/a_27_47# _25_/a_1108_47# 0
C5809 dc_inst.x6.net2 dc_inst.x7.net1 0
C5810 path_sel[1] dc_inst.x2.x12/a_27_47# 0.01216f
C5811 delay_sel[0] dc_inst.x6.x1/a_27_47# 0
C5812 tdo _25_/a_1283_21# 0.0091f
C5813 dc_inst.x1.net9 dc_inst.x2.net12 0.00152f
C5814 dc_inst.x3.x6/a_27_47# dc_inst.x3.x13/a_27_47# 0
C5815 dc_inst.x4.net3 dc_inst.x2.net18 0.02096f
C5816 dc_inst.x8/a_750_97# dc_inst.x2.net17 0
C5817 dc_inst.x2.net16 dc_inst.x2.net19 0
C5818 dc_inst.x2.x5/a_27_47# dc_inst.x2.x4/a_27_47# 0.02448f
C5819 dc_inst.x1.x2/a_27_47# dc_inst.x1.net12 0.06922f
C5820 dc_inst.x2.net18 _23_/a_1283_21# 0
C5821 dc_inst.x3.x4/a_27_47# dc_inst.x3.net3 0.00146f
C5822 path[2] dc_inst.x1.x12/a_27_47# 0.00154f
C5823 VPWR delay_sel[0] 1.70302f
C5824 dc_inst.x5.net6 dc_inst.x6.net8 0
C5825 _09_ _18_/a_505_21# 0
C5826 dc_inst.x7.net3 delay_sel[2] 0.02515f
C5827 tdo _25_/a_805_47# 0
C5828 _15_/a_600_345# path[6] 0.00143f
C5829 VPWR _13_/a_470_47# -0
C5830 dc_inst.x7.net19 _25_/a_193_47# 0
C5831 dc_inst.x8/a_1478_413# dc_inst.x3.net3 0
C5832 path_sel[1] path[7] 0.13747f
C5833 dc_inst.x7.x7/a_27_47# dc_inst.x6.net2 0.02903f
C5834 dc_inst.net4 dc_inst.net5 0.04243f
C5835 dc_inst.x1.net4 dc_inst.x3.net11 0
C5836 dc_inst.x5.net3 dc_inst.x5.net7 0.14017f
C5837 dc_inst.x4.net19 dc_inst.x6.net5 0
C5838 tdo dc_inst.x1.net16 0
C5839 clkbuf_1_1__f_clk/a_110_47# shadow_q 0.02267f
C5840 dc_inst.x8/a_27_47# dc_inst.x3.net2 0
C5841 dc_inst.x4.x1/a_27_47# dc_inst.x8/a_750_97# 0
C5842 dc_inst.x4.net16 dc_inst.x4.net17 0.19602f
C5843 dc_inst.x5.net11 dc_inst.x2.x11/a_27_47# 0
C5844 VPWR dc_inst.x5.net18 0.05512f
C5845 dc_inst.x7.net4 dc_inst.x8/a_757_363# 0.00725f
C5846 dc_inst.x4.x13/a_27_47# dc_inst.x5.net15 0
C5847 dc_inst.x7.net3 dc_inst.x7.net17 0
C5848 dc_inst.x4.net4 tdo 0
C5849 dc_inst.x5.net6 dc_inst.x5.x19/a_27_47# 0
C5850 dc_inst.x5.net17 dc_inst.x5.net19 0.02282f
C5851 dc_inst.x3.x10/a_27_47# dc_inst.x3.net12 0.00552f
C5852 dc_inst.x7.net2 dc_inst.x6.x1/a_27_47# 0.03115f
C5853 dc_inst.net4 path_sel[2] 0.04836f
C5854 VPWR _23_/a_448_47# 0.00221f
C5855 dc_inst.x4.x13/a_27_47# dc_inst.x4.x18/a_27_47# 0
C5856 dc_inst.x2.net6 dc_inst.x2.net12 0.02099f
C5857 _15_/a_288_47# _06_ 0
C5858 dc_inst.x4.x6/a_27_47# dc_inst.x5.x6/a_27_47# 0
C5859 _23_/a_805_47# delay_sel[2] 0
C5860 _13_/a_470_297# dc_inst.x1.net3 0
C5861 dc_inst.x4.net13 dc_inst.x4.net12 0.26892f
C5862 dc_inst.x4.net13 dc_inst.x2.x7/a_27_47# 0
C5863 _15_/a_372_413# dc_inst.x1.net2 0
C5864 VPWR dc_inst.x7.net2 0.12296f
C5865 dc_inst.net4 dc_inst.x6.x7/a_27_47# 0
C5866 dc_inst.x4.net10 dc_inst.x5.net7 0.0479f
C5867 dc_inst.net1 dc_inst.x8/a_757_363# 0
C5868 _15_/a_600_345# dc_inst.x1.net12 0
C5869 VPWR dc_inst.x7.net1 0.54004f
C5870 dc_inst.x8/a_834_97# dc_inst.x4.net3 0
C5871 _17_/a_478_47# dc_inst.x1.net6 0
C5872 dc_inst.x5.net6 dc_inst.x1.net9 0
C5873 dc_inst.x2.x16/a_27_47# dc_inst.x2.net16 0.04145f
C5874 dc_inst.x1.x16/a_27_47# dc_inst.x1.net14 0
C5875 delay_sel[0] dc_inst.x6.net6 0
C5876 dc_inst.x2.net9 dc_inst.x1.x17/a_27_47# 0
C5877 dc_inst.x8/a_834_97# _23_/a_1283_21# 0
C5878 _20_/a_470_297# _20_/a_384_47# -0
C5879 dc_inst.x7.x13/a_27_47# clkbuf_1_0__f_clk/a_110_47# 0
C5880 _04_ dc_inst.x1.net7 0
C5881 dc_inst.x9/a_247_21# dc_inst.x7.x6/a_27_47# 0
C5882 _13_/a_470_47# dc_inst.x3.x5/a_27_47# 0
C5883 dc_inst.net5 dc_inst.x6.net8 0
C5884 dc_inst.x3.net1 _15_/a_872_316# 0
C5885 dc_inst.x7.net16 capture_d 0
C5886 dc_inst.x5.x1/a_27_47# dc_inst.x5.net15 0
C5887 dc_inst.x5.x14/a_27_47# dc_inst.x5.net15 0
C5888 path[2] _17_/a_478_47# 0.00468f
C5889 dc_inst.x6.net5 dc_inst.x6.x11/a_27_47# 0
C5890 dc_inst.x1.net4 dc_inst.x1.net2 0.03375f
C5891 dc_inst.x4.net1 dc_inst.x6.x13/a_27_47# 0
C5892 dc_inst.x2.net6 dc_inst.x2.net13 0.00394f
C5893 dc_inst.x1.net15 dc_inst.x2.net16 0.10728f
C5894 dc_inst.x4.x3/a_27_47# dc_inst.x7.x3/a_27_47# 0
C5895 dc_inst.x4.x5/a_27_47# dc_inst.x4.net5 0.0134f
C5896 dc_inst.x1.net1 dc_inst.x1.net11 0.0047f
C5897 VPWR dc_inst.x1.net6 0.16247f
C5898 VPWR dc_inst.x7.x7/a_27_47# -0.00759f
C5899 dc_inst.x2.net18 dc_inst.x2.net15 0.00488f
C5900 _24_/a_193_47# _23_/a_651_413# 0
C5901 dc_inst.x10/a_76_199# dc_inst.net9 0.00533f
C5902 dc_inst.x8/a_1290_413# dc_inst.x1.x14/a_27_47# 0
C5903 path_sel[1] dc_inst.x1.x1/a_27_47# 0
C5904 dc_inst.x4.net7 dc_inst.x2.net6 0
C5905 dc_inst.x1.net10 dc_inst.x1.x9/a_27_47# 0.0032f
C5906 dc_inst.x6.net8 path_sel[2] 0.00407f
C5907 dc_inst.x1.net15 dc_inst.x3.net3 0
C5908 dc_inst.x5.net6 dc_inst.x4.x11/a_27_47# 0
C5909 clkbuf_1_1__f_clk/a_110_47# dc_inst.x3.x1/a_27_47# 0
C5910 dc_inst.x2.x12/a_27_47# dc_inst.x2.x14/a_27_47# 0
C5911 VPWR path[2] 0.11243f
C5912 dc_inst.x7.net3 _25_/a_1283_21# 0
C5913 dc_inst.x4.net19 dc_inst.x6.net7 0.1392f
C5914 dc_inst.net4 dc_inst.x6.net11 0.11222f
C5915 dc_inst.x6.x7/a_27_47# dc_inst.x6.net8 0.0147f
C5916 dc_inst.x5.net6 dc_inst.x2.net6 0.4225f
C5917 dc_inst.x6.x12/a_27_47# dc_inst.net5 0.0115f
C5918 dc_inst.x6.net14 dc_inst.x4.net10 0
C5919 dc_inst.x4.net2 dc_inst.x8/a_277_47# 0
C5920 dc_inst.x4.net6 tdo 0.02102f
C5921 path_sel[1] _10_ 0
C5922 dc_inst.x5.x19/a_27_47# path_sel[2] 0.00585f
C5923 dc_inst.net6 dc_inst.net4 0.21467f
C5924 delay_sel[1] rst 0
C5925 dc_inst.x4.net2 dc_inst.x1.net8 0
C5926 VPWR dc_inst.x7.net18 0.6854f
C5927 dc_inst.x6.net12 delay_sel[1] 0
C5928 dc_inst.x4.net1 dc_inst.x4.x14/a_27_47# 0
C5929 dc_inst.x7.x18/a_27_47# dc_inst.x6.x1/a_27_47# 0
C5930 _15_/a_1279_413# path_sel[0] 0.00102f
C5931 dc_inst.x6.x12/a_27_47# path_sel[2] 0.01367f
C5932 dc_inst.x7.net4 dc_inst.net4 0.07217f
C5933 dc_inst.x2.net13 dc_inst.x2.net12 0.19109f
C5934 dc_inst.x1.net7 dc_inst.x1.net5 0.04787f
C5935 VPWR dc_inst.x7.x18/a_27_47# 0
C5936 dc_inst.x3.x20/a_27_47# dc_inst.x1.net8 0
C5937 path_sel[1] dc_inst.x5.net16 0.01993f
C5938 dc_inst.x4.net7 dc_inst.x2.net12 0
C5939 _03_ _23_/a_1283_21# 0
C5940 VPWR dc_inst.x4.net2 0.15434f
C5941 dc_inst.x5.x18/a_27_47# path_sel[2] 0.00524f
C5942 _24_/a_761_289# _24_/a_193_47# -0.01126f
C5943 _24_/a_543_47# _24_/a_27_47# -0.00297f
C5944 clknet_1_1__leaf_clk delay_sel[1] 0
C5945 dc_inst.x1.net9 path_sel[2] 0.04627f
C5946 dc_inst.x3.net1 dc_inst.x3.x11/a_27_47# 0.01399f
C5947 dc_inst.x7.x13/a_27_47# dc_inst.x7.net9 0.01157f
C5948 dc_inst.net2 dc_inst.x2.net16 0
C5949 dc_inst.x6.x20/a_27_47# dc_inst.x9/a_834_97# 0
C5950 dc_inst.x5.net6 dc_inst.x2.net12 0.01534f
C5951 dc_inst.x4.x3/a_27_47# dc_inst.x8/a_757_363# 0
C5952 VPWR dc_inst.x3.x20/a_27_47# 0.02924f
C5953 dc_inst.x7.x9/a_27_47# dc_inst.x5.x20/a_27_47# 0.00104f
C5954 dc_inst.x6.net11 dc_inst.x6.net8 0
C5955 dc_inst.net2 dc_inst.x3.net3 0.00735f
C5956 dc_inst.x2.x16/a_27_47# dc_inst.x2.x17/a_27_47# 0
C5957 dc_inst.x3.net15 dc_inst.x3.x15/a_27_47# 0.04362f
C5958 dc_inst.x6.x20/a_27_47# tdo 0
C5959 dc_inst.x6.net10 dc_inst.net4 0.02571f
C5960 dc_inst.x8/a_668_97# _23_/a_193_47# 0
C5961 dc_inst.x8/a_834_97# _23_/a_27_47# 0
C5962 path[1] _17_/a_574_297# 0
C5963 dc_inst.x6.x9/a_27_47# dc_inst.x6.net8 0.00453f
C5964 VPWR dc_inst.x5.net10 -0.00853f
C5965 dc_inst.x4.x11/a_27_47# path_sel[2] 0
C5966 VPWR dc_inst.x3.net13 0.1668f
C5967 dc_inst.x3.net15 dc_inst.x3.net1 0
C5968 dc_inst.x1.net15 dc_inst.x2.x17/a_27_47# 0.04722f
C5969 dc_inst.x4.net1 dc_inst.x6.net7 0
C5970 dc_inst.x3.net2 dc_inst.x3.x14/a_27_47# 0
C5971 dc_inst.x5.x19/a_27_47# dc_inst.x6.net11 0
C5972 dc_inst.net3 dc_inst.x8/a_757_363# 0.04671f
C5973 path_sel[2] dc_inst.x1.net3 0.24619f
C5974 dc_inst.x2.net18 dc_inst.x6.net15 0
C5975 dc_inst.x8/a_750_97# dc_inst.x1.x3/a_27_47# 0
C5976 dc_inst.x8/a_750_97# dc_inst.x4.net5 0
C5977 dc_inst.x2.net6 path_sel[2] 0
C5978 delay_sel[0] dc_inst.x6.x17/a_27_47# 0
C5979 dc_inst.x1.x13/a_27_47# dc_inst.x1.net19 0
C5980 clknet_0_clk _01_ 0.00269f
C5981 dc_inst.x3.x18/a_27_47# _02_ 0
C5982 dc_inst.x5.net6 dc_inst.x2.net13 0.00143f
C5983 dc_inst.x6.x12/a_27_47# dc_inst.x6.net11 0.01776f
C5984 VPWR dc_inst.x4.x6/a_27_47# 0.00173f
C5985 delay_sel[2] _24_/a_805_47# 0
C5986 dc_inst.x7.net6 dc_inst.x9/a_27_47# 0
C5987 delay_sel[0] clkbuf_1_0__f_clk/a_110_47# 0.00435f
C5988 _13_/a_27_297# dc_inst.x3.x11/a_27_47# 0
C5989 dc_inst.x3.net5 path[7] 0
C5990 VPWR _13_/a_112_47# 0.04023f
C5991 dc_inst.net6 dc_inst.x6.x12/a_27_47# 0.0012f
C5992 dc_inst.x5.net6 dc_inst.x4.net7 0.14758f
C5993 dc_inst.x6.x19/a_27_47# tdo 0.00775f
C5994 dc_inst.x2.x16/a_27_47# dc_inst.x2.net10 0
C5995 dc_inst.x5.net5 dc_inst.x2.net7 0.05888f
C5996 dc_inst.x5.x18/a_27_47# dc_inst.x6.net11 0
C5997 dc_inst.x3.net10 path[4] 0.00282f
C5998 dc_inst.x3.net2 path[7] 0
C5999 dc_inst.x7.net4 dc_inst.x6.x12/a_27_47# 0
C6000 dc_inst.x8/a_193_413# dc_inst.x4.x4/a_27_47# 0
C6001 dc_inst.x1.x14/a_27_47# dc_inst.in 0.00178f
C6002 dc_inst.x2.net1 dc_inst.x2.x13/a_27_47# 0.01152f
C6003 clknet_0_clk _02_ 0.00262f
C6004 dc_inst.x4.net14 dc_inst.x5.net7 0
C6005 dc_inst.x4.net3 dc_inst.x8/a_277_47# 0
C6006 dc_inst.x5.x1/a_27_47# dc_inst.x6.x6/a_27_47# 0
C6007 VPWR dc_inst.x7.net14 0.01967f
C6008 dc_inst.x7.net11 dc_inst.x7.net1 0.03395f
C6009 dc_inst.x6.net10 dc_inst.x6.net8 0.00212f
C6010 dc_inst.x2.x9/a_27_47# dc_inst.x2.net7 0.00138f
C6011 _23_/a_1283_21# dc_inst.x8/a_277_47# 0
C6012 dc_inst.x8/a_668_97# dc_inst.x3.net2 0
C6013 dc_inst.net4 dc_inst.x7.net5 0.04416f
C6014 dc_inst.x5.x7/a_27_47# dc_inst.x5.x8/a_27_47# 0.02448f
C6015 dc_inst.x2.x9/a_27_47# dc_inst.x2.net10 0.00877f
C6016 dc_inst.x4.net3 dc_inst.x1.net8 0
C6017 dc_inst.net7 delay_sel[1] 0.10244f
C6018 delay_sel[0] dc_inst.net9 0.02947f
C6019 dc_inst.x9/a_750_97# dc_inst.x7.x5/a_27_47# 0
C6020 dc_inst.x7.net2 dc_inst.x6.x17/a_27_47# 0.02662f
C6021 dc_inst.x3.net15 _13_/a_27_297# 0
C6022 clknet_0_clk _25_/a_448_47# 0
C6023 dc_inst.x4.net4 dc_inst.x2.x18/a_27_47# 0
C6024 path_sel[2] dc_inst.x2.net12 0.00192f
C6025 dc_inst.x3.net13 path[5] 0.02625f
C6026 _15_/a_788_316# dc_inst.x3.x7/a_27_47# 0
C6027 _03_ _23_/a_27_47# 0.00352f
C6028 dc_inst.x7.x2/a_27_47# _00_ 0
C6029 clknet_0_clk dc_inst.x7.net12 0
C6030 dc_inst.x1.net9 dc_inst.x1.net17 0
C6031 path_sel[1] dc_inst.x1.net11 0.08633f
C6032 dc_inst.x2.net7 dc_inst.x2.net3 0.01358f
C6033 _15_/a_27_47# dc_inst.in 0.00642f
C6034 _14_/a_505_21# _00_ 0
C6035 clkbuf_1_1__f_clk/a_110_47# _24_/a_543_47# 0.00694f
C6036 dc_inst.x7.net3 dc_inst.x3.x17/a_27_47# 0
C6037 dc_inst.x6.net10 dc_inst.x5.x19/a_27_47# 0
C6038 dc_inst.x4.net3 VPWR 0.10454f
C6039 dc_inst.x7.x20/a_27_47# clknet_1_0__leaf_clk 0
C6040 dc_inst.x2.x17/a_27_47# dc_inst.net2 0
C6041 dc_inst.x2.x2/a_27_47# dc_inst.x5.net7 0.03645f
C6042 dc_inst.x9/a_1478_413# path_sel[2] 0.00112f
C6043 dc_inst.x10/a_218_374# capture_d 0.00289f
C6044 clkbuf_1_0__f_clk/a_110_47# dc_inst.x7.net1 0.05314f
C6045 dc_inst.x10/a_76_199# delay_sel[2] 0.00322f
C6046 dc_inst.x4.x12/a_27_47# dc_inst.x4.net17 0.00525f
C6047 dc_inst.x4.net18 dc_inst.x6.net11 0
C6048 dc_inst.x2.net17 dc_inst.x1.net5 0
C6049 capture_d shadow_q 0
C6050 _13_/a_27_297# _24_/a_193_47# 0
C6051 VPWR _23_/a_1283_21# 0.01534f
C6052 dc_inst.net4 dc_inst.x4.x8/a_27_47# 0
C6053 dc_inst.x6.net10 dc_inst.x6.x12/a_27_47# 0.01151f
C6054 dc_inst.x1.net4 delay_sel[0] 0
C6055 capture_q rst 0
C6056 path[4] path_sel[0] 0.15543f
C6057 dc_inst.x7.x13/a_27_47# dc_inst.x9/a_277_47# 0.003f
C6058 _23_/a_448_47# dc_inst.net9 0
C6059 clknet_1_0__leaf_clk dc_inst.x7.x2/a_27_47# 0
C6060 dc_inst.x4.net18 dc_inst.x6.x9/a_27_47# 0
C6061 dc_inst.x6.x6/a_27_47# dc_inst.x5.net15 0
C6062 _13_/a_112_47# dc_inst.x3.x5/a_27_47# 0
C6063 _13_/a_112_47# path[5] 0.00326f
C6064 dc_inst.x6.net5 delay_sel[0] 0
C6065 dc_inst.x5.x6/a_27_47# dc_inst.x6.x14/a_27_47# 0.01254f
C6066 dc_inst.x6.net16 dc_inst.x6.x16/a_27_47# 0.01506f
C6067 dc_inst.x6.net10 dc_inst.x5.x18/a_27_47# 0
C6068 dc_inst.x5.net9 dc_inst.x2.net7 0.06031f
C6069 dc_inst.x1.x4/a_27_47# dc_inst.in 0.03315f
C6070 dc_inst.x7.net2 dc_inst.net9 0
C6071 dc_inst.in dc_inst.x1.x8/a_27_47# 0.03443f
C6072 dc_inst.x5.net9 dc_inst.x2.net10 0.01307f
C6073 dc_inst.x7.net9 delay_sel[0] 0
C6074 dc_inst.x4.net8 dc_inst.x4.x7/a_27_47# 0.01543f
C6075 dc_inst.x2.net13 path_sel[2] 0.00235f
C6076 path[3] _19_/a_465_47# 0
C6077 capture_q clknet_1_1__leaf_clk 0.00249f
C6078 dc_inst.x3.net2 dc_inst.x1.x1/a_27_47# 0
C6079 dc_inst.x3.x4/a_27_47# _01_ 0
C6080 dc_inst.net5 dc_inst.x7.x19/a_27_47# 0
C6081 dc_inst.net7 dc_inst.x9/a_757_363# 0.00419f
C6082 dc_inst.x3.net15 _23_/a_1108_47# 0
C6083 delay_sel[0] dc_inst.x9/a_750_97# 0.39033f
C6084 dc_inst.x5.net3 dc_inst.x5.x5/a_27_47# 0.04903f
C6085 dc_inst.x2.net6 dc_inst.x1.net17 0
C6086 dc_inst.x1.x7/a_27_47# dc_inst.x1.net11 0
C6087 dc_inst.x4.net7 path_sel[2] 0.00478f
C6088 dc_inst.x4.x16/a_27_47# dc_inst.x4.x18/a_27_47# 0.08729f
C6089 dc_inst.x3.x10/a_27_47# dc_inst.x3.net6 0.03054f
C6090 dc_inst.x3.x12/a_27_47# dc_inst.x3.net13 0.03413f
C6091 dc_inst.x8/a_1290_413# dc_inst.x2.net19 0
C6092 dc_inst.x6.net14 dc_inst.x2.net18 0
C6093 se _13_/a_470_47# 0
C6094 dc_inst.x3.net8 _02_ 0.13594f
C6095 dc_inst.x8/a_1290_413# dc_inst.x8/a_1478_413# -0.00478f
C6096 dc_inst.x7.net9 dc_inst.x5.net18 0
C6097 _19_/a_465_47# _19_/a_27_47# -0
C6098 dc_inst.x2.x20/a_27_47# dc_inst.net8 0
C6099 dc_inst.x9/a_1290_413# clknet_1_0__leaf_clk 0
C6100 dc_inst.x7.x15/a_27_47# dc_inst.x7.net12 0.00243f
C6101 path_sel[1] dc_inst.x4.net11 0.02019f
C6102 path_sel[1] dc_inst.x1.net14 0.03436f
C6103 dc_inst.x5.net6 path_sel[2] 0.00829f
C6104 _24_/a_193_47# _23_/a_1108_47# 0
C6105 _15_/a_27_47# path[6] 0.04643f
C6106 dc_inst.x2.net4 dc_inst.x2.net5 0.03371f
C6107 dc_inst.x3.x4/a_27_47# _02_ 0
C6108 dc_inst.x2.net15 dc_inst.x8/a_277_47# 0
C6109 clkbuf_1_0__f_clk/a_110_47# dc_inst.x7.net18 0.01181f
C6110 _24_/a_651_413# _00_ 0.02637f
C6111 dc_inst.x6.x12/a_27_47# dc_inst.x7.net5 0
C6112 dc_inst.x6.x19/a_27_47# dc_inst.x7.net3 0
C6113 path[5] _23_/a_1283_21# 0
C6114 dc_inst.x2.net2 dc_inst.x2.net6 0
C6115 VPWR dc_inst.x3.net9 0.00405f
C6116 dc_inst.x8/a_1478_413# _02_ 0
C6117 delay_sel[0] _24_/a_448_47# 0
C6118 dc_inst.x1.net8 dc_inst.x2.net15 0.00364f
C6119 dc_inst.x7.net2 dc_inst.x7.net9 0.00172f
C6120 dc_inst.x1.x14/a_27_47# dc_inst.x1.net12 0
C6121 clknet_0_clk dc_inst.in 0
C6122 dc_inst.x6.net18 dc_inst.x2.net18 0.00256f
C6123 dc_inst.x5.net14 dc_inst.x4.net17 0
C6124 dc_inst.x2.x10/a_27_47# dc_inst.x2.net7 0
C6125 capture_d _25_/a_1108_47# 0
C6126 _23_/a_27_47# dc_inst.x8/a_277_47# 0
C6127 dc_inst.x7.x18/a_27_47# clkbuf_1_0__f_clk/a_110_47# 0
C6128 dc_inst.x3.net12 dc_inst.x3.x14/a_27_47# 0.1104f
C6129 dc_inst.net6 dc_inst.x9/a_1478_413# 0
C6130 dc_inst.x7.net2 dc_inst.x9/a_750_97# 0.03087f
C6131 _15_/a_27_47# dc_inst.x3.net17 0
C6132 dc_inst.x2.net6 dc_inst.x5.x9/a_27_47# 0
C6133 dc_inst.x2.x10/a_27_47# dc_inst.x2.net10 0.05308f
C6134 dc_inst.x7.net9 dc_inst.x7.net1 0
C6135 dc_inst.x6.net19 dc_inst.in 0
C6136 dc_inst.x5.net2 dc_inst.x4.x15/a_27_47# 0
C6137 dc_inst.x6.net9 dc_inst.x6.net2 0
C6138 dc_inst.x7.x9/a_27_47# dc_inst.x5.net19 0.03292f
C6139 _03_ _23_/a_1217_47# 0
C6140 clkbuf_1_1__f_clk/a_110_47# dc_inst.x3.net14 0
C6141 dc_inst.x1.x4/a_27_47# path[6] 0
C6142 dc_inst.x1.x6/a_27_47# path[4] 0
C6143 dc_inst.x9/a_750_97# dc_inst.x7.net1 0
C6144 dc_inst.x7.net4 dc_inst.x9/a_1478_413# 0
C6145 VPWR dc_inst.x2.net15 0.05007f
C6146 dc_inst.x5.x6/a_27_47# dc_inst.x5.net7 0.00319f
C6147 dc_inst.x1.net16 dc_inst.x1.net2 0
C6148 dc_inst.x1.x10/a_27_47# dc_inst.x1.net5 0
C6149 dc_inst.net4 dc_inst.x9/a_668_97# 0
C6150 dc_inst.x1.x7/a_27_47# dc_inst.x1.net14 0
C6151 dc_inst.x4.net4 dc_inst.x1.net2 0
C6152 _15_/a_27_47# dc_inst.x1.net12 0
C6153 dc_inst.x3.x10/a_27_47# _04_ 0
C6154 VPWR _23_/a_27_47# 0.0953f
C6155 dc_inst.x3.net12 path[7] 0.06234f
C6156 dc_inst.x7.x7/a_27_47# dc_inst.x7.net9 0
C6157 dc_inst.x4.net7 dc_inst.x6.net11 0
C6158 dc_inst.x4.x3/a_27_47# dc_inst.x1.net9 0
C6159 dc_inst.x3.net17 dc_inst.x1.x8/a_27_47# 0
C6160 dc_inst.x8/a_1290_413# dc_inst.x2.x16/a_27_47# 0
C6161 dc_inst.x3.x18/a_27_47# path[6] 0.00127f
C6162 dc_inst.net1 dc_inst.x9/a_1478_413# 0.0228f
C6163 dc_inst.x2.net2 dc_inst.x2.net12 0
C6164 dc_inst.x7.net17 dc_inst.x7.x5/a_27_47# 0
C6165 dc_inst.x5.net5 dc_inst.x2.x6/a_27_47# 0.065f
C6166 dc_inst.x1.net7 dc_inst.x2.net16 0
C6167 _15_/a_788_316# dc_inst.x1.x5/a_27_47# 0
C6168 dc_inst.x3.net10 _15_/a_788_316# 0
C6169 dc_inst.x6.net2 dc_inst.x6.net15 0
C6170 dc_inst.net5 path_sel[2] 0.00714f
C6171 dc_inst.x7.net4 dc_inst.x3.net4 0
C6172 dc_inst.x4.x9/a_27_47# dc_inst.x4.x7/a_27_47# 0.01018f
C6173 dc_inst.x5.net6 dc_inst.x6.net11 0
C6174 path[5] dc_inst.x3.net9 0.03503f
C6175 dc_inst.x1.net15 dc_inst.x8/a_1290_413# 0
C6176 dc_inst.x2.net11 dc_inst.x2.x12/a_27_47# 0.03648f
C6177 dc_inst.x6.net17 dc_inst.x6.net19 0
C6178 dc_inst.x7.x10/a_27_47# dc_inst.x7.net6 0.01375f
C6179 dc_inst.x1.x4/a_27_47# dc_inst.x1.net12 0
C6180 dc_inst.x3.net17 dc_inst.x3.x18/a_27_47# 0.05293f
C6181 dc_inst.x4.net15 dc_inst.x4.net17 0.169f
C6182 dc_inst.x4.net7 dc_inst.x1.net17 0
C6183 clknet_0_clk path[6] 0
C6184 dc_inst.x3.net2 dc_inst.x8/a_247_21# 0
C6185 dc_inst.x6.x9/a_27_47# dc_inst.x5.net6 0
C6186 dc_inst.x7.net10 dc_inst.x7.net8 0
C6187 dc_inst.x3.net15 _23_/a_193_47# 0
C6188 dc_inst.net3 dc_inst.x1.net9 0
C6189 dc_inst.net7 dc_inst.x9/a_247_21# 0.02504f
C6190 dc_inst.x3.net16 dc_inst.x3.net8 0
C6191 delay_sel[0] dc_inst.x9/a_277_47# 0.02799f
C6192 dc_inst.x5.net8 dc_inst.x4.net17 0
C6193 dc_inst.x1.net4 dc_inst.x4.net2 0.00241f
C6194 dc_inst.x1.net10 path_sel[0] 0
C6195 delay_sel[0] delay_sel[2] 0.00326f
C6196 dc_inst.x3.net19 dc_inst.x3.net18 0.01505f
C6197 dc_inst.x3.net16 dc_inst.x3.x4/a_27_47# 0.00107f
C6198 dc_inst.x4.x8/a_27_47# dc_inst.x4.x11/a_27_47# 0
C6199 VPWR dc_inst.x6.net9 0.05639f
C6200 dc_inst.net1 dc_inst.x4.net7 0.00434f
C6201 dc_inst.x5.net6 dc_inst.x1.net17 0.2579f
C6202 clknet_1_1__leaf_clk _25_/a_543_47# 0
C6203 dc_inst.x2.net2 dc_inst.x2.net13 0
C6204 dc_inst.x4.x3/a_27_47# dc_inst.x2.net6 0
C6205 _24_/a_193_47# _23_/a_193_47# 0
C6206 dc_inst.x1.net4 dc_inst.x3.x20/a_27_47# 0.02385f
C6207 dc_inst.x6.x7/a_27_47# path_sel[2] 0.0024f
C6208 dc_inst.x8/a_1478_413# dc_inst.x3.net16 0.00217f
C6209 dc_inst.x7.net19 dc_inst.x6.x16/a_27_47# 0
C6210 dc_inst.x7.x6/a_27_47# dc_inst.x6.net2 0.04158f
C6211 dc_inst.x7.net14 clkbuf_1_0__f_clk/a_110_47# 0.00663f
C6212 dc_inst.x2.net2 dc_inst.x4.net7 0.32816f
C6213 _23_/a_27_47# dc_inst.x3.x5/a_27_47# 0
C6214 dc_inst.x9/a_750_97# dc_inst.x7.x18/a_27_47# 0
C6215 dc_inst.x5.net12 dc_inst.x2.net7 0
C6216 dc_inst.x2.net14 dc_inst.x2.x17/a_27_47# 0.01151f
C6217 delay_sel[0] dc_inst.x7.net17 0
C6218 dc_inst.x4.x19/a_27_47# dc_inst.x4.x15/a_27_47# 0
C6219 dc_inst.x4.x2/a_27_47# dc_inst.x1.net18 0
C6220 _20_/a_384_47# dc_inst.x1.net3 0.00142f
C6221 _15_/a_788_316# path_sel[0] 0.05362f
C6222 dc_inst.in dc_inst.x2.net19 0.03445f
C6223 dc_inst.x6.net10 dc_inst.x4.net7 0
C6224 dc_inst.net1 dc_inst.x5.net6 0.00691f
C6225 dc_inst.x6.net13 dc_inst.x6.net16 0.01298f
C6226 VPWR dc_inst.x6.x14/a_27_47# -0.00196f
C6227 _25_/a_448_47# _25_/a_193_47# -0.00297f
C6228 dc_inst.x5.net12 dc_inst.x2.net10 0.04018f
C6229 dc_inst.x1.net18 dc_inst.x1.x17/a_27_47# 0.01682f
C6230 delay_sel[2] _23_/a_448_47# 0
C6231 dc_inst.x8/a_1478_413# dc_inst.in 0.01234f
C6232 dc_inst.x5.x20/a_27_47# delay_sel[1] 0
C6233 dc_inst.x7.net12 _25_/a_193_47# 0.00161f
C6234 _05_ dc_inst.x3.x18/a_27_47# 0
C6235 dc_inst.x5.net9 dc_inst.x2.x6/a_27_47# 0.02794f
C6236 dc_inst.x7.net2 dc_inst.x9/a_277_47# 0.02653f
C6237 dc_inst.x1.net4 dc_inst.x3.net13 0
C6238 dc_inst.x2.net2 dc_inst.x5.net6 0.13789f
C6239 dc_inst.x5.net2 dc_inst.x4.x13/a_27_47# 0
C6240 dc_inst.x4.net3 dc_inst.x6.x17/a_27_47# 0
C6241 dc_inst.x3.net15 dc_inst.x3.net5 0
C6242 dc_inst.x4.x6/a_27_47# dc_inst.x6.x13/a_27_47# 0
C6243 dc_inst.x1.x20/a_27_47# delay_sel[1] 0
C6244 dc_inst.x7.net2 delay_sel[2] 0
C6245 dc_inst.x4.net1 dc_inst.x4.net6 0
C6246 dc_inst.x6.net10 dc_inst.x5.net6 0.09476f
C6247 VPWR dc_inst.x6.net15 0.0069f
C6248 dc_inst.x3.net19 dc_inst.x3.net7 0
C6249 dc_inst.x9/a_277_47# dc_inst.x7.net1 0.01263f
C6250 dc_inst.net2 _01_ 0.00126f
C6251 path_sel[1] _15_/a_288_47# 0.01753f
C6252 dc_inst.x5.net6 dc_inst.x5.x9/a_27_47# 0
C6253 dc_inst.x2.net1 _17_/a_478_47# 0
C6254 dc_inst.x3.net15 dc_inst.x3.net2 0
C6255 dc_inst.x6.net11 dc_inst.net5 0
C6256 dc_inst.x7.net1 delay_sel[2] 0.00179f
C6257 dc_inst.x8/a_1290_413# dc_inst.net2 0.06635f
C6258 _14_/a_76_199# _13_/a_112_47# 0
C6259 VPWR _23_/a_1217_47# 0
C6260 _25_/a_27_47# _00_ 0.48584f
C6261 clknet_0_clk clkload0/a_27_47# 0.11171f
C6262 dc_inst.x2.x11/a_27_47# dc_inst.x2.x12/a_27_47# 0.02448f
C6263 dc_inst.x1.net4 _13_/a_112_47# 0
C6264 dc_inst.net6 dc_inst.net5 0.42358f
C6265 _24_/a_761_289# capture_q 0
C6266 dc_inst.x8/a_750_97# dc_inst.x3.x14/a_27_47# 0
C6267 dc_inst.x6.net9 dc_inst.x6.net6 0.00853f
C6268 dc_inst.x4.x4/a_27_47# dc_inst.in 0
C6269 dc_inst.x7.net2 dc_inst.x7.net17 0.11406f
C6270 dc_inst.x4.x9/a_27_47# dc_inst.x4.net8 0
C6271 dc_inst.x5.net7 dc_inst.x4.x20/a_27_47# 0
C6272 dc_inst.x2.net14 dc_inst.x2.net10 0
C6273 dc_inst.x6.net11 path_sel[2] 0.0186f
C6274 dc_inst.x7.net4 dc_inst.net5 0.20582f
C6275 _16_/a_27_93# _08_ 0
C6276 dc_inst.net2 _02_ 0
C6277 dc_inst.x3.net8 path[6] 0.0325f
C6278 VPWR dc_inst.x2.net1 0
C6279 dc_inst.x5.x6/a_27_47# dc_inst.x1.net19 0
C6280 dc_inst.x2.x17/a_27_47# dc_inst.x1.net7 0
C6281 dc_inst.x7.net1 dc_inst.x7.net17 0.01522f
C6282 dc_inst.x6.net17 dc_inst.x2.net19 0
C6283 dc_inst.net6 path_sel[2] 0.00706f
C6284 dc_inst.x6.x9/a_27_47# path_sel[2] 0.00582f
C6285 clkload0/a_27_47# clkbuf_0_clk/a_110_47# 0.00947f
C6286 dc_inst.x1.x3/a_27_47# dc_inst.x3.net14 0.11287f
C6287 _24_/a_1283_21# dc_inst.x3.net8 0
C6288 _25_/a_27_47# clknet_1_0__leaf_clk 0.03665f
C6289 dc_inst.x4.net5 dc_inst.x6.net16 0
C6290 dc_inst.x7.net7 delay_sel[1] 0
C6291 dc_inst.x3.x4/a_27_47# path[6] 0.01847f
C6292 _24_/a_543_47# capture_d 0.00261f
C6293 dc_inst.x5.net3 dc_inst.x6.net1 0
C6294 VPWR dc_inst.x7.x6/a_27_47# 0.01131f
C6295 _23_/a_1108_47# delay_sel[1] 0
C6296 dc_inst.x6.x14/a_27_47# dc_inst.x6.net6 0
C6297 dc_inst.x6.net14 dc_inst.x6.net2 0
C6298 dc_inst.x7.net4 path_sel[2] 0.00324f
C6299 dc_inst.x3.net15 _23_/a_1462_47# 0
C6300 dc_inst.x5.net2 dc_inst.x5.x1/a_27_47# 0.00199f
C6301 dc_inst.x2.net19 path[6] 0.00241f
C6302 dc_inst.x5.net2 dc_inst.x5.x14/a_27_47# 0.00421f
C6303 se _13_/a_112_47# 0.00242f
C6304 dc_inst.x3.net12 _15_/a_872_316# 0
C6305 _24_/a_1108_47# _01_ 0
C6306 dc_inst.x2.net9 dc_inst.x2.net6 0.05487f
C6307 dc_inst.x2.x8/a_27_47# dc_inst.x2.net7 0.01894f
C6308 dc_inst.x1.net17 path_sel[2] 0.03356f
C6309 dc_inst.x2.x16/a_27_47# dc_inst.in 0
C6310 dc_inst.x1.x15/a_27_47# dc_inst.x2.net15 0
C6311 dc_inst.x8/a_1478_413# path[6] 0.00209f
C6312 dc_inst.x3.net17 dc_inst.x3.net8 0
C6313 _15_/a_600_345# dc_inst.x3.x18/a_27_47# 0
C6314 dc_inst.x2.net10 dc_inst.x2.x8/a_27_47# 0.00134f
C6315 dc_inst.x8/a_1478_413# _24_/a_1283_21# 0
C6316 VPWR dc_inst.x5.net7 0.93075f
C6317 dc_inst.x2.net17 dc_inst.x2.net16 0.0047f
C6318 dc_inst.net3 dc_inst.x9/a_1478_413# 0
C6319 dc_inst.x8/a_834_97# rst 0
C6320 dc_inst.x5.net3 dc_inst.x5.x13/a_27_47# 0.03896f
C6321 dc_inst.x1.x6/a_27_47# _15_/a_788_316# 0
C6322 dc_inst.x3.net17 dc_inst.x3.x4/a_27_47# 0.04488f
C6323 dc_inst.x1.net4 dc_inst.x4.net3 0
C6324 dc_inst.x3.x15/a_27_47# capture_q 0
C6325 dc_inst.x1.net8 dc_inst.x2.x15/a_27_47# 0
C6326 dc_inst.x1.net15 dc_inst.in 0
C6327 dc_inst.net1 path_sel[2] 0.06287f
C6328 dc_inst.x3.x9/a_27_47# dc_inst.x3.net8 0
C6329 dc_inst.x2.net10 _17_/a_27_93# 0
C6330 dc_inst.x6.net17 dc_inst.x4.x4/a_27_47# 0
C6331 dc_inst.x6.net10 dc_inst.net5 0
C6332 delay_sel[2] dc_inst.x7.net18 0
C6333 dc_inst.x4.net7 dc_inst.x4.x8/a_27_47# 0
C6334 _24_/a_1108_47# _02_ 0.00457f
C6335 _06_ dc_inst.x1.x12/a_27_47# 0
C6336 dc_inst.x1.net13 dc_inst.x1.net9 0.0454f
C6337 dc_inst.x2.net2 path_sel[2] 0.00312f
C6338 dc_inst.x9/a_277_47# dc_inst.x7.x18/a_27_47# 0
C6339 dc_inst.net4 dc_inst.x6.net3 0
C6340 dc_inst.x7.x18/a_27_47# delay_sel[2] 0
C6341 dc_inst.x5.net2 dc_inst.x5.net15 0.09204f
C6342 VPWR dc_inst.x2.x15/a_27_47# 0.02173f
C6343 dc_inst.x6.net10 path_sel[2] 0.00685f
C6344 dc_inst.x7.x20/a_27_47# tdo 0.00838f
C6345 dc_inst.x4.net2 delay_sel[2] 0
C6346 dc_inst.x7.x1/a_27_47# dc_inst.net4 0.01889f
C6347 dc_inst.x7.net18 dc_inst.x7.net17 0.22043f
C6348 shadow_q dc_inst.x1.x1/a_27_47# 0
C6349 dc_inst.x5.net2 dc_inst.x4.x18/a_27_47# 0
C6350 dc_inst.x2.net9 dc_inst.x2.net12 0.00466f
C6351 dc_inst.x4.net4 delay_sel[0] 0
C6352 dc_inst.x4.net7 dc_inst.x5.x8/a_27_47# 0
C6353 VPWR dc_inst.x1.x11/a_27_47# 0.00573f
C6354 _05_ dc_inst.x3.net8 0.06699f
C6355 tdo dc_inst.x7.x2/a_27_47# 0.00141f
C6356 dc_inst.x7.net2 _25_/a_1283_21# 0
C6357 dc_inst.x4.net13 path_sel[0] 0.00211f
C6358 dc_inst.x8/a_27_413# dc_inst.x8/a_247_21# -0
C6359 dc_inst.x5.net3 path_sel[1] 0.01861f
C6360 dc_inst.x6.x9/a_27_47# dc_inst.x6.net11 0
C6361 dc_inst.net6 dc_inst.x6.net11 0
C6362 dc_inst.x4.net16 dc_inst.x4.net11 0.02162f
C6363 dc_inst.x7.net1 _25_/a_1283_21# 0
C6364 dc_inst.x7.x18/a_27_47# dc_inst.x7.net17 0.03735f
C6365 dc_inst.x4.net7 dc_inst.x1.x18/a_27_47# 0
C6366 VPWR dc_inst.x6.net14 0.47778f
C6367 clkbuf_1_0__f_clk/a_110_47# _23_/a_27_47# 0
C6368 dc_inst.x7.net4 dc_inst.x6.net11 0
C6369 dc_inst.x2.x16/a_27_47# dc_inst.x2.x5/a_27_47# 0
C6370 dc_inst.x5.net6 dc_inst.x5.x8/a_27_47# 0
C6371 dc_inst.x1.net13 dc_inst.x1.net3 0
C6372 path[3] dc_inst.x1.x12/a_27_47# 0.00507f
C6373 dc_inst.x6.net6 dc_inst.x5.net7 0
C6374 dc_inst.x6.net11 dc_inst.x1.net17 0
C6375 dc_inst.x5.net5 dc_inst.x2.x5/a_27_47# 0
C6376 _18_/a_535_374# path_sel[0] 0
C6377 dc_inst.net2 dc_inst.x3.net16 0.03238f
C6378 dc_inst.x7.net4 dc_inst.net6 0.04748f
C6379 dc_inst.x7.net4 dc_inst.x6.x9/a_27_47# 0
C6380 dc_inst.x7.net1 _25_/a_805_47# 0
C6381 dc_inst.net4 dc_inst.x4.net12 0.09308f
C6382 dc_inst.x1.net15 path[6] 0
C6383 dc_inst.x7.net5 dc_inst.net5 0.2686f
C6384 _23_/a_543_47# _24_/a_651_413# 0
C6385 _03_ rst 0.16478f
C6386 dc_inst.x2.x9/a_27_47# dc_inst.x2.x5/a_27_47# 0
C6387 path_sel[1] dc_inst.x4.net10 0.03305f
C6388 dc_inst.x1.x12/a_27_47# _19_/a_27_47# 0
C6389 _13_/a_27_297# capture_q 0.02897f
C6390 dc_inst.net2 dc_inst.in 0.07593f
C6391 dc_inst.net1 dc_inst.x6.net11 0
C6392 VPWR dc_inst.x6.net18 0.13082f
C6393 dc_inst.x5.net12 dc_inst.x2.x6/a_27_47# 0
C6394 dc_inst.x4.net4 dc_inst.x7.net2 0
C6395 path[4] dc_inst.x3.x2/a_27_47# 0
C6396 dc_inst.x4.net9 dc_inst.x6.net15 0
C6397 dc_inst.x6.net3 dc_inst.x6.net8 0
C6398 dc_inst.x9/a_1290_413# tdo 0.00477f
C6399 dc_inst.x7.net12 dc_inst.x7.net10 0.00273f
C6400 _23_/a_193_47# delay_sel[1] 0
C6401 _23_/a_27_47# dc_inst.net9 0
C6402 path_sel[1] dc_inst.x1.x13/a_27_47# 0.00461f
C6403 dc_inst.x7.net5 path_sel[2] 0.00257f
C6404 dc_inst.net1 dc_inst.net6 0.00278f
C6405 dc_inst.x5.net12 _08_ 0
C6406 dc_inst.x2.net2 dc_inst.x6.net11 0
C6407 dc_inst.x3.x14/a_27_47# dc_inst.x3.net6 0.00155f
C6408 dc_inst.x3.net19 dc_inst.x1.net3 0.01514f
C6409 dc_inst.x2.x17/a_27_47# dc_inst.x2.net17 0.01467f
C6410 _13_/a_112_47# delay_sel[2] 0.00106f
C6411 dc_inst.x7.x12/a_27_47# dc_inst.x7.net13 0
C6412 dc_inst.x7.net4 dc_inst.net1 0.04047f
C6413 dc_inst.x2.x1/a_27_47# dc_inst.x6.net17 0
C6414 _03_ clknet_1_1__leaf_clk 0
C6415 _00_ clkload0/X 0
C6416 dc_inst.x6.net10 dc_inst.x6.net11 0.02531f
C6417 dc_inst.x1.net1 dc_inst.x2.x13/a_27_47# 0
C6418 dc_inst.net1 dc_inst.x1.net17 0.13467f
C6419 dc_inst.x5.net6 dc_inst.x2.net9 0.00853f
C6420 dc_inst.x5.x19/a_27_47# dc_inst.x6.net3 0
C6421 dc_inst.x1.net8 dc_inst.x1.net19 0
C6422 dc_inst.x6.net10 dc_inst.net6 0
C6423 dc_inst.x5.net19 delay_sel[1] 0
C6424 dc_inst.x6.x9/a_27_47# dc_inst.x6.net10 0.00208f
C6425 dc_inst.x4.x3/a_27_47# path_sel[2] 0.00687f
C6426 dc_inst.x6.net14 dc_inst.x6.net6 0
C6427 dc_inst.x1.net13 dc_inst.x2.net12 0
C6428 dc_inst.x6.x12/a_27_47# dc_inst.x6.net3 0
C6429 dc_inst.x6.x17/a_27_47# dc_inst.x6.x14/a_27_47# 0.01224f
C6430 clkbuf_1_1__f_clk/a_110_47# dc_inst.x3.x16/a_27_47# 0
C6431 dc_inst.x3.net15 dc_inst.x3.x3/a_27_47# 0
C6432 _15_/a_600_345# dc_inst.x2.net19 0
C6433 dc_inst.x4.x8/a_27_47# path_sel[2] 0.00212f
C6434 dc_inst.x2.net2 dc_inst.x1.net17 0.0051f
C6435 dc_inst.x6.x20/a_27_47# dc_inst.x7.x5/a_27_47# 0
C6436 VPWR _06_ 0.11223f
C6437 dc_inst.x1.net15 dc_inst.x1.net12 0.07107f
C6438 dc_inst.x7.x13/a_27_47# dc_inst.x9/a_27_47# 0.0101f
C6439 dc_inst.x3.net6 path[7] 0
C6440 dc_inst.x5.net9 dc_inst.x2.x5/a_27_47# 0
C6441 VPWR dc_inst.x1.net19 0.09248f
C6442 dc_inst.x3.net11 path[4] 0.01078f
C6443 dc_inst.x8/a_193_47# dc_inst.in 0
C6444 dc_inst.x5.net16 dc_inst.x5.x15/a_27_47# 0.00356f
C6445 dc_inst.x4.net9 dc_inst.x5.net7 0.02344f
C6446 dc_inst.x6.x17/a_27_47# dc_inst.x6.net15 0
C6447 dc_inst.x3.net5 _15_/a_288_47# 0
C6448 dc_inst.x2.net2 dc_inst.net1 0.01504f
C6449 VPWR tdi 0.01035f
C6450 dc_inst.x7.net14 dc_inst.x7.net17 0
C6451 dc_inst.net2 path[6] 0.01232f
C6452 dc_inst.net3 path_sel[2] 0.00267f
C6453 dc_inst.x6.net10 dc_inst.net1 0
C6454 dc_inst.x7.net7 dc_inst.x9/a_247_21# 0
C6455 dc_inst.x7.x20/a_27_47# dc_inst.x7.net3 0.03859f
C6456 dc_inst.x3.net2 delay_sel[1] 0
C6457 dc_inst.net2 _24_/a_1283_21# 0
C6458 dc_inst.x4.net13 tdo 0.11331f
C6459 dc_inst.x1.net15 dc_inst.x1.x2/a_27_47# 0
C6460 dc_inst.x2.x8/a_27_47# dc_inst.x2.x6/a_27_47# 0
C6461 delay_sel[2] _23_/a_1283_21# 0.00305f
C6462 dc_inst.net8 _23_/a_543_47# 0
C6463 dc_inst.x1.net13 dc_inst.x2.net13 0
C6464 dc_inst.x7.net3 dc_inst.x7.x2/a_27_47# 0.00422f
C6465 dc_inst.x6.net10 dc_inst.x2.net2 0
C6466 dc_inst.x1.x18/a_27_47# path_sel[2] 0.01275f
C6467 VPWR path[3] 0.22326f
C6468 _04_ dc_inst.x3.x14/a_27_47# 0
C6469 dc_inst.x6.x12/a_27_47# dc_inst.x4.net12 0
C6470 dc_inst.x5.x12/a_27_47# dc_inst.x2.net12 0.03324f
C6471 dc_inst.x1.net8 _19_/a_27_47# 0
C6472 dc_inst.x7.net5 dc_inst.x6.net11 0
C6473 VPWR dc_inst.x10/a_505_21# 0.05891f
C6474 rst dc_inst.x8/a_277_47# 0
C6475 dc_inst.x3.x11/a_27_47# shadow_q 0
C6476 dc_inst.net2 dc_inst.x3.net17 0
C6477 dc_inst.x8/a_750_97# dc_inst.x8/a_247_21# -0.02899f
C6478 dc_inst.x7.net10 dc_inst.in 0
C6479 dc_inst.net6 dc_inst.x7.net5 0.02712f
C6480 dc_inst.x5.net11 dc_inst.x2.net7 0
C6481 dc_inst.x4.net2 dc_inst.x4.net4 0.17138f
C6482 dc_inst.x6.x20/a_27_47# delay_sel[0] 0
C6483 dc_inst.x6.x14/a_27_47# dc_inst.x6.x13/a_27_47# 0.02448f
C6484 dc_inst.x5.net2 dc_inst.x6.x6/a_27_47# 0.13659f
C6485 dc_inst.x5.net11 dc_inst.x2.net10 0.0419f
C6486 dc_inst.x9/a_923_363# dc_inst.x9/a_834_97# -0
C6487 dc_inst.x5.net5 dc_inst.x5.net4 0.29667f
C6488 dc_inst.x5.net14 dc_inst.x5.net16 0.00347f
C6489 VPWR _19_/a_27_47# 0.04418f
C6490 _08_ _17_/a_27_93# 0.00193f
C6491 dc_inst.x7.net4 dc_inst.x7.net5 0.10962f
C6492 _07_ path_sel[0] 0.29135f
C6493 _06_ path[5] 0
C6494 _24_/a_1108_47# path[6] 0
C6495 path[4] dc_inst.x1.net2 0
C6496 dc_inst.x1.net7 _08_ 0
C6497 _04_ path[7] 0
C6498 clknet_1_1__leaf_clk dc_inst.x8/a_277_47# 0
C6499 _03_ dc_inst.net7 0.00129f
C6500 dc_inst.x6.net14 dc_inst.x4.net9 0
C6501 VPWR rst 1.20407f
C6502 dc_inst.net4 dc_inst.x1.net18 0
C6503 dc_inst.x6.net5 dc_inst.x6.x14/a_27_47# 0
C6504 dc_inst.x6.x13/a_27_47# dc_inst.x6.net15 0
C6505 dc_inst.x4.net5 dc_inst.x2.net16 0.00199f
C6506 VPWR dc_inst.x6.net12 0.11868f
C6507 dc_inst.x2.net9 path_sel[2] 0
C6508 dc_inst.x1.net15 dc_inst.x2.x4/a_27_47# 0.00122f
C6509 tdo dc_inst.net8 0
C6510 dc_inst.x2.x19/a_27_47# _01_ 0
C6511 dc_inst.x3.net19 dc_inst.x3.net4 0.01129f
C6512 dc_inst.x9/a_1290_413# dc_inst.x7.net3 0
C6513 dc_inst.x3.net15 shadow_q 0.06119f
C6514 dc_inst.x4.x15/a_27_47# dc_inst.x5.net12 0.00185f
C6515 dc_inst.x5.x12/a_27_47# dc_inst.x2.net13 0.00131f
C6516 tdi path[5] 0.00172f
C6517 dc_inst.x7.net4 dc_inst.x4.x3/a_27_47# 0
C6518 dc_inst.x1.net11 _19_/a_109_297# 0.01456f
C6519 dc_inst.x1.x3/a_27_47# dc_inst.x3.net3 0
C6520 dc_inst.x5.net3 dc_inst.x5.net19 0
C6521 path[0] _07_ 0.00483f
C6522 delay_sel[0] dc_inst.x6.x19/a_27_47# 0
C6523 dc_inst.x7.net16 delay_sel[1] 0
C6524 dc_inst.x4.net12 dc_inst.x4.x11/a_27_47# 0.00194f
C6525 _09_ dc_inst.x1.x5/a_27_47# 0.00892f
C6526 VPWR clknet_1_1__leaf_clk 0.19797f
C6527 dc_inst.x4.net18 dc_inst.x4.net12 0
C6528 dc_inst.x6.x20/a_27_47# dc_inst.x7.net2 0.02194f
C6529 dc_inst.x7.net19 capture_d 0.01448f
C6530 _24_/a_193_47# shadow_q 0
C6531 dc_inst.x6.x18/a_27_47# dc_inst.in 0.02942f
C6532 _10_ dc_inst.x3.net6 0.00164f
C6533 dc_inst.x6.net10 dc_inst.x7.net5 0
C6534 dc_inst.x5.net6 dc_inst.x5.x12/a_27_47# 0
C6535 dc_inst.net1 dc_inst.x4.x3/a_27_47# 0
C6536 dc_inst.x7.net4 dc_inst.net3 0.20697f
C6537 dc_inst.x3.x12/a_27_47# _06_ 0.00109f
C6538 dc_inst.net3 dc_inst.x1.net17 0
C6539 dc_inst.net7 dc_inst.x6.net2 0
C6540 dc_inst.x5.net9 dc_inst.x5.net4 0.07058f
C6541 path_sel[1] dc_inst.x4.net14 0.00724f
C6542 _24_/a_27_47# _01_ 0
C6543 dc_inst.x6.net14 dc_inst.x6.x17/a_27_47# 0
C6544 dc_inst.x3.net14 dc_inst.x3.x14/a_27_47# 0.00377f
C6545 dc_inst.x1.net5 path[7] 0
C6546 delay_sel[0] dc_inst.x9/a_27_47# 0
C6547 dc_inst.x7.net6 dc_inst.x7.x4/a_27_47# 0.02965f
C6548 dc_inst.x3.x5/a_27_47# rst 0
C6549 dc_inst.x3.net6 _15_/a_872_316# 0
C6550 dc_inst.x6.net12 dc_inst.x6.net6 0
C6551 dc_inst.x1.x18/a_27_47# dc_inst.x1.net17 0.0426f
C6552 path[5] rst 0.00319f
C6553 _05_ _24_/a_1108_47# 0
C6554 delay_sel[2] _23_/a_27_47# 0.03341f
C6555 dc_inst.x6.net9 dc_inst.x6.net7 0.00114f
C6556 dc_inst.x2.net3 dc_inst.x4.x7/a_27_47# 0.0022f
C6557 dc_inst.x7.net2 dc_inst.x6.x19/a_27_47# 0.01192f
C6558 _25_/a_27_47# tdo 0
C6559 dc_inst.net3 dc_inst.net1 0.0135f
C6560 dc_inst.net4 dc_inst.x6.x10/a_27_47# 0.00666f
C6561 dc_inst.x9/a_247_21# dc_inst.x6.net4 0
C6562 dc_inst.x7.net9 dc_inst.x7.x6/a_27_47# 0
C6563 path_sel[1] dc_inst.x2.x13/a_27_47# 0.00682f
C6564 _09_ path_sel[0] 0.00685f
C6565 dc_inst.x4.x19/a_27_47# dc_inst.x6.x6/a_27_47# 0
C6566 VPWR dc_inst.x5.x5/a_27_47# 0.01267f
C6567 dc_inst.x1.net13 path_sel[2] 0.01888f
C6568 _24_/a_27_47# _02_ -0
C6569 dc_inst.x2.x2/a_27_47# dc_inst.x1.x20/a_27_47# 0
C6570 dc_inst.net1 dc_inst.x1.x18/a_27_47# 0.02637f
C6571 dc_inst.x6.x18/a_27_47# dc_inst.x6.net17 0.01469f
C6572 dc_inst.net2 _15_/a_600_345# 0
C6573 dc_inst.x5.net12 dc_inst.x2.x5/a_27_47# 0
C6574 dc_inst.x1.x4/a_27_47# _15_/a_27_47# 0.01132f
C6575 dc_inst.x7.net19 dc_inst.x7.net13 0
C6576 path_sel[1] dc_inst.x2.x2/a_27_47# 0.00577f
C6577 dc_inst.x4.net3 dc_inst.x1.net16 0.00109f
C6578 _03_ _24_/a_761_289# 0
C6579 dc_inst.x2.x7/a_27_47# dc_inst.x2.net12 0
C6580 VPWR dc_inst.x1.x16/a_27_47# 0.01609f
C6581 dc_inst.x3.net14 path[7] 0
C6582 delay_sel[0] dc_inst.x8/a_923_363# 0
C6583 dc_inst.x4.net11 dc_inst.x4.x12/a_27_47# 0.12789f
C6584 dc_inst.x5.net3 dc_inst.x4.x10/a_27_47# 0
C6585 dc_inst.x6.net14 dc_inst.net9 0
C6586 dc_inst.x6.x12/a_27_47# dc_inst.x1.net18 0
C6587 dc_inst.x4.net3 dc_inst.x4.net4 0.30472f
C6588 _04_ _10_ 0.0666f
C6589 dc_inst.x3.net5 capture_q 0
C6590 dc_inst.x5.net3 dc_inst.x4.net16 0.12848f
C6591 _24_/a_193_47# _25_/a_1108_47# 0
C6592 dc_inst.x2.net7 dc_inst.x5.net1 0
C6593 dc_inst.x4.net5 dc_inst.x2.x17/a_27_47# 0.00135f
C6594 dc_inst.x3.net2 capture_q 0
C6595 _15_/a_788_316# dc_inst.x3.net11 0.0107f
C6596 dc_inst.net7 dc_inst.x6.x1/a_27_47# 0.00124f
C6597 dc_inst.x3.x8/a_27_47# path[7] 0
C6598 dc_inst.x2.net10 dc_inst.x5.net1 0.01134f
C6599 dc_inst.x3.net19 path_sel[2] 0
C6600 dc_inst.x8/a_27_413# delay_sel[1] 0.00635f
C6601 dc_inst.x8/a_1290_413# dc_inst.x2.net17 0
C6602 dc_inst.x4.x13/a_27_47# dc_inst.x5.net12 0
C6603 dc_inst.x6.net14 dc_inst.x6.x13/a_27_47# 0.02478f
C6604 dc_inst.x1.x4/a_27_47# dc_inst.x1.x8/a_27_47# 0.08729f
C6605 dc_inst.x6.x20/a_27_47# dc_inst.x7.x18/a_27_47# 0
C6606 dc_inst.x2.net18 _23_/a_1108_47# 0
C6607 dc_inst.x9/a_27_47# dc_inst.x7.net1 0.00945f
C6608 dc_inst.x5.x15/a_27_47# dc_inst.x4.net11 0
C6609 dc_inst.x4.net2 dc_inst.x6.x20/a_27_47# 0
C6610 VPWR dc_inst.net7 0.01578f
C6611 dc_inst.x7.net3 dc_inst.net8 0.14814f
C6612 dc_inst.x4.net6 dc_inst.x4.x6/a_27_47# 0.0403f
C6613 tdo _25_/a_1217_47# 0
C6614 _15_/a_193_47# path[6] 0
C6615 dc_inst.x4.net10 dc_inst.x4.x10/a_27_47# 0.05174f
C6616 dc_inst.x2.net14 dc_inst.x2.x5/a_27_47# 0.00103f
C6617 dc_inst.x5.x12/a_27_47# path_sel[2] 0.00207f
C6618 dc_inst.x6.x10/a_27_47# dc_inst.x6.net8 0
C6619 VPWR dc_inst.x1.x19/a_27_47# 0.01563f
C6620 dc_inst.x4.net16 dc_inst.x4.net10 0
C6621 dc_inst.x6.net14 dc_inst.x6.net5 0
C6622 dc_inst.x2.x19/a_27_47# dc_inst.in 0.02705f
C6623 dc_inst.x6.net18 dc_inst.x6.x13/a_27_47# 0
C6624 path_sel[0] dc_inst.x5.x10/a_27_47# 0.00267f
C6625 _16_/a_27_93# _17_/a_174_21# 0.00254f
C6626 dc_inst.x6.net12 dc_inst.x4.net9 0
C6627 dc_inst.x4.net5 dc_inst.x2.net7 0.00181f
C6628 dc_inst.x7.x6/a_27_47# dc_inst.x6.net7 0
C6629 VPWR _23_/a_651_413# 0.01656f
C6630 dc_inst.x4.net8 dc_inst.x2.net3 0.0126f
C6631 dc_inst.x5.net11 _08_ 0.0023f
C6632 _10_ dc_inst.x1.net5 0.05267f
C6633 dc_inst.x5.net6 dc_inst.x4.net12 0
C6634 dc_inst.x4.net2 dc_inst.x6.x19/a_27_47# 0
C6635 dc_inst.x5.net6 dc_inst.x2.x7/a_27_47# 0.00663f
C6636 dc_inst.x6.x12/a_27_47# dc_inst.x6.x10/a_27_47# 0
C6637 _23_/a_1217_47# delay_sel[2] 0
C6638 dc_inst.x5.x1/a_27_47# dc_inst.x5.net12 0
C6639 dc_inst.x5.x17/a_27_47# dc_inst.x7.net8 0
C6640 clkbuf_1_1__f_clk/a_110_47# _01_ 0
C6641 dc_inst.x5.net14 dc_inst.x4.net11 0
C6642 _15_/a_788_316# dc_inst.x1.net2 0
C6643 dc_inst.x5.net12 dc_inst.x5.x14/a_27_47# 0.00297f
C6644 dc_inst.x5.x13/a_27_47# dc_inst.x5.net13 0.01506f
C6645 dc_inst.x3.x6/a_27_47# dc_inst.x3.net18 0.00149f
C6646 dc_inst.net3 dc_inst.x4.x3/a_27_47# 0
C6647 _20_/a_470_297# path_sel[0] 0.00206f
C6648 dc_inst.x3.net15 dc_inst.x3.net6 0
C6649 VPWR dc_inst.x1.net1 0.04707f
C6650 dc_inst.x6.net18 dc_inst.x9/a_750_97# 0
C6651 dc_inst.x2.net15 dc_inst.x1.net16 0.07129f
C6652 dc_inst.x1.net7 path[6] 0
C6653 path_sel[1] dc_inst.x5.x6/a_27_47# 0.00283f
C6654 dc_inst.net5 dc_inst.x6.net3 0
C6655 dc_inst.x1.net9 dc_inst.x1.x9/a_27_47# 0.0173f
C6656 dc_inst.x6.x13/a_27_47# dc_inst.x1.net19 0
C6657 clkbuf_1_1__f_clk/a_110_47# _02_ 0.00626f
C6658 _24_/a_27_47# dc_inst.in 0.00382f
C6659 dc_inst.x2.x13/a_27_47# dc_inst.x2.x14/a_27_47# 0.02448f
C6660 dc_inst.x7.x1/a_27_47# dc_inst.net5 0
C6661 dc_inst.x6.net12 dc_inst.x6.x17/a_27_47# 0
C6662 tdi _14_/a_76_199# 0.00366f
C6663 clkbuf_1_0__f_clk/a_110_47# rst 0.00671f
C6664 dc_inst.x5.net12 dc_inst.x5.net4 0.00328f
C6665 dc_inst.x6.net3 path_sel[2] 0.0386f
C6666 dc_inst.x3.net7 dc_inst.x3.x7/a_27_47# 0.04654f
C6667 dc_inst.x10/a_505_21# dc_inst.net9 0.0021f
C6668 dc_inst.x6.net1 dc_inst.x6.net2 0
C6669 dc_inst.net4 clknet_1_0__leaf_clk 0
C6670 VPWR _24_/a_761_289# 0.00249f
C6671 dc_inst.x7.x1/a_27_47# path_sel[2] 0.00581f
C6672 dc_inst.x5.net12 dc_inst.x4.x18/a_27_47# 0
C6673 path_sel[1] dc_inst.x5.net13 0.0054f
C6674 path_sel[0] _18_/a_76_199# 0
C6675 dc_inst.x3.net7 dc_inst.x3.x6/a_27_47# 0.00124f
C6676 dc_inst.x2.net7 dc_inst.x4.net17 0
C6677 dc_inst.x4.x6/a_27_47# dc_inst.x6.x19/a_27_47# 0
C6678 dc_inst.x4.net19 dc_inst.x4.net13 0
C6679 tdo dc_inst.x1.x17/a_27_47# 0
C6680 dc_inst.x3.net14 _15_/a_872_316# 0
C6681 dc_inst.x7.net5 dc_inst.x9/a_668_97# 0
C6682 dc_inst.x5.net3 dc_inst.x4.x5/a_27_47# 0
C6683 dc_inst.x1.net7 dc_inst.x1.net12 0.03612f
C6684 _15_/a_27_47# dc_inst.x3.x4/a_27_47# 0.00123f
C6685 dc_inst.x4.x16/a_27_47# dc_inst.x5.net9 0
C6686 _04_ dc_inst.x1.net11 0
C6687 clknet_0_clk clkbuf_0_clk/a_110_47# 0.09759f
C6688 _15_/a_27_47# dc_inst.x2.net19 0
C6689 dc_inst.net9 rst 0.04427f
C6690 path_sel[1] dc_inst.x5.x2/a_27_47# 0.00491f
C6691 dc_inst.x2.net17 dc_inst.in 0
C6692 se tdi 0.08567f
C6693 dc_inst.x8/a_750_97# delay_sel[1] 0.22633f
C6694 dc_inst.x6.net1 dc_inst.x4.x20/a_27_47# 0.01122f
C6695 _20_/a_79_21# _15_/a_788_316# 0
C6696 dc_inst.x4.net12 path_sel[2] 0
C6697 path_sel[1] dc_inst.x5.x16/a_27_47# 0.01325f
C6698 dc_inst.x5.net12 dc_inst.x4.x7/a_27_47# 0
C6699 dc_inst.x2.net14 dc_inst.x2.x4/a_27_47# 0
C6700 dc_inst.x7.x13/a_27_47# dc_inst.x6.x2/a_27_47# 0
C6701 dc_inst.x5.x20/a_27_47# dc_inst.x6.net2 0
C6702 VPWR dc_inst.x3.x15/a_27_47# 0.07034f
C6703 _14_/a_76_199# rst 0.03506f
C6704 _24_/a_27_47# path[6] 0
C6705 dc_inst.x6.net12 dc_inst.x6.x13/a_27_47# 0.05072f
C6706 dc_inst.x1.x2/a_27_47# dc_inst.x1.net7 0.00279f
C6707 _03_ _23_/a_1108_47# 0
C6708 _24_/a_543_47# _24_/a_193_47# -0.01997f
C6709 _24_/a_1283_21# _24_/a_27_47# -0
C6710 clknet_1_1__leaf_clk dc_inst.net9 0
C6711 dc_inst.x2.x6/a_27_47# dc_inst.x5.net1 0
C6712 path[4] dc_inst.x1.net6 0
C6713 dc_inst.x4.x1/a_27_47# dc_inst.in 0.03752f
C6714 dc_inst.x5.x4/a_27_47# path_sel[0] 0.00273f
C6715 VPWR dc_inst.x3.net1 0.17892f
C6716 dc_inst.x3.net13 dc_inst.x3.x13/a_27_47# 0
C6717 path_sel[1] dc_inst.x6.net2 0
C6718 dc_inst.x6.x3/a_27_47# dc_inst.x6.x2/a_27_47# 0
C6719 dc_inst.x3.x3/a_27_47# capture_q 0
C6720 dc_inst.x6.net11 dc_inst.x6.net3 0
C6721 VPWR dc_inst.x6.net1 0.00948f
C6722 dc_inst.x6.net12 dc_inst.x6.net5 0
C6723 dc_inst.x8/a_27_413# dc_inst.x9/a_247_21# 0
C6724 dc_inst.x2.x8/a_27_47# dc_inst.x2.x4/a_27_47# 0.01254f
C6725 _08_ dc_inst.x5.net1 0
C6726 dc_inst.x6.net17 dc_inst.x6.x16/a_27_47# 0.04144f
C6727 _14_/a_76_199# clknet_1_1__leaf_clk 0.00155f
C6728 delay_sel[1] _25_/a_1108_47# 0
C6729 path_sel[1] dc_inst.x5.x3/a_27_47# 0.00483f
C6730 clkbuf_1_1__f_clk/a_110_47# dc_inst.x3.net16 0
C6731 dc_inst.x1.x9/a_27_47# dc_inst.x2.net12 0
C6732 dc_inst.x9/a_27_47# dc_inst.x7.net14 0
C6733 dc_inst.x5.net6 dc_inst.x1.net18 0.00481f
C6734 dc_inst.x1.net10 dc_inst.x5.x11/a_27_47# 0
C6735 dc_inst.x8/a_834_97# _23_/a_193_47# 0
C6736 dc_inst.x1.net15 dc_inst.x1.x14/a_27_47# 0.04037f
C6737 dc_inst.x3.x1/a_27_47# delay_sel[1] 0
C6738 path[1] _17_/a_478_47# 0
C6739 dc_inst.x7.x1/a_27_47# dc_inst.net6 0.04097f
C6740 dc_inst.x6.net17 dc_inst.x2.net17 0
C6741 dc_inst.x1.net11 dc_inst.x1.net5 0.06778f
C6742 dc_inst.x9/a_750_97# rst 0
C6743 VPWR dc_inst.x5.x13/a_27_47# 0.00151f
C6744 se rst 0.66191f
C6745 dc_inst.x3.net10 dc_inst.x3.net18 0
C6746 dc_inst.x2.x3/a_27_47# dc_inst.x2.net6 0
C6747 dc_inst.x4.net4 dc_inst.x6.net15 0.00654f
C6748 dc_inst.x4.net13 dc_inst.x4.net1 0.0403f
C6749 dc_inst.x4.net16 dc_inst.x4.net14 0.2086f
C6750 dc_inst.x7.net4 dc_inst.x7.x1/a_27_47# 0
C6751 dc_inst.x3.x10/a_27_47# _02_ 0
C6752 path_sel[1] dc_inst.x4.x20/a_27_47# 0.00892f
C6753 dc_inst.x7.net7 dc_inst.x6.net2 0.09125f
C6754 dc_inst.x1.x20/a_27_47# dc_inst.x8/a_277_47# 0
C6755 dc_inst.x7.x14/a_27_47# dc_inst.x7.net13 0.01776f
C6756 dc_inst.x6.x15/a_27_47# tdo 0.01775f
C6757 dc_inst.x7.x10/a_27_47# dc_inst.x7.net1 0.00318f
C6758 dc_inst.x8/a_1290_413# dc_inst.x1.x3/a_27_47# 0
C6759 dc_inst.x3.x5/a_27_47# dc_inst.x3.x15/a_27_47# 0.00381f
C6760 dc_inst.x1.net7 _15_/a_600_345# 0
C6761 path_sel[1] _17_/a_478_47# 0
C6762 dc_inst.x3.x11/a_27_47# dc_inst.x3.x8/a_27_47# 0
C6763 path[5] dc_inst.x3.x15/a_27_47# 0
C6764 VPWR path[1] 0.05598f
C6765 delay_sel[2] _24_/a_1217_47# 0
C6766 dc_inst.x4.net12 dc_inst.x6.net11 0
C6767 path_sel[1] dc_inst.x1.net8 0.12726f
C6768 dc_inst.net7 clkbuf_1_0__f_clk/a_110_47# 0.00179f
C6769 se clknet_1_1__leaf_clk 0.1203f
C6770 dc_inst.x4.x1/a_27_47# dc_inst.x6.net17 0
C6771 VPWR dc_inst.x5.x20/a_27_47# -0
C6772 dc_inst.x3.net3 path[7] 0.002f
C6773 _24_/a_27_47# clkload0/a_27_47# 0.0055f
C6774 VPWR _13_/a_27_297# 0.02724f
C6775 _05_ _24_/a_27_47# 0
C6776 dc_inst.x7.net15 dc_inst.x7.x19/a_27_47# 0
C6777 _24_/a_448_47# rst 0
C6778 dc_inst.x2.x2/a_27_47# dc_inst.x4.x10/a_27_47# 0
C6779 dc_inst.x4.x17/a_27_47# dc_inst.x4.net8 0.00108f
C6780 dc_inst.x5.net19 dc_inst.x7.x8/a_27_47# 0.01382f
C6781 VPWR dc_inst.x7.x11/a_27_47# 0.05651f
C6782 dc_inst.x3.net1 dc_inst.x3.x5/a_27_47# 0
C6783 dc_inst.x5.x7/a_27_47# path_sel[0] 0.00238f
C6784 dc_inst.x1.net13 dc_inst.net3 0
C6785 dc_inst.x3.net1 path[5] 0.04512f
C6786 dc_inst.x3.net15 dc_inst.x3.net14 0.02526f
C6787 dc_inst.x5.net3 dc_inst.x4.x12/a_27_47# 0
C6788 dc_inst.x8/a_668_97# dc_inst.x3.net3 0
C6789 dc_inst.x4.net8 dc_inst.x5.net12 0
C6790 VPWR dc_inst.x1.x20/a_27_47# 0.04831f
C6791 dc_inst.x1.x10/a_27_47# dc_inst.in 0
C6792 dc_inst.x6.net6 dc_inst.x6.net1 0.02768f
C6793 dc_inst.x3.x20/a_27_47# path[4] 0
C6794 dc_inst.x3.net10 dc_inst.x3.net7 0
C6795 path_sel[1] VPWR 1.35649f
C6796 dc_inst.x2.x3/a_27_47# dc_inst.x2.net12 0
C6797 dc_inst.x5.net2 dc_inst.x4.x19/a_27_47# 0
C6798 _23_/a_1108_47# dc_inst.x8/a_277_47# 0
C6799 dc_inst.x8/a_834_97# dc_inst.x3.net2 0
C6800 clknet_1_1__leaf_clk _24_/a_448_47# 0.01492f
C6801 dc_inst.x5.net6 dc_inst.x6.x10/a_27_47# 0.00181f
C6802 dc_inst.x1.x4/a_27_47# dc_inst.x1.net15 0
C6803 dc_inst.net7 dc_inst.net9 0.00275f
C6804 dc_inst.x1.net15 dc_inst.x1.x8/a_27_47# 0
C6805 dc_inst.x3.x7/a_27_47# dc_inst.x1.net3 0
C6806 dc_inst.x5.net12 dc_inst.x6.x6/a_27_47# 0
C6807 dc_inst.x5.net6 dc_inst.x1.x9/a_27_47# 0
C6808 dc_inst.x2.net17 dc_inst.x1.net12 0
C6809 shadow_q capture_q 0.02732f
C6810 dc_inst.x1.net14 dc_inst.x1.net5 0
C6811 dc_inst.x7.net7 dc_inst.x6.x1/a_27_47# 0
C6812 clknet_0_clk _25_/a_651_413# 0.00151f
C6813 dc_inst.x5.net3 dc_inst.x5.x15/a_27_47# 0
C6814 clkbuf_1_1__f_clk/a_110_47# path[6] 0.0098f
C6815 _03_ _23_/a_193_47# 0
C6816 dc_inst.x3.net13 path[4] 0.01642f
C6817 dc_inst.x4.net10 dc_inst.x4.x12/a_27_47# 0
C6818 dc_inst.net3 dc_inst.x3.net19 0
C6819 dc_inst.x1.x7/a_27_47# dc_inst.x1.net8 0.00259f
C6820 clkbuf_1_1__f_clk/a_110_47# _24_/a_1283_21# 0.02393f
C6821 dc_inst.x2.x15/a_27_47# dc_inst.x1.net16 0.01342f
C6822 tdo dc_inst.x5.x4/a_27_47# 0
C6823 path_sel[2] dc_inst.x1.net18 0.01192f
C6824 dc_inst.x10/a_505_21# delay_sel[2] 0.0535f
C6825 dc_inst.x10/a_76_199# dc_inst.net8 0.00299f
C6826 dc_inst.x4.x17/a_27_47# dc_inst.x4.x16/a_27_47# 0
C6827 VPWR dc_inst.x7.net7 0.00979f
C6828 dc_inst.x5.net13 dc_inst.x5.net19 0
C6829 dc_inst.x4.net6 dc_inst.x6.net15 0
C6830 _15_/a_397_47# path_sel[2] 0
C6831 VPWR _23_/a_1108_47# 0.00968f
C6832 clkbuf_0_clk/a_110_47# _25_/a_651_413# 0
C6833 dc_inst.x4.x16/a_27_47# dc_inst.x5.net12 0
C6834 dc_inst.x6.net10 dc_inst.x4.net12 0
C6835 _23_/a_651_413# dc_inst.net9 0
C6836 dc_inst.net4 path_sel[0] 0
C6837 dc_inst.x1.x2/a_27_47# dc_inst.x2.net17 0
C6838 dc_inst.x1.x7/a_27_47# VPWR 0.07181f
C6839 clkbuf_1_1__f_clk/a_110_47# dc_inst.x3.net17 0
C6840 dc_inst.x5.net11 dc_inst.x1.net12 0.00175f
C6841 _15_/a_27_47# dc_inst.net2 0
C6842 dc_inst.x1.x1/a_27_47# dc_inst.x3.net3 0
C6843 dc_inst.x9/a_277_47# rst 0
C6844 dc_inst.x7.x20/a_27_47# dc_inst.x7.net2 0.00399f
C6845 path_sel[1] dc_inst.x6.net6 0.03384f
C6846 path_sel[1] dc_inst.x3.x5/a_27_47# 0
C6847 path_sel[1] path[5] 0.00241f
C6848 delay_sel[2] rst 0.32284f
C6849 capture_d _01_ 0.0038f
C6850 dc_inst.x4.net4 dc_inst.x6.net14 0.00437f
C6851 dc_inst.x9/a_1478_413# _00_ 0
C6852 _13_/a_470_297# _00_ 0
C6853 clknet_0_clk _25_/a_193_47# 0.01581f
C6854 dc_inst.x5.net3 dc_inst.x5.net14 0.15253f
C6855 dc_inst.x7.x1/a_27_47# dc_inst.x7.net5 0
C6856 dc_inst.x5.net18 dc_inst.x6.x2/a_27_47# 0
C6857 dc_inst.net7 dc_inst.x9/a_750_97# 0.02258f
C6858 VPWR dc_inst.x7.x16/a_27_47# -0.00656f
C6859 dc_inst.x7.x20/a_27_47# dc_inst.x7.net1 0
C6860 delay_sel[0] dc_inst.x9/a_1290_413# 0.05466f
C6861 dc_inst.x7.net2 dc_inst.x7.x2/a_27_47# 0.02597f
C6862 dc_inst.x3.net9 dc_inst.x3.x13/a_27_47# 0.03086f
C6863 dc_inst.x5.net6 dc_inst.x2.x3/a_27_47# 0.00943f
C6864 dc_inst.x2.net4 dc_inst.x2.net7 0
C6865 dc_inst.x6.net4 dc_inst.x6.net2 0
C6866 dc_inst.x6.x10/a_27_47# dc_inst.net5 0
C6867 dc_inst.x6.x15/a_27_47# dc_inst.x7.net3 0
C6868 _13_/a_470_297# dc_inst.x3.x7/a_27_47# 0
C6869 dc_inst.x7.x2/a_27_47# dc_inst.x7.net1 0
C6870 dc_inst.x2.x12/a_27_47# dc_inst.x2.net7 0
C6871 dc_inst.x1.net10 path[2] 0
C6872 clkbuf_0_clk/a_110_47# _25_/a_193_47# 0.01729f
C6873 rst dc_inst.x7.net17 0
C6874 dc_inst.x9/a_1478_413# clknet_1_0__leaf_clk 0
C6875 delay_sel[2] clknet_1_1__leaf_clk 0.32535f
C6876 capture_d _02_ 0.00491f
C6877 dc_inst.x2.x12/a_27_47# dc_inst.x2.net10 0.14817f
C6878 dc_inst.x4.net16 dc_inst.x5.x6/a_27_47# 0.00121f
C6879 dc_inst.x4.net6 dc_inst.x5.net7 0.03762f
C6880 clkbuf_1_1__f_clk/a_110_47# _05_ 0
C6881 clkbuf_1_1__f_clk/a_110_47# clkload0/a_27_47# 0.02166f
C6882 _15_/a_193_369# path[6] 0.00165f
C6883 dc_inst.x7.net3 dc_inst.x7.x3/a_27_47# 0.05267f
C6884 dc_inst.x5.net19 dc_inst.x6.net2 0.08566f
C6885 _15_/a_788_316# dc_inst.x1.net6 0.00163f
C6886 dc_inst.x5.x7/a_27_47# tdo 0.00385f
C6887 _15_/a_1064_47# _07_ 0
C6888 dc_inst.x6.x10/a_27_47# path_sel[2] 0.00517f
C6889 _23_/a_1108_47# dc_inst.x3.x5/a_27_47# 0
C6890 _24_/a_1270_413# _00_ 0
C6891 dc_inst.x4.net5 dc_inst.in 0
C6892 path_sel[2] dc_inst.x1.x9/a_27_47# 0.00523f
C6893 path[5] _23_/a_1108_47# 0
C6894 dc_inst.net4 dc_inst.x7.net6 0.08389f
C6895 dc_inst.x6.net11 dc_inst.x1.net18 0
C6896 dc_inst.x3.x16/a_27_47# dc_inst.x1.x1/a_27_47# 0
C6897 dc_inst.x4.net13 dc_inst.x2.net8 0
C6898 dc_inst.x1.x10/a_27_47# dc_inst.x1.net12 0
C6899 _23_/a_193_47# dc_inst.x8/a_277_47# 0
C6900 dc_inst.x7.net2 dc_inst.x9/a_1290_413# 0.03216f
C6901 VPWR dc_inst.x2.x14/a_27_47# 0.00765f
C6902 _03_ _23_/a_1462_47# 0
C6903 dc_inst.x2.x20/a_27_47# path_sel[2] 0.00371f
C6904 dc_inst.x9/a_1290_413# dc_inst.x7.net1 0
C6905 dc_inst.x7.net4 dc_inst.x1.net18 0
C6906 dc_inst.x5.net3 dc_inst.x4.net15 0.19062f
C6907 dc_inst.x1.net17 dc_inst.x1.net18 0.23806f
C6908 dc_inst.x1.net16 dc_inst.x1.net19 0
C6909 dc_inst.x7.x20/a_27_47# dc_inst.x7.net18 0
C6910 dc_inst.x5.net3 dc_inst.x5.net8 0.16683f
C6911 path_sel[1] dc_inst.x4.net9 0.0375f
C6912 dc_inst.x4.net4 dc_inst.x1.net19 0.01113f
C6913 VPWR _23_/a_193_47# 0.04702f
C6914 clknet_1_0__leaf_clk dc_inst.x7.x19/a_27_47# 0.00131f
C6915 dc_inst.x7.x2/a_27_47# dc_inst.x7.net18 0
C6916 dc_inst.x2.x16/a_27_47# dc_inst.x2.net19 0
C6917 dc_inst.x4.net6 dc_inst.x6.net14 0
C6918 dc_inst.net4 tdo 0.04252f
C6919 dc_inst.net1 dc_inst.x1.net18 0.2697f
C6920 VPWR dc_inst.x6.net4 0.03129f
C6921 path_sel[1] dc_inst.x1.x15/a_27_47# 0.01915f
C6922 dc_inst.x6.net17 dc_inst.x4.net5 0
C6923 dc_inst.x1.x5/a_27_47# dc_inst.x1.net3 0.11122f
C6924 dc_inst.x4.x15/a_27_47# dc_inst.x4.net17 0.00348f
C6925 _15_/a_288_47# dc_inst.x1.net5 0
C6926 dc_inst.x7.x18/a_27_47# dc_inst.x7.x2/a_27_47# 0.08729f
C6927 dc_inst.x3.x10/a_27_47# dc_inst.x3.net17 0
C6928 dc_inst.x7.x12/a_27_47# delay_sel[1] 0.00493f
C6929 dc_inst.x7.x11/a_27_47# dc_inst.x7.net11 0.00287f
C6930 dc_inst.x3.net3 dc_inst.x8/a_247_21# 0
C6931 dc_inst.x2.x3/a_27_47# path_sel[2] 0
C6932 dc_inst.x2.net2 dc_inst.x1.net18 0.02427f
C6933 dc_inst.x1.net15 dc_inst.x2.net19 0
C6934 VPWR dc_inst.x5.net19 0.1906f
C6935 rst _25_/a_1283_21# 0.03099f
C6936 _20_/a_79_21# _07_ 0.00107f
C6937 path[4] dc_inst.x3.net9 0
C6938 dc_inst.x1.net12 dc_inst.x5.net1 0
C6939 dc_inst.x6.net11 dc_inst.x6.x10/a_27_47# 0.01782f
C6940 dc_inst.x7.net12 dc_inst.x7.net13 0.10319f
C6941 dc_inst.x3.net2 dc_inst.x8/a_277_47# 0.01407f
C6942 dc_inst.x3.x10/a_27_47# dc_inst.x3.x9/a_27_47# 0
C6943 dc_inst.net7 dc_inst.x9/a_277_47# 0.06299f
C6944 delay_sel[0] dc_inst.x9/a_923_363# 0.00152f
C6945 dc_inst.x4.net6 dc_inst.x6.net18 0
C6946 dc_inst.net6 dc_inst.x6.x10/a_27_47# 0
C6947 dc_inst.x5.x20/a_27_47# clkbuf_1_0__f_clk/a_110_47# 0
C6948 dc_inst.x3.net16 capture_d 0
C6949 dc_inst.x3.net2 dc_inst.x1.net8 0
C6950 dc_inst.net7 delay_sel[2] 0
C6951 delay_sel[0] dc_inst.net8 0.01212f
C6952 dc_inst.x5.net11 _17_/a_174_21# 0
C6953 dc_inst.x1.x3/a_27_47# dc_inst.x3.net17 0
C6954 dc_inst.x7.x11/a_27_47# clkbuf_1_0__f_clk/a_110_47# 0
C6955 dc_inst.x3.net14 _15_/a_288_47# 0
C6956 clknet_1_1__leaf_clk _25_/a_1283_21# 0.01408f
C6957 dc_inst.x3.net13 _15_/a_788_316# 0
C6958 dc_inst.x3.net14 delay_sel[1] 0
C6959 dc_inst.x4.x11/a_27_47# path_sel[0] 0
C6960 dc_inst.x6.net16 delay_sel[1] 0
C6961 VPWR dc_inst.x3.net5 0.20057f
C6962 dc_inst.x4.net18 path_sel[0] 0.00333f
C6963 dc_inst.x4.net14 dc_inst.x4.x12/a_27_47# 0
C6964 capture_d dc_inst.in 0.20259f
C6965 dc_inst.x1.net17 dc_inst.x1.x9/a_27_47# 0
C6966 dc_inst.x1.x7/a_27_47# dc_inst.x1.x15/a_27_47# 0
C6967 path_sel[0] dc_inst.x1.net3 0.04931f
C6968 VPWR dc_inst.x3.net2 0.04279f
C6969 dc_inst.net7 dc_inst.x7.net17 0.05019f
C6970 se dc_inst.x3.x15/a_27_47# 0
C6971 _23_/a_193_47# dc_inst.x3.x5/a_27_47# 0
C6972 dc_inst.x2.net6 path_sel[0] 0.00147f
C6973 dc_inst.x6.net5 dc_inst.x6.net1 0.01066f
C6974 dc_inst.x8/a_27_47# dc_inst.in 0.01509f
C6975 dc_inst.x7.net4 dc_inst.x2.x20/a_27_47# 0
C6976 dc_inst.x4.net16 dc_inst.x4.x20/a_27_47# 0
C6977 dc_inst.x6.net4 dc_inst.x6.net6 0
C6978 delay_sel[2] _23_/a_651_413# 0.00332f
C6979 capture_d _23_/a_639_47# 0.00158f
C6980 dc_inst.net8 _23_/a_448_47# 0
C6981 dc_inst.x7.net12 _25_/a_761_289# 0
C6982 dc_inst.x2.x13/a_27_47# dc_inst.x2.x11/a_27_47# 0
C6983 dc_inst.x5.net12 dc_inst.x1.x8/a_27_47# 0
C6984 clknet_1_0__leaf_clk dc_inst.net5 0
C6985 dc_inst.x4.net6 dc_inst.x1.net19 0
C6986 dc_inst.x3.net15 dc_inst.x3.net3 0.01044f
C6987 dc_inst.x5.net19 dc_inst.x6.net6 0.02419f
C6988 dc_inst.x8/a_750_97# dc_inst.x2.net18 0
C6989 dc_inst.x4.x4/a_27_47# dc_inst.x2.net3 0
C6990 dc_inst.x6.x17/a_27_47# dc_inst.x7.net7 0
C6991 dc_inst.x6.x20/a_27_47# dc_inst.x6.net18 0
C6992 path_sel[1] _15_/a_372_413# 0
C6993 dc_inst.x1.net15 dc_inst.x2.x16/a_27_47# 0.0385f
C6994 dc_inst.x7.x4/a_27_47# dc_inst.x7.x5/a_27_47# 0.02448f
C6995 dc_inst.net2 dc_inst.x2.net19 0.00842f
C6996 dc_inst.x6.net10 dc_inst.x6.x10/a_27_47# 0.05394f
C6997 dc_inst.x2.x16/a_27_47# dc_inst.x2.x9/a_27_47# 0
C6998 dc_inst.net1 dc_inst.x2.x20/a_27_47# 0
C6999 dc_inst.x8/a_1478_413# dc_inst.net2 0.01881f
C7000 dc_inst.x5.x11/a_27_47# _07_ 0
C7001 dc_inst.x5.net4 dc_inst.x5.net1 0
C7002 VPWR dc_inst.x4.x10/a_27_47# 0.01915f
C7003 dc_inst.x6.x12/a_27_47# tdo 0.00205f
C7004 dc_inst.x5.net5 dc_inst.x2.x9/a_27_47# 0
C7005 dc_inst.x5.x9/a_27_47# dc_inst.x1.x9/a_27_47# 0
C7006 dc_inst.x10/a_76_199# clkload0/X 0
C7007 VPWR dc_inst.x4.net16 0.20286f
C7008 dc_inst.x5.net16 dc_inst.x7.net8 0
C7009 dc_inst.x6.net14 dc_inst.x6.x19/a_27_47# 0
C7010 dc_inst.x1.x14/a_27_47# dc_inst.x1.net7 0
C7011 _20_/a_79_21# _09_ 0
C7012 _24_/a_543_47# capture_q 0
C7013 dc_inst.x6.net17 capture_d 0
C7014 path_sel[1] dc_inst.x6.x13/a_27_47# 0
C7015 path_sel[0] dc_inst.x2.net12 0
C7016 dc_inst.x5.x17/a_27_47# dc_inst.x5.x14/a_27_47# 0
C7017 dc_inst.x3.net5 dc_inst.x3.x5/a_27_47# 0.01975f
C7018 path[2] _18_/a_535_374# 0
C7019 dc_inst.x3.net5 path[5] 0.06373f
C7020 dc_inst.x2.x3/a_27_47# dc_inst.x1.net17 0
C7021 dc_inst.x1.net4 path_sel[1] 0.07316f
C7022 dc_inst.x7.net9 dc_inst.x5.x20/a_27_47# 0.00177f
C7023 dc_inst.x3.net2 dc_inst.x3.x5/a_27_47# 0
C7024 _24_/a_1108_47# dc_inst.x3.net8 0
C7025 dc_inst.x8/a_27_47# dc_inst.x6.net17 0
C7026 dc_inst.x4.x13/a_27_47# dc_inst.x4.net17 0.0263f
C7027 dc_inst.x3.net2 path[5] 0.00302f
C7028 dc_inst.x2.net16 dc_inst.x1.net14 0
C7029 _24_/a_761_289# delay_sel[2] 0.01477f
C7030 _24_/a_1283_21# capture_d 0
C7031 dc_inst.x7.x16/a_27_47# clkbuf_1_0__f_clk/a_110_47# 0.0043f
C7032 VPWR dc_inst.x7.net16 -0.00264f
C7033 dc_inst.x6.net18 dc_inst.x6.x19/a_27_47# 0.0184f
C7034 path_sel[1] dc_inst.x6.net5 0
C7035 dc_inst.x3.net15 dc_inst.x3.x16/a_27_47# 0.12306f
C7036 se _13_/a_27_297# 0
C7037 dc_inst.x7.x9/a_27_47# dc_inst.x7.x14/a_27_47# 0
C7038 _15_/a_27_47# dc_inst.x1.net7 0
C7039 dc_inst.x1.x6/a_27_47# dc_inst.x1.net3 0
C7040 dc_inst.x6.x8/a_27_47# dc_inst.x6.net8 0.02031f
C7041 dc_inst.net7 _25_/a_1283_21# 0
C7042 dc_inst.x1.x16/a_27_47# dc_inst.x1.net16 0.01914f
C7043 dc_inst.x5.net2 dc_inst.x5.net12 0.0055f
C7044 dc_inst.x7.x15/a_27_47# dc_inst.x7.net10 0
C7045 delay_sel[0] dc_inst.x7.x4/a_27_47# 0.01187f
C7046 dc_inst.x6.x18/a_27_47# dc_inst.x6.net19 0.00101f
C7047 dc_inst.x4.net6 dc_inst.x6.net12 0
C7048 dc_inst.x4.net5 dc_inst.x2.x4/a_27_47# 0.00168f
C7049 dc_inst.x2.net2 dc_inst.x2.x3/a_27_47# 0
C7050 dc_inst.x8/a_834_97# dc_inst.x8/a_750_97# -0
C7051 dc_inst.x5.net5 dc_inst.x5.net9 0.38595f
C7052 dc_inst.x5.x17/a_27_47# dc_inst.x5.net15 0.01154f
C7053 path_sel[1] dc_inst.x4.x14/a_27_47# 0.00451f
C7054 dc_inst.x2.net13 path_sel[0] 0
C7055 dc_inst.x1.x16/a_27_47# dc_inst.x4.net4 0
C7056 _02_ path[7] 0.01765f
C7057 dc_inst.x1.x3/a_27_47# _15_/a_600_345# 0
C7058 tdo dc_inst.x4.x11/a_27_47# 0.00384f
C7059 dc_inst.x5.net2 dc_inst.x6.x5/a_27_47# 0
C7060 _25_/a_27_47# dc_inst.x7.net1 0.04335f
C7061 dc_inst.x2.net10 _17_/a_574_297# 0
C7062 dc_inst.x1.x18/a_27_47# dc_inst.x1.net18 0.00232f
C7063 dc_inst.x4.net18 tdo 0
C7064 dc_inst.x3.net4 path_sel[0] 0.00104f
C7065 dc_inst.x5.net1 _17_/a_174_21# 0
C7066 dc_inst.x5.x19/a_27_47# dc_inst.x6.x8/a_27_47# 0
C7067 _15_/a_27_47# dc_inst.x2.x19/a_27_47# 0
C7068 dc_inst.x4.net16 dc_inst.x6.net6 0
C7069 dc_inst.x2.x9/a_27_47# dc_inst.x5.net9 0
C7070 dc_inst.x1.x7/a_27_47# dc_inst.x1.net4 0
C7071 dc_inst.x1.x4/a_27_47# dc_inst.x1.net7 0
C7072 dc_inst.x3.x17/a_27_47# rst 0
C7073 tdo dc_inst.x2.net6 0
C7074 dc_inst.x5.x1/a_27_47# dc_inst.x4.net17 0.00616f
C7075 delay_sel[2] dc_inst.x3.x15/a_27_47# 0
C7076 dc_inst.net6 clknet_1_0__leaf_clk 0
C7077 dc_inst.x4.net2 dc_inst.net8 0
C7078 dc_inst.x5.x14/a_27_47# dc_inst.x4.net17 0
C7079 dc_inst.x7.net9 dc_inst.x7.net7 0
C7080 dc_inst.x1.net15 dc_inst.net2 0
C7081 dc_inst.x3.x12/a_27_47# dc_inst.x3.net2 0
C7082 dc_inst.x1.net16 dc_inst.x1.x19/a_27_47# 0
C7083 dc_inst.x5.x6/a_27_47# dc_inst.x4.x12/a_27_47# 0
C7084 dc_inst.x7.net4 clknet_1_0__leaf_clk 0
C7085 dc_inst.x5.net6 path_sel[0] 0.00225f
C7086 dc_inst.x4.net5 dc_inst.x4.x7/a_27_47# 0.01107f
C7087 dc_inst.x1.net10 dc_inst.x2.net15 0
C7088 capture_d clkload0/a_27_47# 0.015f
C7089 dc_inst.x3.net18 dc_inst.x3.x2/a_27_47# 0
C7090 dc_inst.x8/a_193_413# dc_inst.x8/a_247_21# -0.0024f
C7091 dc_inst.x8/a_27_413# dc_inst.x8/a_277_47# -0.00157f
C7092 dc_inst.x4.net15 dc_inst.x4.net14 0.16244f
C7093 dc_inst.x4.net4 dc_inst.x1.x19/a_27_47# 0
C7094 _15_/a_788_316# dc_inst.x3.net9 0
C7095 dc_inst.x3.x20/a_27_47# dc_inst.net8 0.00414f
C7096 VPWR dc_inst.x2.net5 0.07018f
C7097 dc_inst.x3.x17/a_27_47# clknet_1_1__leaf_clk 0
C7098 dc_inst.x7.net19 delay_sel[1] 0
C7099 dc_inst.x4.net14 dc_inst.x5.net8 0.00709f
C7100 dc_inst.x3.net14 capture_q 0
C7101 dc_inst.x7.net1 dc_inst.x7.x4/a_27_47# 0
C7102 clkbuf_1_0__f_clk/a_110_47# _23_/a_193_47# 0
C7103 dc_inst.x6.x20/a_27_47# dc_inst.x6.net12 0
C7104 _18_/a_218_47# path_sel[0] 0
C7105 dc_inst.x1.net8 dc_inst.x3.x3/a_27_47# 0
C7106 VPWR dc_inst.x3.net12 0.23912f
C7107 dc_inst.x7.net1 _25_/a_1217_47# 0
C7108 dc_inst.x5.net15 dc_inst.x4.net17 0
C7109 path_sel[1] dc_inst.x6.net7 0.02273f
C7110 _10_ _19_/a_193_297# 0
C7111 dc_inst.x3.x8/a_27_47# capture_q 0
C7112 _07_ dc_inst.x1.net6 0
C7113 VPWR dc_inst.x8/a_27_413# -0.01205f
C7114 tdo dc_inst.x2.net12 0
C7115 dc_inst.x4.x18/a_27_47# dc_inst.x4.net17 0.01227f
C7116 dc_inst.x5.net19 clkbuf_1_0__f_clk/a_110_47# 0
C7117 path_sel[2] dc_inst.x1.x5/a_27_47# 0.00252f
C7118 dc_inst.x2.x17/a_27_47# dc_inst.x1.net14 0
C7119 path[3] _15_/a_1279_413# 0
C7120 dc_inst.net3 dc_inst.x2.x20/a_27_47# 0.00212f
C7121 dc_inst.x1.x14/a_27_47# dc_inst.x2.net17 0.1093f
C7122 dc_inst.x9/a_1478_413# tdo 0.01619f
C7123 VPWR dc_inst.x3.x3/a_27_47# 0
C7124 VPWR dc_inst.x4.x5/a_27_47# -0
C7125 _23_/a_193_47# dc_inst.net9 0
C7126 dc_inst.x4.x19/a_27_47# dc_inst.x5.net12 0.00484f
C7127 path[2] _07_ 0.00571f
C7128 dc_inst.x3.net11 dc_inst.x3.net18 0
C7129 dc_inst.x6.x18/a_27_47# dc_inst.x2.net19 0
C7130 dc_inst.x5.net13 dc_inst.x5.x15/a_27_47# 0
C7131 dc_inst.x4.net9 dc_inst.x4.x10/a_27_47# 0
C7132 _16_/a_27_93# dc_inst.x5.net9 0
C7133 dc_inst.x6.x19/a_27_47# rst 0
C7134 _10_ _08_ 0.05861f
C7135 _13_/a_27_297# delay_sel[2] 0
C7136 dc_inst.x4.net16 dc_inst.x4.net9 0.0438f
C7137 dc_inst.x6.net12 dc_inst.x6.x19/a_27_47# 0
C7138 _20_/a_79_21# _18_/a_76_199# 0
C7139 dc_inst.x4.x2/a_27_47# delay_sel[0] 0
C7140 dc_inst.x7.x11/a_27_47# delay_sel[2] 0.00232f
C7141 dc_inst.x2.x19/a_27_47# dc_inst.x6.net19 0
C7142 VPWR dc_inst.x2.net11 0
C7143 _15_/a_193_47# dc_inst.x2.net19 0
C7144 dc_inst.x7.x10/a_27_47# dc_inst.x7.x6/a_27_47# 0.01254f
C7145 dc_inst.in path[7] 0.0034f
C7146 _03_ _25_/a_1108_47# 0.00291f
C7147 dc_inst.x4.net19 dc_inst.net4 0.00364f
C7148 dc_inst.x2.net7 dc_inst.x4.net11 0
C7149 dc_inst.x2.x10/a_27_47# dc_inst.x5.net9 0
C7150 path_sel[0] path_sel[2] 0.0031f
C7151 dc_inst.x2.net16 delay_sel[1] 0
C7152 dc_inst.x4.net7 tdo 0.14328f
C7153 dc_inst.x2.net10 dc_inst.x1.net14 0
C7154 dc_inst.x3.net12 path[5] 0.03855f
C7155 dc_inst.x5.x16/a_27_47# dc_inst.x5.x15/a_27_47# 0.02448f
C7156 dc_inst.x8/a_668_97# dc_inst.in 0
C7157 delay_sel[1] dc_inst.x3.net3 0
C7158 dc_inst.x3.net11 dc_inst.x3.net7 0
C7159 dc_inst.x6.net5 dc_inst.x6.net4 0.03371f
C7160 dc_inst.x5.net13 dc_inst.x5.net14 0.23431f
C7161 dc_inst.x7.net5 clknet_1_0__leaf_clk 0
C7162 dc_inst.x4.x1/a_27_47# _15_/a_27_47# 0
C7163 dc_inst.x5.net6 tdo 0.0545f
C7164 dc_inst.x4.net3 dc_inst.net8 0
C7165 dc_inst.x4.x2/a_27_47# dc_inst.x7.net2 0
C7166 _24_/a_27_47# clknet_0_clk 0
C7167 dc_inst.net2 _24_/a_1108_47# 0
C7168 dc_inst.x2.net4 dc_inst.x2.x5/a_27_47# 0
C7169 dc_inst.x6.net5 dc_inst.x5.net19 0.00306f
C7170 _09_ dc_inst.x1.net6 0.00221f
C7171 dc_inst.net8 _23_/a_1283_21# 0
C7172 delay_sel[2] _23_/a_1108_47# 0.01664f
C7173 dc_inst.x4.net16 dc_inst.x6.x17/a_27_47# 0
C7174 dc_inst.x2.net17 dc_inst.x1.x8/a_27_47# 0.01477f
C7175 dc_inst.x5.net5 dc_inst.x5.net12 0.00207f
C7176 dc_inst.x5.net17 dc_inst.x5.net15 0
C7177 dc_inst.x7.net9 dc_inst.x5.net19 0.06838f
C7178 _07_ dc_inst.x5.net10 0
C7179 VPWR dc_inst.x10/a_218_374# -0.00163f
C7180 _01_ dc_inst.x8/a_247_21# 0
C7181 dc_inst.x1.net15 dc_inst.x5.net12 0
C7182 dc_inst.x5.net14 dc_inst.x5.x2/a_27_47# 0
C7183 dc_inst.x7.net6 dc_inst.net5 0.14064f
C7184 VPWR shadow_q 0.06848f
C7185 dc_inst.x1.net4 dc_inst.x3.net5 0
C7186 dc_inst.x5.net12 dc_inst.x2.x9/a_27_47# 0.00179f
C7187 _09_ path[2] 0.00166f
C7188 dc_inst.x8/a_750_97# dc_inst.x8/a_277_47# -0.08341f
C7189 dc_inst.x8/a_1290_413# dc_inst.x8/a_247_21# -0.00452f
C7190 dc_inst.x4.net15 dc_inst.x5.x6/a_27_47# 0
C7191 dc_inst.x5.net14 dc_inst.x5.x16/a_27_47# 0.00348f
C7192 dc_inst.x6.x20/a_27_47# dc_inst.net7 0
C7193 dc_inst.x7.x20/a_27_47# dc_inst.x6.net15 0
C7194 _23_/a_193_47# _24_/a_448_47# 0
C7195 dc_inst.x3.net16 dc_inst.x1.x1/a_27_47# 0
C7196 dc_inst.x1.net4 dc_inst.x3.net2 0.0886f
C7197 dc_inst.x9/a_277_47# dc_inst.x7.x16/a_27_47# 0
C7198 VPWR _19_/a_109_297# 0
C7199 dc_inst.x7.net16 clkbuf_1_0__f_clk/a_110_47# 0.00736f
C7200 dc_inst.x4.net19 dc_inst.x6.net8 0
C7201 dc_inst.x7.net6 path_sel[2] 0.00478f
C7202 dc_inst.net4 dc_inst.x6.x11/a_27_47# 0.01578f
C7203 dc_inst.x7.x16/a_27_47# delay_sel[2] 0
C7204 dc_inst.x3.x12/a_27_47# dc_inst.x3.net12 0.03379f
C7205 _06_ path[4] 0.01425f
C7206 path[6] path[7] 0.12921f
C7207 dc_inst.x1.x4/a_27_47# dc_inst.x5.net11 0
C7208 dc_inst.x4.net9 dc_inst.x2.net5 0
C7209 dc_inst.x1.net9 dc_inst.x2.x18/a_27_47# 0.03525f
C7210 VPWR dc_inst.x4.x12/a_27_47# -0.01014f
C7211 VPWR dc_inst.x10/a_218_47# -0
C7212 dc_inst.x1.x1/a_27_47# dc_inst.in 0.04327f
C7213 VPWR dc_inst.x2.x11/a_27_47# -0.00202f
C7214 dc_inst.x1.net13 dc_inst.x1.x9/a_27_47# 0
C7215 VPWR clk 0.07929f
C7216 dc_inst.x4.net8 dc_inst.x4.net17 0
C7217 delay_sel[0] dc_inst.x6.x15/a_27_47# 0
C7218 path[4] _15_/a_1281_47# 0
C7219 dc_inst.x3.net5 se 0
C7220 dc_inst.x7.x9/a_27_47# dc_inst.x7.net12 0.01149f
C7221 VPWR dc_inst.x8/a_750_97# -0.19511f
C7222 dc_inst.x9/a_1478_413# dc_inst.x7.net3 0
C7223 dc_inst.x2.x19/a_27_47# dc_inst.x2.net19 0.04302f
C7224 dc_inst.x4.net15 dc_inst.x5.net13 0
C7225 dc_inst.x1.net11 _19_/a_193_297# 0.00694f
C7226 dc_inst.x7.x16/a_27_47# dc_inst.x7.net17 0.0018f
C7227 dc_inst.x3.net17 path[7] 0
C7228 dc_inst.x1.net15 dc_inst.x2.net14 0
C7229 dc_inst.x7.net16 dc_inst.net9 0
C7230 dc_inst.net7 dc_inst.x6.x19/a_27_47# 0
C7231 dc_inst.x9/a_247_21# dc_inst.x7.net19 0
C7232 tdo dc_inst.net5 0.00932f
C7233 _10_ dc_inst.in 0.00555f
C7234 dc_inst.x6.x6/a_27_47# dc_inst.x4.net17 0
C7235 dc_inst.x3.x11/a_27_47# _02_ 0.00609f
C7236 dc_inst.x3.x1/a_27_47# dc_inst.x8/a_277_47# 0
C7237 dc_inst.x5.net12 dc_inst.x5.net9 0.03946f
C7238 VPWR dc_inst.x5.x15/a_27_47# 0.00863f
C7239 dc_inst.x5.net6 dc_inst.x6.x8/a_27_47# 0
C7240 dc_inst.x6.net4 dc_inst.x6.net7 0
C7241 dc_inst.x3.x9/a_27_47# path[7] 0
C7242 path[3] path[4] 0.09977f
C7243 dc_inst.x2.x17/a_27_47# delay_sel[1] 0
C7244 dc_inst.x4.x9/a_27_47# dc_inst.x4.net5 0
C7245 dc_inst.x4.net9 dc_inst.x4.x5/a_27_47# 0
C7246 dc_inst.x5.net5 dc_inst.x2.x8/a_27_47# 0
C7247 dc_inst.x3.net15 _01_ 0.00619f
C7248 dc_inst.x4.net15 dc_inst.x5.x2/a_27_47# 0
C7249 shadow_q dc_inst.x3.x5/a_27_47# 0.00455f
C7250 tdo path_sel[2] 0.0443f
C7251 dc_inst.x2.net14 dc_inst.x2.net3 0
C7252 dc_inst.x1.net10 dc_inst.x2.x15/a_27_47# 0
C7253 dc_inst.x1.net12 path[7] 0
C7254 path[5] shadow_q 0
C7255 dc_inst.x1.net11 _08_ 0.01026f
C7256 dc_inst.x9/a_1290_413# dc_inst.x6.net15 0.00113f
C7257 dc_inst.x1.net15 dc_inst.x2.x8/a_27_47# 0
C7258 dc_inst.x4.x1/a_27_47# dc_inst.x6.net19 0
C7259 dc_inst.x7.net3 dc_inst.x3.net4 0.00243f
C7260 dc_inst.x6.x11/a_27_47# dc_inst.x6.net8 0
C7261 dc_inst.x2.x9/a_27_47# dc_inst.x2.x8/a_27_47# 0
C7262 dc_inst.x1.net10 dc_inst.x1.x11/a_27_47# 0
C7263 dc_inst.x5.x12/a_27_47# dc_inst.x1.x9/a_27_47# 0.01013f
C7264 dc_inst.x7.net2 dc_inst.x6.x15/a_27_47# 0
C7265 dc_inst.x4.x2/a_27_47# dc_inst.x4.net2 0.01556f
C7266 VPWR _25_/a_1108_47# -0.00109f
C7267 dc_inst.x1.net3 dc_inst.x3.x2/a_27_47# 0.01318f
C7268 dc_inst.x1.x20/a_27_47# dc_inst.x1.net16 0
C7269 dc_inst.x4.x16/a_27_47# dc_inst.x4.net17 0.00669f
C7270 dc_inst.x2.x16/a_27_47# dc_inst.x1.net7 0
C7271 path[4] _19_/a_27_47# 0
C7272 dc_inst.x2.x1/a_27_47# dc_inst.x2.net14 0
C7273 path_sel[1] dc_inst.x1.net16 0
C7274 dc_inst.x7.x13/a_27_47# dc_inst.net4 0
C7275 VPWR dc_inst.x3.x1/a_27_47# 0.00992f
C7276 _24_/a_193_47# _01_ 0.00202f
C7277 _15_/a_872_316# dc_inst.in 0
C7278 _05_ path[7] 0.00692f
C7279 dc_inst.x3.net15 _02_ 0
C7280 dc_inst.x4.net4 dc_inst.x1.x20/a_27_47# 0
C7281 dc_inst.net7 dc_inst.x9/a_27_47# 0
C7282 dc_inst.x4.net16 dc_inst.x4.x14/a_27_47# 0.00426f
C7283 delay_sel[2] _23_/a_193_47# 0.0421f
C7284 dc_inst.net8 _23_/a_27_47# 0.00393f
C7285 dc_inst.x3.net6 _15_/a_1060_369# 0
C7286 path_sel[1] dc_inst.x4.net4 0
C7287 clkbuf_1_1__f_clk/a_110_47# clknet_0_clk 0.00955f
C7288 dc_inst.x1.x1/a_27_47# path[6] 0
C7289 dc_inst.x9/a_277_47# dc_inst.x6.net4 0
C7290 dc_inst.x1.x2/a_27_47# path[7] 0
C7291 dc_inst.x2.net14 dc_inst.x5.net9 0
C7292 dc_inst.x1.net15 dc_inst.x1.net7 0
C7293 dc_inst.x7.x17/a_27_47# capture_d 0
C7294 dc_inst.x8/a_750_97# path[5] 0
C7295 dc_inst.x5.x9/a_27_47# path_sel[0] 0.0029f
C7296 VPWR dc_inst.x5.net14 0.2586f
C7297 dc_inst.x6.x9/a_27_47# dc_inst.x7.net6 0
C7298 dc_inst.net4 dc_inst.x6.x3/a_27_47# 0.00318f
C7299 dc_inst.net6 dc_inst.x7.net6 0.03924f
C7300 dc_inst.x7.x14/a_27_47# delay_sel[1] 0.00457f
C7301 dc_inst.x2.x16/a_27_47# dc_inst.x2.x19/a_27_47# 0
C7302 dc_inst.x2.x12/a_27_47# dc_inst.x5.net4 0.01151f
C7303 _20_/a_470_297# path[2] 0
C7304 dc_inst.x9/a_750_97# dc_inst.x7.net16 0
C7305 _24_/a_193_47# _02_ -0.00164f
C7306 dc_inst.x2.net4 dc_inst.x2.x4/a_27_47# 0.12862f
C7307 dc_inst.x2.x10/a_27_47# dc_inst.x5.net12 0.02061f
C7308 dc_inst.x7.net4 dc_inst.x7.net6 0.05055f
C7309 dc_inst.x5.net8 dc_inst.x5.x3/a_27_47# 0
C7310 dc_inst.x4.net18 dc_inst.x4.net19 0.02916f
C7311 dc_inst.x7.net8 delay_sel[1] 0
C7312 _20_/a_79_21# dc_inst.x3.net7 0
C7313 _03_ _24_/a_543_47# 0
C7314 dc_inst.x3.net17 dc_inst.x1.x1/a_27_47# 0
C7315 delay_sel[0] dc_inst.x8/a_757_363# 0.00724f
C7316 dc_inst.x1.x14/a_27_47# dc_inst.x4.net5 0
C7317 capture_q dc_inst.x3.net3 0
C7318 dc_inst.x2.x18/a_27_47# dc_inst.x2.net12 0
C7319 dc_inst.x1.net15 dc_inst.x2.x19/a_27_47# 0
C7320 dc_inst.x5.net9 dc_inst.x2.x8/a_27_47# 0
C7321 dc_inst.x6.x8/a_27_47# dc_inst.net5 0
C7322 dc_inst.x1.net6 _18_/a_76_199# 0
C7323 _04_ dc_inst.x1.x12/a_27_47# 0
C7324 dc_inst.in dc_inst.x8/a_247_21# 0.00692f
C7325 dc_inst.net6 dc_inst.x9/a_834_97# 0.00326f
C7326 tdo dc_inst.x6.net11 0.02241f
C7327 dc_inst.x6.x8/a_27_47# path_sel[2] 0.0053f
C7328 dc_inst.x8/a_1478_413# dc_inst.x2.net17 0
C7329 dc_inst.x8/a_27_413# dc_inst.net9 0.04336f
C7330 dc_inst.x8/a_193_413# delay_sel[1] 0.00365f
C7331 dc_inst.x1.net9 dc_inst.x1.net2 0
C7332 dc_inst.x9/a_193_47# dc_inst.x7.net1 0
C7333 dc_inst.x3.net5 delay_sel[2] 0.00147f
C7334 dc_inst.x5.x10/a_27_47# dc_inst.x5.net10 0.04506f
C7335 path[2] _18_/a_76_199# 0.01355f
C7336 dc_inst.net6 tdo 0
C7337 tdo _25_/a_1462_47# 0
C7338 _15_/a_600_345# path[7] 0.03374f
C7339 dc_inst.x4.net16 dc_inst.x6.net7 0
C7340 dc_inst.x3.net2 delay_sel[2] 0
C7341 dc_inst.x7.net4 tdo 0.01921f
C7342 dc_inst.x6.x3/a_27_47# dc_inst.x6.net8 0.01273f
C7343 dc_inst.x6.x8/a_27_47# dc_inst.x6.x7/a_27_47# 0
C7344 dc_inst.net4 dc_inst.x7.x5/a_27_47# 0.01302f
C7345 dc_inst.x1.net4 dc_inst.x3.net12 0
C7346 dc_inst.x4.x1/a_27_47# dc_inst.x2.net19 0.00236f
C7347 dc_inst.x6.net6 dc_inst.x5.net14 0.00607f
C7348 VPWR dc_inst.x4.net15 0.02106f
C7349 tdo dc_inst.x1.net17 0.02307f
C7350 _10_ dc_inst.x1.net12 0.01622f
C7351 dc_inst.x4.net9 dc_inst.x4.x12/a_27_47# 0.00135f
C7352 VPWR dc_inst.x3.net6 0.38699f
C7353 dc_inst.x3.x16/a_27_47# capture_q 0.01158f
C7354 VPWR dc_inst.x5.net8 0.00983f
C7355 _16_/a_27_93# _17_/a_27_93# 0.01199f
C7356 _16_/a_229_47# _17_/a_174_21# 0
C7357 path_sel[1] dc_inst.x4.net6 0.00275f
C7358 _03_ dc_inst.x7.x12/a_27_47# 0
C7359 dc_inst.x2.net17 dc_inst.x4.x4/a_27_47# 0
C7360 dc_inst.x6.net14 dc_inst.x9/a_1290_413# 0
C7361 VPWR _23_/a_1270_413# 0
C7362 dc_inst.x3.net15 dc_inst.x3.net16 0.00349f
C7363 _13_/a_470_47# dc_inst.x3.net18 0
C7364 dc_inst.net1 tdo 0.13106f
C7365 dc_inst.x1.net2 dc_inst.x1.net3 0.08036f
C7366 _15_/a_788_316# _06_ 0.00273f
C7367 dc_inst.x1.net11 dc_inst.in 0
C7368 dc_inst.x4.net13 dc_inst.x5.net7 0
C7369 dc_inst.x4.net1 dc_inst.x4.x11/a_27_47# 0.02333f
C7370 clkbuf_1_1__f_clk/a_110_47# dc_inst.x3.x4/a_27_47# 0
C7371 _23_/a_1462_47# delay_sel[2] 0
C7372 dc_inst.x4.net3 dc_inst.x4.x2/a_27_47# 0.01503f
C7373 dc_inst.x6.net13 dc_inst.x6.net19 0
C7374 _15_/a_1064_47# dc_inst.x1.net3 0
C7375 se dc_inst.x3.net12 0
C7376 dc_inst.x4.net12 dc_inst.x6.x10/a_27_47# 0
C7377 dc_inst.x1.x12/a_27_47# dc_inst.x1.net5 0.00126f
C7378 dc_inst.net2 dc_inst.x2.x19/a_27_47# 0.00357f
C7379 dc_inst.x2.net2 tdo 0.00177f
C7380 dc_inst.x4.net3 dc_inst.x1.x17/a_27_47# 0
C7381 dc_inst.x1.net10 path[3] 0.00227f
C7382 dc_inst.x8/a_27_413# dc_inst.x9/a_750_97# 0
C7383 _15_/a_788_316# _15_/a_1281_47# -0
C7384 dc_inst.x4.x17/a_27_47# dc_inst.x5.net12 0
C7385 dc_inst.x7.net11 clk 0.05534f
C7386 dc_inst.x3.net19 dc_inst.x3.x6/a_27_47# 0
C7387 dc_inst.x5.net3 dc_inst.x2.net7 0.01987f
C7388 _20_/a_384_47# path_sel[0] 0.00984f
C7389 dc_inst.x6.net10 tdo 0
C7390 dc_inst.x2.x16/a_27_47# dc_inst.x2.net17 0.00108f
C7391 dc_inst.x6.net18 dc_inst.x9/a_1290_413# 0.01236f
C7392 dc_inst.x1.x3/a_27_47# dc_inst.x3.x18/a_27_47# 0.01254f
C7393 dc_inst.net3 path_sel[0] 0
C7394 dc_inst.x5.x8/a_27_47# path_sel[0] 0.00219f
C7395 dc_inst.x6.x8/a_27_47# dc_inst.x6.net11 0
C7396 dc_inst.net4 delay_sel[0] 0.36399f
C7397 se dc_inst.x3.x3/a_27_47# 0
C7398 dc_inst.x9/a_277_47# dc_inst.x7.net16 0
C7399 _24_/a_193_47# dc_inst.in 0.00225f
C7400 dc_inst.x7.net6 dc_inst.x7.net5 0.22699f
C7401 dc_inst.x1.net10 _19_/a_27_47# 0
C7402 dc_inst.x7.net16 delay_sel[2] 0
C7403 dc_inst.x1.net15 dc_inst.x2.net17 0.07311f
C7404 dc_inst.x4.net19 dc_inst.x4.net7 0
C7405 dc_inst.x5.x14/a_27_47# dc_inst.x5.net16 0.00106f
C7406 dc_inst.x6.x9/a_27_47# dc_inst.x6.x8/a_27_47# 0
C7407 tdi _14_/a_505_21# 0.03354f
C7408 dc_inst.x3.x11/a_27_47# path[6] 0.00326f
C7409 _15_/a_788_316# path[3] 0.00202f
C7410 _15_/a_600_345# dc_inst.x1.x1/a_27_47# 0
C7411 clkbuf_1_0__f_clk/a_110_47# clk 0.00266f
C7412 dc_inst.x3.net6 dc_inst.x3.x5/a_27_47# 0.00202f
C7413 dc_inst.x4.net10 dc_inst.x2.net7 0.04458f
C7414 path[5] dc_inst.x3.net6 0.03377f
C7415 VPWR _24_/a_543_47# 0.02355f
C7416 VPWR _04_ 0.10399f
C7417 path_sel[0] _18_/a_505_21# 0.02522f
C7418 dc_inst.net2 _24_/a_27_47# 0
C7419 dc_inst.x7.net16 dc_inst.x7.net17 0.02492f
C7420 dc_inst.x2.net14 dc_inst.x5.net12 0.00132f
C7421 _15_/a_788_316# _19_/a_27_47# 0
C7422 dc_inst.x3.net14 _15_/a_1060_369# 0
C7423 dc_inst.x4.x1/a_27_47# dc_inst.x1.net15 0
C7424 dc_inst.x4.net1 dc_inst.x2.net12 0
C7425 dc_inst.x1.x13/a_27_47# dc_inst.x2.net10 0
C7426 dc_inst.x7.net5 dc_inst.x9/a_834_97# 0
C7427 dc_inst.x1.net14 dc_inst.in 0
C7428 dc_inst.x1.net15 dc_inst.x5.net11 0
C7429 dc_inst.x2.x3/a_27_47# dc_inst.x2.x7/a_27_47# 0.01254f
C7430 dc_inst.x6.net16 dc_inst.x6.net2 0
C7431 _14_/a_76_199# shadow_q 0.00236f
C7432 dc_inst.x7.net2 dc_inst.net4 0.01587f
C7433 dc_inst.x10/a_218_47# dc_inst.net9 0
C7434 dc_inst.x3.net15 path[6] 0.01335f
C7435 delay_sel[1] _01_ 0
C7436 _20_/a_79_21# dc_inst.x1.net3 0.00976f
C7437 dc_inst.x2.net9 path_sel[0] 0
C7438 dc_inst.x5.net15 dc_inst.x5.net16 0.25927f
C7439 dc_inst.x3.net1 dc_inst.x3.x13/a_27_47# 0.01163f
C7440 dc_inst.x1.net4 shadow_q 0
C7441 dc_inst.x7.x20/a_27_47# rst 0.04098f
C7442 path[0] _18_/a_505_21# 0.00326f
C7443 dc_inst.x3.x11/a_27_47# dc_inst.x3.x9/a_27_47# 0.01254f
C7444 dc_inst.x8/a_1290_413# delay_sel[1] 0.00303f
C7445 tdi _14_/a_218_47# 0
C7446 dc_inst.net4 dc_inst.x7.net1 0.05963f
C7447 dc_inst.x5.x4/a_27_47# dc_inst.x5.net10 0.00267f
C7448 dc_inst.x1.net8 dc_inst.x1.net5 0.00402f
C7449 dc_inst.x7.x2/a_27_47# rst 0.00176f
C7450 dc_inst.x7.net4 dc_inst.x7.net3 0.15f
C7451 dc_inst.x5.net12 dc_inst.x2.x8/a_27_47# 0
C7452 dc_inst.x6.net10 dc_inst.x6.x8/a_27_47# 0
C7453 dc_inst.x2.x18/a_27_47# path_sel[2] 0.00603f
C7454 _14_/a_505_21# rst 0.086f
C7455 _24_/a_193_47# path[6] 0
C7456 dc_inst.x4.net3 dc_inst.x6.x15/a_27_47# 0
C7457 dc_inst.x3.net15 dc_inst.x3.net17 0
C7458 dc_inst.x2.net16 dc_inst.x2.net18 0
C7459 _02_ delay_sel[1] 0
C7460 dc_inst.x2.net15 dc_inst.x1.x17/a_27_47# 0.03623f
C7461 VPWR dc_inst.x3.x19/a_27_47# -0.00377f
C7462 path_sel[2] dc_inst.x3.x2/a_27_47# 0
C7463 dc_inst.x9/a_27_47# dc_inst.x5.x20/a_27_47# 0
C7464 dc_inst.x4.net3 dc_inst.x7.x3/a_27_47# 0
C7465 dc_inst.x1.net13 dc_inst.x1.x5/a_27_47# 0
C7466 VPWR dc_inst.x1.net5 0.51133f
C7467 _05_ dc_inst.x3.x11/a_27_47# 0
C7468 VPWR dc_inst.x7.x12/a_27_47# 0.04011f
C7469 dc_inst.x5.net18 dc_inst.x6.net8 0.00794f
C7470 tdo dc_inst.x4.x8/a_27_47# 0.00679f
C7471 se shadow_q 0
C7472 dc_inst.x1.net4 dc_inst.x8/a_750_97# 0
C7473 _04_ path[5] 0
C7474 dc_inst.net4 dc_inst.x7.x7/a_27_47# 0.00138f
C7475 dc_inst.net1 dc_inst.x7.net3 0
C7476 dc_inst.x3.net15 dc_inst.x3.x9/a_27_47# 0
C7477 _23_/a_1283_21# dc_inst.x7.x3/a_27_47# 0
C7478 dc_inst.x5.net6 dc_inst.x6.x11/a_27_47# 0
C7479 dc_inst.x1.net11 dc_inst.x1.net12 0.03659f
C7480 dc_inst.x2.net1 _07_ 0
C7481 dc_inst.x4.net1 dc_inst.x4.net7 0.00367f
C7482 _23_/a_27_47# clkload0/X 0
C7483 dc_inst.x6.x12/a_27_47# delay_sel[0] 0
C7484 dc_inst.x8/a_193_413# dc_inst.x9/a_247_21# 0
C7485 _14_/a_505_21# clknet_1_1__leaf_clk 0
C7486 delay_sel[1] _25_/a_448_47# 0
C7487 dc_inst.x8/a_27_413# delay_sel[2] 0
C7488 dc_inst.x7.net12 delay_sel[1] 0.17559f
C7489 dc_inst.x6.x1/a_27_47# dc_inst.x6.net16 0.00209f
C7490 dc_inst.x1.net14 path[6] 0
C7491 dc_inst.x9/a_1290_413# rst 0.00117f
C7492 dc_inst.x4.x1/a_27_47# dc_inst.net2 0
C7493 dc_inst.net3 tdo 0
C7494 dc_inst.x5.x8/a_27_47# tdo 0.01841f
C7495 dc_inst.x4.net1 dc_inst.x5.net6 0
C7496 dc_inst.x5.net18 dc_inst.x5.x19/a_27_47# 0.12901f
C7497 dc_inst.x6.net12 dc_inst.x9/a_1290_413# 0
C7498 _14_/a_218_47# rst 0
C7499 dc_inst.x3.x3/a_27_47# delay_sel[2] 0
C7500 dc_inst.x5.net2 dc_inst.x4.net17 0.00181f
C7501 dc_inst.x1.x6/a_27_47# _18_/a_505_21# 0
C7502 VPWR dc_inst.x3.net14 0.13751f
C7503 dc_inst.x7.net1 dc_inst.x6.net8 0
C7504 VPWR dc_inst.x6.net16 0.03455f
C7505 dc_inst.x3.net19 dc_inst.x3.net10 0
C7506 dc_inst.x4.net19 path_sel[2] 0.00128f
C7507 dc_inst.x1.x2/a_27_47# dc_inst.x1.net11 0
C7508 dc_inst.net4 dc_inst.x7.net18 0
C7509 clknet_0_clk capture_d 0
C7510 dc_inst.x1.x18/a_27_47# tdo 0.01323f
C7511 dc_inst.x7.x15/a_27_47# dc_inst.x9/a_27_413# 0
C7512 dc_inst.x2.net14 dc_inst.x1.net7 0
C7513 VPWR dc_inst.x3.x8/a_27_47# 0.00706f
C7514 dc_inst.x7.net7 dc_inst.x9/a_27_47# 0
C7515 delay_sel[2] _24_/a_1462_47# 0
C7516 dc_inst.x5.x18/a_27_47# dc_inst.x5.net18 0.04365f
C7517 _14_/a_218_47# clknet_1_1__leaf_clk 0
C7518 _14_/a_218_374# _02_ 0
C7519 dc_inst.x4.net19 dc_inst.x6.x7/a_27_47# 0
C7520 dc_inst.x4.x13/a_27_47# dc_inst.x4.net11 0.00139f
C7521 dc_inst.x2.x16/a_27_47# dc_inst.x6.net13 0
C7522 dc_inst.x7.net2 dc_inst.x6.x12/a_27_47# 0
C7523 _24_/a_193_47# clkload0/a_27_47# 0.00129f
C7524 clkbuf_1_1__f_clk/a_110_47# dc_inst.net2 0
C7525 _03_ dc_inst.x7.net19 0
C7526 _24_/a_651_413# rst 0
C7527 dc_inst.x3.net13 dc_inst.x3.net18 0
C7528 dc_inst.x3.x19/a_27_47# dc_inst.x3.x5/a_27_47# 0
C7529 dc_inst.x3.x12/a_27_47# _04_ 0
C7530 dc_inst.x2.net8 dc_inst.x2.net6 0
C7531 dc_inst.x7.x7/a_27_47# dc_inst.x6.net8 0
C7532 dc_inst.x3.x19/a_27_47# path[5] 0.00938f
C7533 path[5] dc_inst.x1.net5 0
C7534 dc_inst.x3.net1 path[4] 0.0013f
C7535 dc_inst.x8/a_834_97# dc_inst.x3.net3 0
C7536 dc_inst.x5.net3 dc_inst.x2.x6/a_27_47# 0.03903f
C7537 dc_inst.x2.x10/a_27_47# dc_inst.x5.net11 0.11178f
C7538 dc_inst.x1.net15 dc_inst.x6.net13 0
C7539 dc_inst.x1.net14 dc_inst.x1.net12 0.1711f
C7540 dc_inst.x5.net5 dc_inst.x5.net1 0
C7541 dc_inst.x1.x11/a_27_47# _07_ 0.00599f
C7542 dc_inst.x4.net3 dc_inst.x8/a_757_363# 0
C7543 path[3] _18_/a_535_374# 0
C7544 dc_inst.x4.net5 dc_inst.x4.x4/a_27_47# 0.03066f
C7545 _23_/a_1283_21# dc_inst.x8/a_757_363# 0
C7546 dc_inst.x3.net19 path_sel[0] 0
C7547 clknet_1_1__leaf_clk _24_/a_651_413# 0.00722f
C7548 _13_/a_112_47# dc_inst.x3.net18 0
C7549 _13_/a_470_47# dc_inst.x1.net3 0
C7550 dc_inst.x7.x20/a_27_47# dc_inst.net7 0.00219f
C7551 dc_inst.x2.x3/a_27_47# dc_inst.x1.net18 0
C7552 dc_inst.x1.net11 _15_/a_600_345# 0
C7553 dc_inst.x6.net7 dc_inst.x4.x12/a_27_47# 0
C7554 _17_/a_174_21# _17_/a_574_297# -0
C7555 dc_inst.x6.x11/a_27_47# path_sel[2] 0.00379f
C7556 dc_inst.x2.x17/a_27_47# dc_inst.x2.net18 0
C7557 clknet_0_clk _25_/a_1270_413# 0
C7558 dc_inst.x5.x12/a_27_47# path_sel[0] 0
C7559 dc_inst.x3.net14 dc_inst.x3.x5/a_27_47# 0.04376f
C7560 dc_inst.x4.x2/a_27_47# dc_inst.x6.net15 0
C7561 dc_inst.x9/a_193_413# dc_inst.x7.x15/a_27_47# 0
C7562 dc_inst.x3.net14 path[5] 0.40006f
C7563 dc_inst.net7 dc_inst.x7.x2/a_27_47# 0.03242f
C7564 dc_inst.x3.net5 dc_inst.x3.x17/a_27_47# 0
C7565 _15_/a_288_47# dc_inst.in 0
C7566 dc_inst.x1.x2/a_27_47# dc_inst.x1.net14 0.00292f
C7567 dc_inst.x6.x20/a_27_47# dc_inst.x5.net19 0
C7568 clkbuf_1_1__f_clk/a_110_47# _24_/a_1108_47# 0.00771f
C7569 dc_inst.in delay_sel[1] 0.14345f
C7570 dc_inst.x5.x1/a_27_47# dc_inst.x4.net11 0
C7571 dc_inst.net1 dc_inst.x2.x18/a_27_47# 0
C7572 path_sel[2] dc_inst.x1.net2 0.32507f
C7573 dc_inst.x3.net13 dc_inst.x3.net7 0.00251f
C7574 dc_inst.x3.net2 dc_inst.x3.x17/a_27_47# 0.1359f
C7575 _24_/a_448_47# _25_/a_1108_47# 0
C7576 dc_inst.x10/a_505_21# dc_inst.net8 0.01076f
C7577 dc_inst.x10/a_218_374# delay_sel[2] 0
C7578 dc_inst.x4.net14 dc_inst.x2.net7 0
C7579 dc_inst.x2.net8 dc_inst.x2.net12 0
C7580 delay_sel[2] shadow_q 0.01429f
C7581 dc_inst.x4.net5 dc_inst.x2.x16/a_27_47# 0.00377f
C7582 dc_inst.x1.net10 dc_inst.x1.net1 0.0144f
C7583 dc_inst.x4.net1 path_sel[2] 0
C7584 path[5] dc_inst.x3.x8/a_27_47# 0.00604f
C7585 dc_inst.x4.x6/a_27_47# dc_inst.net4 0.00124f
C7586 dc_inst.x4.net19 dc_inst.x6.x9/a_27_47# 0
C7587 dc_inst.x5.net5 dc_inst.x4.net5 0
C7588 dc_inst.x4.x19/a_27_47# dc_inst.x4.net17 0.00104f
C7589 dc_inst.x5.x15/a_27_47# dc_inst.x6.net7 0.03595f
C7590 dc_inst.x5.net2 dc_inst.x5.net17 0.00352f
C7591 dc_inst.x8/a_1290_413# capture_q 0
C7592 dc_inst.x2.net5 dc_inst.x1.net16 0.00213f
C7593 _15_/a_193_369# dc_inst.net2 0
C7594 dc_inst.x1.net15 dc_inst.x4.net5 0.0176f
C7595 _13_/a_112_47# dc_inst.x3.net7 0.00547f
C7596 dc_inst.net8 rst 0.0851f
C7597 _15_/a_27_47# dc_inst.x3.x14/a_27_47# 0
C7598 delay_sel[2] clk 0.05579f
C7599 clknet_0_clk _25_/a_761_289# 0.00604f
C7600 path_sel[1] path[4] 0
C7601 dc_inst.x5.net9 dc_inst.x5.net1 0.13966f
C7602 dc_inst.x7.x13/a_27_47# dc_inst.net5 0.00864f
C7603 capture_q _02_ 0.18622f
C7604 dc_inst.net3 dc_inst.x7.net3 0
C7605 dc_inst.net4 dc_inst.x7.net14 0.01011f
C7606 delay_sel[0] dc_inst.x9/a_1478_413# 0.05607f
C7607 dc_inst.net7 dc_inst.x9/a_1290_413# -0
C7608 dc_inst.x5.net15 dc_inst.x4.net11 0
C7609 dc_inst.x5.x4/a_27_47# dc_inst.x2.net15 0
C7610 dc_inst.x3.x12/a_27_47# dc_inst.x3.net14 0
C7611 dc_inst.x4.net5 dc_inst.x2.net3 0
C7612 dc_inst.x1.x15/a_27_47# dc_inst.x1.net5 0
C7613 dc_inst.x6.net17 delay_sel[1] 0
C7614 _09_ dc_inst.x1.x11/a_27_47# 0.00267f
C7615 dc_inst.x7.x13/a_27_47# path_sel[2] 0
C7616 clkbuf_0_clk/a_110_47# _25_/a_761_289# 0.00994f
C7617 dc_inst.x1.net6 dc_inst.x1.net3 0.00893f
C7618 dc_inst.x6.x3/a_27_47# dc_inst.net5 0
C7619 dc_inst.net8 clknet_1_1__leaf_clk 0
C7620 dc_inst.x2.net1 dc_inst.x5.x10/a_27_47# 0.01149f
C7621 dc_inst.x4.net19 dc_inst.x2.net2 0
C7622 dc_inst.x6.net11 dc_inst.x6.x11/a_27_47# 0.00263f
C7623 _15_/a_27_47# path[7] 0.02524f
C7624 _15_/a_288_47# path[6] 0.01701f
C7625 dc_inst.x5.net14 dc_inst.x6.net7 0.01307f
C7626 se dc_inst.x3.net6 0
C7627 delay_sel[1] path[6] 0
C7628 dc_inst.x4.net15 dc_inst.x4.x14/a_27_47# 0.00148f
C7629 dc_inst.x5.net12 dc_inst.x5.net11 0.07593f
C7630 dc_inst.x2.x1/a_27_47# dc_inst.x4.net5 0.03312f
C7631 _24_/a_1283_21# delay_sel[1] 0
C7632 dc_inst.x7.x12/a_27_47# dc_inst.x7.net11 0.02051f
C7633 dc_inst.x4.x1/a_27_47# dc_inst.x6.x18/a_27_47# 0
C7634 dc_inst.x5.net8 dc_inst.x4.x14/a_27_47# 0.00156f
C7635 dc_inst.x4.net19 dc_inst.x6.net10 0.00304f
C7636 dc_inst.x4.net2 dc_inst.x1.net9 0
C7637 dc_inst.x2.net14 dc_inst.x2.net17 0.00789f
C7638 dc_inst.net6 dc_inst.x6.x11/a_27_47# 0
C7639 dc_inst.x6.x3/a_27_47# path_sel[2] 0.01495f
C7640 dc_inst.x6.x9/a_27_47# dc_inst.x6.x11/a_27_47# 0
C7641 VPWR dc_inst.x7.net19 0.17776f
C7642 dc_inst.x9/a_277_47# _25_/a_1108_47# 0
C7643 dc_inst.x5.net6 dc_inst.x2.net8 0.01844f
C7644 dc_inst.x4.net5 dc_inst.x5.net9 0
C7645 _20_/a_79_21# path_sel[2] 0.01731f
C7646 dc_inst.x9/a_247_21# dc_inst.x7.net12 0.00341f
C7647 dc_inst.x7.net3 _23_/a_761_289# 0
C7648 delay_sel[2] _25_/a_1108_47# 0
C7649 dc_inst.x3.net7 _23_/a_1283_21# 0
C7650 dc_inst.x2.x15/a_27_47# dc_inst.x1.x17/a_27_47# 0
C7651 _23_/a_27_47# dc_inst.x8/a_757_363# 0
C7652 _08_ _19_/a_465_47# 0
C7653 dc_inst.x6.x15/a_27_47# dc_inst.x6.net15 0.04368f
C7654 dc_inst.x7.net2 dc_inst.x9/a_1478_413# 0.00986f
C7655 dc_inst.x5.net3 dc_inst.x4.x15/a_27_47# 0.03552f
C7656 dc_inst.x7.x10/a_27_47# dc_inst.x5.x20/a_27_47# 0.01771f
C7657 delay_sel[2] dc_inst.x3.x1/a_27_47# 0
C7658 dc_inst.x2.x10/a_27_47# dc_inst.x5.net1 0.00253f
C7659 delay_sel[0] dc_inst.x7.x19/a_27_47# 0
C7660 path[3] _07_ 0.00269f
C7661 _25_/a_27_47# rst 0
C7662 dc_inst.x7.x12/a_27_47# clkbuf_1_0__f_clk/a_110_47# 0.01013f
C7663 dc_inst.x1.x14/a_27_47# dc_inst.x1.x1/a_27_47# 0
C7664 dc_inst.x7.net17 _25_/a_1108_47# 0
C7665 dc_inst.x7.net15 clknet_1_0__leaf_clk 0.00157f
C7666 dc_inst.x2.net14 dc_inst.x5.net11 0
C7667 dc_inst.x4.x3/a_27_47# dc_inst.x2.x18/a_27_47# 0
C7668 dc_inst.x1.net9 dc_inst.x5.net10 0
C7669 dc_inst.x4.net12 path_sel[0] 0
C7670 dc_inst.x2.x7/a_27_47# path_sel[0] 0
C7671 _07_ _19_/a_27_47# 0.00871f
C7672 dc_inst.net5 dc_inst.x7.x5/a_27_47# 0.03349f
C7673 dc_inst.x2.net16 dc_inst.x8/a_277_47# 0
C7674 dc_inst.x5.net6 dc_inst.x5.net18 0
C7675 _25_/a_27_47# clknet_1_1__leaf_clk 0
C7676 dc_inst.x6.x17/a_27_47# dc_inst.x6.net16 0.04886f
C7677 dc_inst.x1.net7 dc_inst.x2.net17 0
C7678 _14_/a_218_374# path[6] 0.00106f
C7679 dc_inst.x4.net1 dc_inst.net1 0
C7680 dc_inst.x7.x8/a_27_47# dc_inst.x7.net8 0.12789f
C7681 dc_inst.x6.net10 dc_inst.x6.x11/a_27_47# 0.1338f
C7682 dc_inst.x1.x10/a_27_47# dc_inst.x5.net12 0
C7683 dc_inst.x7.net4 dc_inst.x10/a_76_199# 0
C7684 dc_inst.x3.net1 _15_/a_788_316# 0
C7685 path[2] dc_inst.x2.net12 0
C7686 dc_inst.x7.x1/a_27_47# dc_inst.x7.net6 0.00257f
C7687 path_sel[2] dc_inst.x7.x5/a_27_47# 0.00254f
C7688 dc_inst.x3.net16 capture_q 0.00128f
C7689 dc_inst.x3.net3 dc_inst.x8/a_277_47# 0
C7690 _15_/a_27_47# dc_inst.x1.x1/a_27_47# 0
C7691 dc_inst.x1.net8 dc_inst.x3.net3 0
C7692 dc_inst.x7.net2 dc_inst.x5.net6 0
C7693 dc_inst.x6.x3/a_27_47# dc_inst.x6.net11 0
C7694 dc_inst.net7 dc_inst.x9/a_923_363# 0
C7695 dc_inst.x3.net7 dc_inst.x3.net9 0
C7696 dc_inst.x7.x19/a_27_47# dc_inst.x7.net1 0.0078f
C7697 VPWR dc_inst.x2.net16 0.00201f
C7698 dc_inst.x5.x11/a_27_47# path_sel[2] 0
C7699 dc_inst.net7 dc_inst.net8 0
C7700 dc_inst.x3.net1 _14_/a_505_21# 0.00143f
C7701 dc_inst.x3.net13 dc_inst.x1.net3 0.00914f
C7702 dc_inst.x4.net6 dc_inst.x4.x5/a_27_47# 0.00873f
C7703 dc_inst.x2.net6 dc_inst.x5.net10 0
C7704 dc_inst.x5.net11 _17_/a_27_93# 0
C7705 dc_inst.net1 dc_inst.x10/a_76_199# 0
C7706 _15_/a_27_47# _10_ 0.00162f
C7707 VPWR dc_inst.x3.net3 0.08425f
C7708 dc_inst.x1.net4 dc_inst.x1.net5 0.00445f
C7709 dc_inst.x4.net19 dc_inst.x4.x8/a_27_47# 0
C7710 dc_inst.x4.x6/a_27_47# dc_inst.x4.x11/a_27_47# 0
C7711 dc_inst.x2.net8 path_sel[2] 0
C7712 dc_inst.x4.x17/a_27_47# dc_inst.x6.net13 0
C7713 dc_inst.x1.x10/a_27_47# dc_inst.x2.net14 0
C7714 delay_sel[0] dc_inst.net5 0.08056f
C7715 dc_inst.x4.net8 dc_inst.x4.net11 0
C7716 dc_inst.x1.x1/a_27_47# dc_inst.x1.x8/a_27_47# 0.01018f
C7717 path[2] dc_inst.x2.net13 0
C7718 path_sel[1] dc_inst.x1.net10 0.07728f
C7719 dc_inst.x3.x17/a_27_47# dc_inst.x3.x3/a_27_47# 0
C7720 path[3] _09_ 0.00176f
C7721 _13_/a_112_47# dc_inst.x1.net3 0
C7722 dc_inst.x4.x1/a_27_47# dc_inst.x2.x19/a_27_47# 0.08729f
C7723 dc_inst.x7.x1/a_27_47# tdo 0
C7724 delay_sel[2] _23_/a_1270_413# 0
C7725 dc_inst.x6.x5/a_27_47# dc_inst.x6.net13 0
C7726 dc_inst.x1.net19 dc_inst.x1.x17/a_27_47# 0
C7727 dc_inst.x4.net3 dc_inst.x1.net9 0
C7728 dc_inst.x7.net12 _25_/a_543_47# 0
C7729 dc_inst.x5.net12 dc_inst.x5.net1 0.09339f
C7730 se dc_inst.x3.x19/a_27_47# 0
C7731 delay_sel[0] path_sel[2] 0.0663f
C7732 dc_inst.x1.x4/a_27_47# _10_ 0
C7733 dc_inst.x1.net4 dc_inst.x3.net14 0.00154f
C7734 dc_inst.x2.net18 _01_ 0
C7735 dc_inst.x6.x6/a_27_47# dc_inst.x4.net11 0
C7736 _10_ dc_inst.x1.x8/a_27_47# 0
C7737 _05_ _14_/a_218_374# 0
C7738 dc_inst.x5.net3 dc_inst.x4.x13/a_27_47# 0
C7739 dc_inst.x1.x11/a_27_47# _18_/a_76_199# 0.01787f
C7740 _09_ _19_/a_27_47# 0.00871f
C7741 dc_inst.x6.net14 dc_inst.x6.x15/a_27_47# 0.01536f
C7742 dc_inst.x5.net10 dc_inst.x2.net12 0
C7743 dc_inst.x7.net12 _25_/a_639_47# 0
C7744 dc_inst.x6.net11 dc_inst.x7.x5/a_27_47# 0
C7745 dc_inst.x5.net18 path_sel[2] 0.00575f
C7746 dc_inst.x7.x19/a_27_47# dc_inst.x7.net18 0.05151f
C7747 capture_q path[6] 0.01666f
C7748 VPWR dc_inst.x3.x16/a_27_47# 0.01153f
C7749 dc_inst.x7.net2 dc_inst.net5 0.14286f
C7750 dc_inst.net6 dc_inst.x7.x5/a_27_47# 0.01802f
C7751 dc_inst.x4.net12 tdo 0
C7752 _24_/a_1283_21# capture_q 0.03307f
C7753 dc_inst.x4.x16/a_27_47# dc_inst.x4.net11 0.01149f
C7754 dc_inst.x9/a_750_97# dc_inst.x6.net16 0
C7755 dc_inst.x1.x7/a_27_47# dc_inst.x1.net10 0.0051f
C7756 dc_inst.x3.net14 se 0
C7757 dc_inst.x1.x10/a_27_47# dc_inst.x1.net7 0
C7758 dc_inst.x6.net18 dc_inst.x6.x15/a_27_47# 0
C7759 dc_inst.x7.net4 dc_inst.x7.x5/a_27_47# 0.02511f
C7760 dc_inst.x3.net14 _14_/a_535_374# 0
C7761 dc_inst.net4 dc_inst.x6.net9 0
C7762 path[2] _18_/a_218_47# 0
C7763 dc_inst.net5 dc_inst.x7.net1 0.17975f
C7764 path[5] dc_inst.x3.net3 0
C7765 dc_inst.x3.net8 path[7] 0
C7766 _25_/a_193_47# _25_/a_761_289# -0.0105f
C7767 dc_inst.x7.net2 path_sel[2] 0.00557f
C7768 dc_inst.x3.x20/a_27_47# dc_inst.x3.net4 0
C7769 dc_inst.x2.net7 dc_inst.x5.x3/a_27_47# 0
C7770 dc_inst.x6.net2 dc_inst.x7.net8 0.0719f
C7771 dc_inst.x3.net17 capture_q 0
C7772 path_sel[1] dc_inst.x6.x2/a_27_47# 0
C7773 _20_/a_470_297# _06_ 0.00306f
C7774 clknet_1_0__leaf_clk _00_ 0.00379f
C7775 dc_inst.x3.net2 path[4] 0
C7776 dc_inst.x4.net1 dc_inst.x4.x8/a_27_47# 0.01151f
C7777 dc_inst.x5.x4/a_27_47# dc_inst.x2.x15/a_27_47# 0
C7778 se dc_inst.x3.x8/a_27_47# 0
C7779 _24_/a_543_47# delay_sel[2] 0.01209f
C7780 _24_/a_1108_47# capture_d 0
C7781 dc_inst.x7.net1 path_sel[2] 0.00134f
C7782 _15_/a_397_47# path_sel[0] -0.0014f
C7783 dc_inst.x2.net13 dc_inst.x5.net10 0
C7784 dc_inst.x5.net3 dc_inst.x5.x1/a_27_47# 0
C7785 rst clkload0/X 0.06153f
C7786 dc_inst.x2.net19 path[7] 0.00105f
C7787 dc_inst.x5.net3 dc_inst.x5.x14/a_27_47# 0.14165f
C7788 dc_inst.net4 dc_inst.x6.x14/a_27_47# 0.00214f
C7789 dc_inst.x8/a_193_47# capture_d 0
C7790 VPWR dc_inst.x2.x17/a_27_47# -0.00355f
C7791 dc_inst.net3 dc_inst.x1.net2 0
C7792 dc_inst.x7.x7/a_27_47# dc_inst.net5 0
C7793 dc_inst.x1.x13/a_27_47# dc_inst.x1.net12 0.01626f
C7794 clkbuf_1_1__f_clk/a_110_47# _24_/a_27_47# 0.01268f
C7795 dc_inst.x3.x17/a_27_47# shadow_q 0
C7796 dc_inst.x7.x10/a_27_47# dc_inst.x6.net4 0
C7797 delay_sel[0] dc_inst.x6.net11 0
C7798 dc_inst.x4.net1 dc_inst.x5.x8/a_27_47# 0
C7799 dc_inst.x2.net14 dc_inst.x4.net5 0.00506f
C7800 dc_inst.x6.net10 dc_inst.x7.x5/a_27_47# 0
C7801 dc_inst.net4 dc_inst.x6.net15 0
C7802 path_sel[2] dc_inst.x1.net6 0.00154f
C7803 dc_inst.net7 _25_/a_1217_47# 0
C7804 clknet_1_1__leaf_clk clkload0/X 0.01011f
C7805 dc_inst.net6 delay_sel[0] 0.02988f
C7806 dc_inst.x4.x9/a_27_47# dc_inst.x4.net11 0.00152f
C7807 dc_inst.x5.x7/a_27_47# dc_inst.x5.net7 0.03084f
C7808 dc_inst.x7.x7/a_27_47# path_sel[2] 0.00669f
C7809 dc_inst.x7.x10/a_27_47# dc_inst.x5.net19 0.00625f
C7810 dc_inst.x5.net6 dc_inst.x5.net10 0
C7811 dc_inst.x7.net19 clkbuf_1_0__f_clk/a_110_47# 0.00198f
C7812 dc_inst.x4.x6/a_27_47# dc_inst.x4.net7 0.00203f
C7813 dc_inst.x1.net8 dc_inst.x2.net10 0
C7814 dc_inst.x5.net1 _17_/a_27_93# 0
C7815 _20_/a_470_297# path[3] 0.00252f
C7816 dc_inst.x3.x16/a_27_47# path[5] 0
C7817 dc_inst.x1.net9 dc_inst.x2.net15 0.0409f
C7818 dc_inst.x7.net4 delay_sel[0] 0.01886f
C7819 dc_inst.x9/a_193_413# dc_inst.x7.net10 0
C7820 _05_ capture_q 0.00347f
C7821 dc_inst.x5.net3 dc_inst.x5.net4 0.02466f
C7822 dc_inst.x1.net7 dc_inst.x5.net1 0.00116f
C7823 dc_inst.x5.net18 dc_inst.x6.net11 0
C7824 _13_/a_112_47# dc_inst.x3.net4 0
C7825 dc_inst.x6.net9 dc_inst.x6.net8 0.02168f
C7826 delay_sel[0] dc_inst.x1.net17 0
C7827 dc_inst.x5.net5 dc_inst.x2.net4 0
C7828 dc_inst.x5.net2 dc_inst.x5.net16 0.02302f
C7829 dc_inst.x5.net3 dc_inst.x5.net15 0
C7830 dc_inst.net5 dc_inst.x7.net18 0
C7831 dc_inst.x4.x15/a_27_47# dc_inst.x4.net14 0.02899f
C7832 dc_inst.x4.x17/a_27_47# dc_inst.x4.net17 0.00338f
C7833 VPWR dc_inst.x2.net7 0.31187f
C7834 dc_inst.x1.net10 dc_inst.x2.x14/a_27_47# 0
C7835 dc_inst.x6.x4/a_27_47# dc_inst.x7.net10 0
C7836 dc_inst.x3.net12 dc_inst.x3.x13/a_27_47# 0.04669f
C7837 dc_inst.x5.net3 dc_inst.x4.x18/a_27_47# 0.02634f
C7838 dc_inst.x4.x6/a_27_47# dc_inst.x5.net6 0.03381f
C7839 _15_/a_27_47# dc_inst.x1.net11 0
C7840 VPWR dc_inst.x7.x14/a_27_47# 0.04276f
C7841 VPWR dc_inst.x2.net10 0.23669f
C7842 dc_inst.x5.net12 dc_inst.x4.net17 0.00443f
C7843 dc_inst.x4.net5 dc_inst.x2.x8/a_27_47# 0
C7844 dc_inst.x7.x12/a_27_47# delay_sel[2] 0
C7845 dc_inst.x8/a_193_413# dc_inst.x8/a_277_47# -0.00148f
C7846 VPWR dc_inst.x7.net8 0.01786f
C7847 dc_inst.net1 delay_sel[0] 0.07283f
C7848 dc_inst.x1.net1 _07_ 0.00382f
C7849 dc_inst.x7.net2 dc_inst.x6.net11 0
C7850 dc_inst.x7.x18/a_27_47# dc_inst.net5 0
C7851 dc_inst.x4.net2 dc_inst.net5 0
C7852 dc_inst.x2.x9/a_27_47# dc_inst.x2.x12/a_27_47# 0
C7853 dc_inst.net4 dc_inst.x7.x6/a_27_47# 0.00304f
C7854 dc_inst.x3.net19 dc_inst.x3.x2/a_27_47# 0.02435f
C7855 dc_inst.x7.net19 dc_inst.net9 0
C7856 dc_inst.x6.net9 dc_inst.x5.x19/a_27_47# 0
C7857 dc_inst.net6 dc_inst.x7.net2 0.21725f
C7858 dc_inst.x7.net2 _25_/a_1462_47# 0
C7859 path[3] _18_/a_76_199# 0.00709f
C7860 dc_inst.x7.net14 dc_inst.x7.x19/a_27_47# 0.17563f
C7861 dc_inst.x10/a_505_21# dc_inst.x7.x3/a_27_47# 0
C7862 _18_/a_439_47# path_sel[0] 0
C7863 dc_inst.x1.x1/a_27_47# dc_inst.x2.net19 0
C7864 dc_inst.x7.net4 dc_inst.x7.net2 0.02592f
C7865 dc_inst.x2.net4 dc_inst.x2.net3 0.03433f
C7866 dc_inst.x8/a_1478_413# dc_inst.x1.x1/a_27_47# 0
C7867 dc_inst.net4 dc_inst.x5.net7 0.0247f
C7868 dc_inst.x4.net2 path_sel[2] 0.00485f
C7869 dc_inst.net6 dc_inst.x7.net1 0
C7870 dc_inst.x7.x8/a_27_47# dc_inst.x7.net12 0
C7871 dc_inst.x2.x20/a_27_47# path_sel[0] 0
C7872 dc_inst.x2.net18 dc_inst.in 0.28459f
C7873 path_sel[1] dc_inst.x4.net13 0.01816f
C7874 dc_inst.x5.net3 dc_inst.x4.x7/a_27_47# 0
C7875 dc_inst.x4.net5 dc_inst.x1.net7 0
C7876 dc_inst.x1.x14/a_27_47# dc_inst.x1.net14 0.00742f
C7877 dc_inst.x7.net5 dc_inst.x7.x5/a_27_47# 0.03846f
C7878 VPWR dc_inst.x8/a_193_413# 0.00538f
C7879 _03_ _01_ 0
C7880 dc_inst.x7.net4 dc_inst.x7.net1 0.02152f
C7881 dc_inst.x6.x15/a_27_47# rst 0
C7882 _19_/a_27_47# _18_/a_76_199# 0
C7883 dc_inst.x1.x16/a_27_47# dc_inst.x1.x17/a_27_47# 0.01018f
C7884 dc_inst.x1.x12/a_27_47# _19_/a_193_297# 0
C7885 dc_inst.x3.x17/a_27_47# dc_inst.x3.x1/a_27_47# 0
C7886 dc_inst.x6.x12/a_27_47# dc_inst.x6.x14/a_27_47# 0
C7887 dc_inst.x7.net6 dc_inst.x7.net15 0
C7888 dc_inst.x3.x20/a_27_47# path_sel[2] 0.00136f
C7889 dc_inst.x6.x5/a_27_47# dc_inst.x6.x4/a_27_47# 0.02448f
C7890 tdo dc_inst.x1.net18 0.00118f
C7891 rst dc_inst.x7.x3/a_27_47# 0.01786f
C7892 dc_inst.net1 dc_inst.x7.net2 0
C7893 dc_inst.x6.net10 dc_inst.x5.net18 0
C7894 dc_inst.x4.net3 dc_inst.x5.net6 0
C7895 dc_inst.x7.x17/a_27_47# delay_sel[1] 0
C7896 dc_inst.x8/a_27_47# dc_inst.x6.x18/a_27_47# 0
C7897 dc_inst.x3.net19 dc_inst.x3.net11 0
C7898 _16_/a_229_47# dc_inst.x5.net9 0
C7899 dc_inst.x5.net9 dc_inst.x2.x12/a_27_47# 0
C7900 _03_ _02_ 0
C7901 dc_inst.x4.net10 dc_inst.x4.x7/a_27_47# 0
C7902 _15_/a_27_47# dc_inst.x1.net14 0
C7903 _08_ dc_inst.x1.x12/a_27_47# 0
C7904 dc_inst.x4.x2/a_27_47# dc_inst.x1.x19/a_27_47# 0
C7905 dc_inst.x1.x19/a_27_47# dc_inst.x1.x17/a_27_47# 0
C7906 tdo _24_/a_639_47# 0
C7907 dc_inst.x6.net17 dc_inst.x2.net18 0
C7908 dc_inst.x4.net18 dc_inst.x6.net9 0
C7909 dc_inst.x6.net14 dc_inst.net4 0.00117f
C7910 _03_ _25_/a_448_47# 0
C7911 dc_inst.x5.net7 dc_inst.x6.net8 0
C7912 dc_inst.x1.net13 dc_inst.x1.net2 0
C7913 _03_ dc_inst.x7.net12 0
C7914 dc_inst.x1.x10/a_27_47# dc_inst.x5.net11 0.00329f
C7915 dc_inst.x4.x6/a_27_47# path_sel[2] 0.00518f
C7916 dc_inst.x1.net1 _09_ 0.00143f
C7917 delay_sel[0] dc_inst.x7.net5 0.00119f
C7918 dc_inst.x6.net4 dc_inst.x6.x2/a_27_47# 0
C7919 dc_inst.x3.net12 path[4] 0.01619f
C7920 dc_inst.x2.net18 path[6] 0
C7921 dc_inst.x8/a_834_97# dc_inst.in 0
C7922 dc_inst.x7.net15 tdo 0
C7923 dc_inst.x1.x4/a_27_47# dc_inst.x1.net14 0
C7924 dc_inst.x7.net14 dc_inst.net5 0
C7925 dc_inst.x7.net4 dc_inst.x7.net18 0
C7926 dc_inst.x1.net14 dc_inst.x1.x8/a_27_47# 0
C7927 dc_inst.x2.x6/a_27_47# dc_inst.x5.x3/a_27_47# 0.08729f
C7928 dc_inst.x4.x13/a_27_47# dc_inst.x4.net14 0
C7929 dc_inst.x5.net19 dc_inst.x6.x2/a_27_47# 0.00853f
C7930 dc_inst.net2 path[7] 0
C7931 dc_inst.x2.net16 dc_inst.x6.x13/a_27_47# 0
C7932 dc_inst.net6 dc_inst.x7.x18/a_27_47# 0
C7933 dc_inst.x9/a_1478_413# _23_/a_27_47# 0.00149f
C7934 dc_inst.x5.x19/a_27_47# dc_inst.x5.net7 0
C7935 dc_inst.x4.net2 dc_inst.net6 0
C7936 dc_inst.x1.net15 dc_inst.x1.x1/a_27_47# 0
C7937 dc_inst.net4 dc_inst.x6.net18 0
C7938 _24_/a_193_47# clknet_0_clk 0
C7939 tdo dc_inst.x6.x10/a_27_47# 0.00176f
C7940 dc_inst.net8 _23_/a_1108_47# 0
C7941 dc_inst.x5.net3 dc_inst.x4.net8 0
C7942 dc_inst.x2.net1 dc_inst.x1.net9 0
C7943 dc_inst.x8/a_668_97# dc_inst.net2 0
C7944 dc_inst.x2.net15 dc_inst.x2.net13 0
C7945 dc_inst.x3.net19 dc_inst.x1.net2 0.00349f
C7946 dc_inst.x7.net4 dc_inst.x4.net2 0.01882f
C7947 _01_ dc_inst.x8/a_277_47# 0
C7948 rst dc_inst.x8/a_757_363# 0
C7949 dc_inst.x4.net2 dc_inst.x1.net17 0
C7950 dc_inst.x1.net4 dc_inst.x3.net3 0.02338f
C7951 dc_inst.x8/a_750_97# dc_inst.x8/a_923_363# -0
C7952 dc_inst.x8/a_1290_413# dc_inst.x8/a_277_47# -0.00422f
C7953 dc_inst.x6.net2 dc_inst.x7.net12 0
C7954 dc_inst.x7.net2 dc_inst.x7.net5 0
C7955 dc_inst.x4.net9 dc_inst.x2.net7 0
C7956 dc_inst.x5.net3 dc_inst.x6.x6/a_27_47# 0
C7957 _23_/a_193_47# _24_/a_651_413# 0
C7958 VPWR _19_/a_193_297# 0
C7959 dc_inst.x4.net3 path_sel[2] 0.00821f
C7960 dc_inst.net3 delay_sel[0] 0.0075f
C7961 dc_inst.x4.net5 dc_inst.x6.x16/a_27_47# 0
C7962 dc_inst.x7.net5 dc_inst.x7.net1 0
C7963 dc_inst.x4.net2 dc_inst.net1 0.04364f
C7964 _07_ path[1] 0.00409f
C7965 dc_inst.x5.net11 dc_inst.x5.net1 0.00693f
C7966 _08_ _17_/a_478_47# 0.00129f
C7967 dc_inst.x4.net14 dc_inst.x5.x1/a_27_47# 0.01151f
C7968 dc_inst.x4.net4 dc_inst.x1.net5 0
C7969 dc_inst.x5.net6 dc_inst.x2.net15 0
C7970 _02_ dc_inst.x8/a_277_47# 0
C7971 dc_inst.x4.x15/a_27_47# dc_inst.x5.net13 0
C7972 dc_inst.x4.net5 dc_inst.x2.net17 0.01647f
C7973 VPWR _01_ 0.20183f
C7974 VPWR dc_inst.x10/a_439_47# 0.00107f
C7975 dc_inst.x4.x3/a_27_47# dc_inst.x7.net2 0
C7976 se dc_inst.x3.net3 0.00167f
C7977 VPWR dc_inst.x2.x6/a_27_47# -0.00287f
C7978 dc_inst.x4.x6/a_27_47# dc_inst.x6.net11 0
C7979 dc_inst.x1.net7 _19_/a_205_47# 0
C7980 VPWR dc_inst.x8/a_1290_413# -0.02539f
C7981 dc_inst.x5.net3 dc_inst.x4.x16/a_27_47# 0.04184f
C7982 dc_inst.x2.net1 dc_inst.x2.net6 0.00143f
C7983 dc_inst.x5.net2 dc_inst.x4.net11 0
C7984 path_sel[1] _07_ 0.08409f
C7985 _03_ dc_inst.in 0
C7986 dc_inst.x7.x14/a_27_47# dc_inst.x7.net11 0
C7987 dc_inst.x2.net9 dc_inst.x2.net8 0.03433f
C7988 dc_inst.x1.net9 dc_inst.x2.x15/a_27_47# 0.00362f
C7989 VPWR _08_ 0.08726f
C7990 tdi dc_inst.x3.net7 0
C7991 dc_inst.x6.net14 dc_inst.x6.x12/a_27_47# 0
C7992 dc_inst.x3.net15 dc_inst.x3.net8 0.00271f
C7993 dc_inst.x9/a_277_47# dc_inst.x7.net19 0
C7994 dc_inst.x7.x20/a_27_47# dc_inst.x7.net16 0
C7995 VPWR _02_ 0.34917f
C7996 _23_/a_543_47# _00_ 0
C7997 dc_inst.x3.net18 rst 0
C7998 dc_inst.net2 dc_inst.x1.x1/a_27_47# 0.00419f
C7999 dc_inst.x7.net19 delay_sel[2] 0.00312f
C8000 dc_inst.x4.net19 dc_inst.x4.net12 0
C8001 delay_sel[0] _23_/a_761_289# 0
C8002 _03_ _23_/a_639_47# 0
C8003 dc_inst.net3 dc_inst.x7.net2 0
C8004 dc_inst.x5.net7 dc_inst.x2.net6 0
C8005 dc_inst.x7.net16 dc_inst.x7.x2/a_27_47# 0
C8006 dc_inst.x9/a_1478_413# dc_inst.x6.net15 0
C8007 dc_inst.x4.net14 dc_inst.x4.x18/a_27_47# 0.05421f
C8008 dc_inst.x7.x14/a_27_47# clkbuf_1_0__f_clk/a_110_47# 0.0095f
C8009 dc_inst.x7.net6 clknet_1_0__leaf_clk 0
C8010 _24_/a_27_47# capture_d 0.03177f
C8011 dc_inst.x7.x1/a_27_47# dc_inst.x6.x11/a_27_47# 0.00102f
C8012 dc_inst.x5.x9/a_27_47# dc_inst.x5.net10 0.01506f
C8013 dc_inst.x7.net19 dc_inst.x7.net17 0.144f
C8014 VPWR dc_inst.x7.net12 0.14233f
C8015 dc_inst.x5.net12 _16_/a_229_47# 0
C8016 dc_inst.x7.net5 dc_inst.x7.net18 0
C8017 dc_inst.x7.net15 dc_inst.x7.net3 0
C8018 dc_inst.x1.x10/a_27_47# dc_inst.x5.net1 0.00212f
C8019 se dc_inst.x3.x16/a_27_47# 0
C8020 dc_inst.x5.net6 dc_inst.x6.net9 0
C8021 dc_inst.x5.net12 dc_inst.x2.x12/a_27_47# 0.0029f
C8022 dc_inst.x2.net1 dc_inst.x2.net12 0.00175f
C8023 dc_inst.x1.net10 dc_inst.x2.net5 0
C8024 dc_inst.x1.x16/a_27_47# dc_inst.x8/a_757_363# 0
C8025 dc_inst.x8/a_27_47# _24_/a_27_47# 0
C8026 dc_inst.x1.net15 dc_inst.x8/a_247_21# 0
C8027 delay_sel[0] dc_inst.x9/a_668_97# 0
C8028 dc_inst.net7 dc_inst.x9/a_193_47# 0
C8029 dc_inst.x5.net3 dc_inst.x4.x9/a_27_47# 0
C8030 dc_inst.x1.x7/a_27_47# _07_ 0
C8031 dc_inst.net8 _23_/a_193_47# 0.00436f
C8032 dc_inst.x7.x17/a_27_47# dc_inst.x9/a_247_21# 0.00993f
C8033 dc_inst.x6.net10 dc_inst.x4.x6/a_27_47# 0.00161f
C8034 dc_inst.x1.x11/a_27_47# dc_inst.x1.net3 0
C8035 dc_inst.net4 dc_inst.x6.net12 0.00335f
C8036 dc_inst.x8/a_1290_413# path[5] 0
C8037 dc_inst.x3.net9 VGND 0.28655f
C8038 dc_inst.x3.x8/a_27_47# VGND 0.21068f
C8039 dc_inst.x6.net8 VGND 0.20107f
C8040 dc_inst.x6.x7/a_27_47# VGND 0.20759f
C8041 dc_inst.x4.x20/a_27_47# VGND 0.28418f
C8042 dc_inst.x1.net12 VGND 0.30477f
C8043 dc_inst.x1.x12/a_27_47# VGND 0.20097f
C8044 dc_inst.x3.net8 VGND 0.27669f
C8045 dc_inst.x3.x7/a_27_47# VGND 0.20231f
C8046 dc_inst.x6.net7 VGND 0.3538f
C8047 dc_inst.x6.net6 VGND 0.41296f
C8048 dc_inst.x6.x6/a_27_47# VGND 0.20729f
C8049 dc_inst.x5.net19 VGND 0.5141f
C8050 dc_inst.x5.x19/a_27_47# VGND 0.20754f
C8051 dc_inst.x1.net11 VGND 0.23459f
C8052 dc_inst.x1.x11/a_27_47# VGND 0.20914f
C8053 dc_inst.x3.net7 VGND 0.15787f
C8054 dc_inst.x3.net6 VGND 0.16988f
C8055 dc_inst.x3.x6/a_27_47# VGND 0.2053f
C8056 dc_inst.x6.x5/a_27_47# VGND 0.19831f
C8057 dc_inst.x1.net1 VGND 0.19312f
C8058 dc_inst.x1.net10 VGND 0.21657f
C8059 dc_inst.x1.x10/a_27_47# VGND 0.20953f
C8060 dc_inst.x5.net18 VGND 0.16928f
C8061 dc_inst.x5.x18/a_27_47# VGND 0.24624f
C8062 dc_inst.x3.x5/a_27_47# VGND 0.2383f
C8063 dc_inst.x6.net5 VGND 0.19032f
C8064 dc_inst.x6.x4/a_27_47# VGND 0.20717f
C8065 dc_inst.x5.net17 VGND 0.32528f
C8066 dc_inst.x5.x17/a_27_47# VGND 0.21182f
C8067 dc_inst.x1.x20/a_27_47# VGND 0.27865f
C8068 dc_inst.x3.net5 VGND 0.15259f
C8069 dc_inst.x3.x4/a_27_47# VGND 0.20465f
C8070 dc_inst.x6.net4 VGND 0.19533f
C8071 dc_inst.x6.x3/a_27_47# VGND 0.20713f
C8072 _04_ VGND 0.23736f
C8073 dc_inst.x2.net19 VGND 0.249f
C8074 dc_inst.x2.x19/a_27_47# VGND 0.2413f
C8075 dc_inst.x5.net16 VGND 0.3721f
C8076 dc_inst.x5.net15 VGND 0.24353f
C8077 dc_inst.x5.x16/a_27_47# VGND 0.2165f
C8078 dc_inst.x3.net4 VGND 0.21272f
C8079 dc_inst.x3.x3/a_27_47# VGND 0.20796f
C8080 dc_inst.x6.net3 VGND 0.24657f
C8081 dc_inst.x6.net2 VGND 0.33046f
C8082 dc_inst.x6.x2/a_27_47# VGND 0.22674f
C8083 dc_inst.x5.x15/a_27_47# VGND 0.20695f
C8084 dc_inst.x2.net18 VGND 0.42072f
C8085 dc_inst.x2.x18/a_27_47# VGND 0.21232f
C8086 _01_ VGND 0.38434f
C8087 rst VGND 1.43716f
C8088 dc_inst.x3.net3 VGND 0.65415f
C8089 dc_inst.x3.x2/a_27_47# VGND 0.20355f
C8090 dc_inst.x2.net17 VGND 0.20598f
C8091 dc_inst.x2.x17/a_27_47# VGND 0.20869f
C8092 dc_inst.x6.x1/a_27_47# VGND 0.1938f
C8093 _05_ VGND 0.18963f
C8094 _13_/a_470_47# VGND 0
C8095 _13_/a_470_297# VGND 0.02004f
C8096 _13_/a_27_297# VGND 0.00302f
C8097 _13_/a_112_47# VGND 0.27287f
C8098 dc_inst.x5.net14 VGND 0.20509f
C8099 dc_inst.x5.net13 VGND 0.23734f
C8100 dc_inst.x5.x14/a_27_47# VGND 0.20388f
C8101 dc_inst.net8 VGND 1.09074f
C8102 delay_sel[2] VGND 1.55915f
C8103 capture_d VGND 0.33487f
C8104 dc_inst.x10/a_439_47# VGND -0
C8105 dc_inst.x10/a_535_374# VGND -0
C8106 dc_inst.x10/a_218_374# VGND -0
C8107 dc_inst.x10/a_505_21# VGND 0.26112f
C8108 dc_inst.x10/a_76_199# VGND 0.13023f
C8109 dc_inst.x3.net2 VGND 0.48008f
C8110 dc_inst.x3.x1/a_27_47# VGND 0.21088f
C8111 dc_inst.x2.net16 VGND 0.19833f
C8112 dc_inst.x2.x16/a_27_47# VGND 0.23058f
C8113 tdi VGND 1.55929f
C8114 se VGND 1.27036f
C8115 _14_/a_439_47# VGND -0
C8116 _14_/a_218_47# VGND 0
C8117 _14_/a_535_374# VGND -0
C8118 _14_/a_218_374# VGND -0
C8119 _14_/a_505_21# VGND 0.25582f
C8120 _14_/a_76_199# VGND 0.1385f
C8121 dc_inst.x5.net12 VGND 3.43444f
C8122 dc_inst.x5.x13/a_27_47# VGND 0.20644f
C8123 dc_inst.x5.x12/a_27_47# VGND 0.20857f
C8124 dc_inst.x2.net15 VGND 0.45603f
C8125 dc_inst.x2.x15/a_27_47# VGND 0.2123f
C8126 path[4] VGND 0.56334f
C8127 path[5] VGND 0.61905f
C8128 path[7] VGND 1.78095f
C8129 path[6] VGND 0.56785f
C8130 _15_/a_1281_47# VGND -0
C8131 _15_/a_1064_47# VGND -0
C8132 _15_/a_397_47# VGND -0
C8133 _15_/a_1279_413# VGND -0
C8134 _15_/a_872_316# VGND 0.0189f
C8135 _15_/a_193_47# VGND -0
C8136 _15_/a_600_345# VGND 0.16458f
C8137 _15_/a_788_316# VGND 0.20349f
C8138 _15_/a_372_413# VGND 0
C8139 _15_/a_288_47# VGND 0.02175f
C8140 _15_/a_193_369# VGND 0
C8141 _15_/a_27_47# VGND 0.28432f
C8142 clkbuf_1_1__f_clk/a_110_47# VGND 1.74948f
C8143 dc_inst.x2.net14 VGND 0.19832f
C8144 dc_inst.x2.x14/a_27_47# VGND 0.20891f
C8145 _07_ VGND 0.23124f
C8146 path[1] VGND 0.7864f
C8147 path_sel[0] VGND 3.63778f
C8148 _16_/a_229_47# VGND 0.05391f
C8149 _16_/a_27_93# VGND 0.30513f
C8150 dc_inst.x5.net11 VGND 0.29954f
C8151 dc_inst.x5.x11/a_27_47# VGND 0.26214f
C8152 dc_inst.x2.net13 VGND 0.23819f
C8153 dc_inst.x2.x13/a_27_47# VGND 0.20894f
C8154 _08_ VGND 0.2073f
C8155 path_sel[1] VGND 1.8608f
C8156 path[0] VGND 1.46967f
C8157 _17_/a_478_47# VGND 0.08016f
C8158 _17_/a_27_93# VGND 0.21107f
C8159 _17_/a_174_21# VGND 0.20825f
C8160 dc_inst.x5.x9/a_27_47# VGND 0.25008f
C8161 dc_inst.x5.net1 VGND 0.26285f
C8162 dc_inst.x5.net10 VGND 0.24013f
C8163 dc_inst.x5.x10/a_27_47# VGND 0.20773f
C8164 dc_inst.x2.net10 VGND 0.22468f
C8165 dc_inst.x2.x9/a_27_47# VGND 0.24025f
C8166 path[3] VGND 0.65298f
C8167 path[2] VGND 0.72545f
C8168 _09_ VGND 0.15879f
C8169 _18_/a_535_374# VGND -0
C8170 _18_/a_505_21# VGND 0.27564f
C8171 _18_/a_76_199# VGND 0.13872f
C8172 dc_inst.x2.net12 VGND 0.35773f
C8173 dc_inst.x2.x12/a_27_47# VGND 0.20911f
C8174 dc_inst.x5.net9 VGND 0.25467f
C8175 dc_inst.x5.net8 VGND 0.23576f
C8176 dc_inst.x5.x8/a_27_47# VGND 0.23978f
C8177 dc_inst.net5 VGND 0.46469f
C8178 dc_inst.x5.x20/a_27_47# VGND 0.28019f
C8179 dc_inst.x2.net9 VGND 0.19744f
C8180 dc_inst.x2.x8/a_27_47# VGND 0.21063f
C8181 dc_inst.x2.net11 VGND 0.21677f
C8182 dc_inst.x2.x11/a_27_47# VGND 0.20893f
C8183 dc_inst.x5.net7 VGND 0.4371f
C8184 dc_inst.x5.x7/a_27_47# VGND 0.20423f
C8185 _10_ VGND 0.3446f
C8186 path_sel[2] VGND 1.18289f
C8187 _19_/a_465_47# VGND -0
C8188 _19_/a_205_47# VGND 0
C8189 _19_/a_193_297# VGND -0
C8190 _19_/a_109_297# VGND -0.00123f
C8191 _19_/a_27_47# VGND 0.29576f
C8192 dc_inst.x6.x19/a_27_47# VGND 0.22386f
C8193 dc_inst.x2.net8 VGND 0.18618f
C8194 dc_inst.x2.x7/a_27_47# VGND 0.20644f
C8195 dc_inst.x5.x6/a_27_47# VGND 0.20376f
C8196 dc_inst.x2.net1 VGND 0.18796f
C8197 dc_inst.x2.x10/a_27_47# VGND 0.20777f
C8198 dc_inst.x6.net18 VGND 0.27521f
C8199 dc_inst.x6.x18/a_27_47# VGND 0.25032f
C8200 dc_inst.x2.net7 VGND 0.18137f
C8201 dc_inst.x2.net6 VGND 0.40452f
C8202 dc_inst.x2.x6/a_27_47# VGND 0.20157f
C8203 dc_inst.x5.net6 VGND 0.76626f
C8204 dc_inst.x5.net5 VGND 0.17356f
C8205 dc_inst.x5.x5/a_27_47# VGND 0.19483f
C8206 dc_inst.x2.x20/a_27_47# VGND 0.28865f
C8207 dc_inst.x6.net17 VGND 0.35001f
C8208 dc_inst.x6.x17/a_27_47# VGND 0.19549f
C8209 dc_inst.x2.x5/a_27_47# VGND 0.24403f
C8210 dc_inst.x5.x4/a_27_47# VGND 0.20862f
C8211 dc_inst.x6.net16 VGND 0.17943f
C8212 dc_inst.x6.x16/a_27_47# VGND 0.20634f
C8213 dc_inst.x3.x19/a_27_47# VGND 0.20416f
C8214 clknet_1_0__leaf_clk VGND 0.71268f
C8215 clknet_0_clk VGND 1.29001f
C8216 clkbuf_1_0__f_clk/a_110_47# VGND 1.7332f
C8217 dc_inst.x2.net5 VGND 0.24881f
C8218 dc_inst.x2.x4/a_27_47# VGND 0.21192f
C8219 dc_inst.x5.net4 VGND 0.25489f
C8220 dc_inst.x5.x3/a_27_47# VGND 0.23795f
C8221 dc_inst.x3.net18 VGND 0.21285f
C8222 dc_inst.x3.x18/a_27_47# VGND 0.20575f
C8223 dc_inst.x6.net15 VGND 0.18641f
C8224 dc_inst.x6.x15/a_27_47# VGND 0.24885f
C8225 dc_inst.x2.net4 VGND 0.18144f
C8226 dc_inst.x2.x3/a_27_47# VGND 0.20719f
C8227 dc_inst.x5.net3 VGND 0.33344f
C8228 dc_inst.x5.net2 VGND 0.36417f
C8229 dc_inst.x5.x2/a_27_47# VGND 0.2464f
C8230 dc_inst.x6.net14 VGND 0.24376f
C8231 dc_inst.x6.x14/a_27_47# VGND 0.20368f
C8232 dc_inst.x3.net17 VGND 0.26428f
C8233 dc_inst.x3.net16 VGND 0.19571f
C8234 dc_inst.x3.x17/a_27_47# VGND 0.2007f
C8235 dc_inst.x2.net3 VGND 0.17825f
C8236 dc_inst.x2.net2 VGND 0.16052f
C8237 dc_inst.x2.x2/a_27_47# VGND 0.20726f
C8238 dc_inst.net4 VGND 0.53806f
C8239 dc_inst.x5.x1/a_27_47# VGND 0.20528f
C8240 dc_inst.x3.x16/a_27_47# VGND 0.19612f
C8241 dc_inst.x6.net13 VGND 0.2285f
C8242 dc_inst.x6.x13/a_27_47# VGND 0.24109f
C8243 dc_inst.net1 VGND 0.47471f
C8244 dc_inst.x2.x1/a_27_47# VGND 0.20589f
C8245 dc_inst.x6.net12 VGND 0.18734f
C8246 dc_inst.x6.x12/a_27_47# VGND 0.2071f
C8247 dc_inst.x3.net15 VGND 0.17204f
C8248 dc_inst.x3.x15/a_27_47# VGND 0.24565f
C8249 dc_inst.x3.net14 VGND 0.51411f
C8250 dc_inst.x3.net13 VGND 0.22509f
C8251 dc_inst.x3.x14/a_27_47# VGND 0.20725f
C8252 dc_inst.x6.net11 VGND 0.35355f
C8253 dc_inst.x6.x11/a_27_47# VGND 0.20376f
C8254 dc_inst.x6.net1 VGND 0.15449f
C8255 dc_inst.x6.x10/a_27_47# VGND 0.20693f
C8256 dc_inst.x3.x13/a_27_47# VGND 0.2052f
C8257 dc_inst.x7.net10 VGND 0.2101f
C8258 dc_inst.x7.x9/a_27_47# VGND 0.22622f
C8259 dc_inst.x4.net10 VGND 0.23035f
C8260 dc_inst.x4.net9 VGND 0.38117f
C8261 dc_inst.x4.x9/a_27_47# VGND 0.20508f
C8262 dc_inst.x6.net19 VGND 0.20476f
C8263 dc_inst.x6.x20/a_27_47# VGND 0.27876f
C8264 dc_inst.x3.net12 VGND 0.61271f
C8265 dc_inst.x3.net11 VGND 0.4637f
C8266 dc_inst.x3.x12/a_27_47# VGND 0.21271f
C8267 dc_inst.x7.net9 VGND 0.46603f
C8268 dc_inst.x7.x8/a_27_47# VGND 0.21153f
C8269 _06_ VGND 0.32619f
C8270 _20_/a_384_47# VGND 0.02697f
C8271 _20_/a_470_297# VGND -0.00158f
C8272 _20_/a_79_21# VGND 0.24052f
C8273 dc_inst.x1.net9 VGND 0.29714f
C8274 dc_inst.x1.x9/a_27_47# VGND 0.21021f
C8275 dc_inst.net9 VGND 0.52407f
C8276 delay_sel[1] VGND 2.11942f
C8277 dc_inst.net7 VGND 0.47585f
C8278 delay_sel[0] VGND 1.36458f
C8279 dc_inst.x9/a_834_97# VGND 0.01584f
C8280 dc_inst.x9/a_668_97# VGND 0.0155f
C8281 dc_inst.x9/a_193_47# VGND -0
C8282 dc_inst.x9/a_27_47# VGND 0.03599f
C8283 dc_inst.x9/a_1478_413# VGND 0.15287f
C8284 dc_inst.x9/a_1290_413# VGND 0.19621f
C8285 dc_inst.x9/a_750_97# VGND 0.03215f
C8286 dc_inst.x9/a_757_363# VGND 0.00666f
C8287 dc_inst.x9/a_277_47# VGND -0.31746f
C8288 dc_inst.x9/a_247_21# VGND 0.33369f
C8289 dc_inst.x9/a_193_413# VGND 0.00305f
C8290 dc_inst.x9/a_27_413# VGND 0.02678f
C8291 dc_inst.x3.x11/a_27_47# VGND 0.19996f
C8292 dc_inst.x4.x8/a_27_47# VGND 0.20471f
C8293 dc_inst.x7.net19 VGND 0.25633f
C8294 dc_inst.x7.x19/a_27_47# VGND 0.19351f
C8295 dc_inst.x7.net8 VGND 0.17228f
C8296 dc_inst.x7.x7/a_27_47# VGND 0.20696f
C8297 dc_inst.x1.x8/a_27_47# VGND 0.19661f
C8298 dc_inst.net2 VGND 0.55887f
C8299 dc_inst.x8/a_834_97# VGND 0.02337f
C8300 dc_inst.x8/a_668_97# VGND 0.01733f
C8301 dc_inst.x8/a_193_47# VGND -0
C8302 dc_inst.x8/a_27_47# VGND 0.02685f
C8303 dc_inst.x8/a_1478_413# VGND 0.15507f
C8304 dc_inst.x8/a_1290_413# VGND 0.20594f
C8305 dc_inst.x8/a_750_97# VGND 0.04831f
C8306 dc_inst.x8/a_757_363# VGND 0.01436f
C8307 dc_inst.x8/a_923_363# VGND 0
C8308 dc_inst.x8/a_277_47# VGND -0.28619f
C8309 dc_inst.x8/a_247_21# VGND 0.35678f
C8310 dc_inst.x8/a_193_413# VGND 0.00446f
C8311 dc_inst.x8/a_27_413# VGND 0.02756f
C8312 dc_inst.x4.net8 VGND 0.27819f
C8313 dc_inst.x4.net7 VGND 0.14916f
C8314 dc_inst.x4.x7/a_27_47# VGND 0.20775f
C8315 dc_inst.x7.net18 VGND 0.13405f
C8316 dc_inst.x7.x18/a_27_47# VGND 0.20425f
C8317 dc_inst.x3.net1 VGND 0.24381f
C8318 dc_inst.x3.net10 VGND 0.20705f
C8319 dc_inst.x3.x10/a_27_47# VGND 0.22632f
C8320 dc_inst.x7.net7 VGND 0.15558f
C8321 dc_inst.x7.net6 VGND 0.51031f
C8322 dc_inst.x7.x6/a_27_47# VGND 0.20679f
C8323 _03_ VGND 0.44054f
C8324 dc_inst.x1.net8 VGND 0.31888f
C8325 dc_inst.x1.net7 VGND 0.85799f
C8326 dc_inst.x1.x7/a_27_47# VGND 0.24321f
C8327 dc_inst.x3.net19 VGND 0.29348f
C8328 dc_inst.x3.x20/a_27_47# VGND 0.28601f
C8329 dc_inst.x4.x6/a_27_47# VGND 0.20092f
C8330 dc_inst.x7.net17 VGND 0.254f
C8331 dc_inst.x7.x17/a_27_47# VGND 0.20382f
C8332 dc_inst.x7.x5/a_27_47# VGND 0.23948f
C8333 shadow_q VGND 0.72134f
C8334 _23_/a_1462_47# VGND 0.00226f
C8335 _23_/a_1217_47# VGND 0
C8336 _23_/a_1270_413# VGND 0
C8337 _23_/a_651_413# VGND 0.00469f
C8338 _23_/a_448_47# VGND 0.0139f
C8339 _23_/a_1108_47# VGND 0.16902f
C8340 _23_/a_1283_21# VGND 0.4233f
C8341 _23_/a_543_47# VGND 0.15918f
C8342 _23_/a_761_289# VGND 0.12382f
C8343 _23_/a_193_47# VGND 0.27994f
C8344 _23_/a_27_47# VGND 0.53687f
C8345 dc_inst.x1.x6/a_27_47# VGND 0.22481f
C8346 dc_inst.x4.net6 VGND 0.117f
C8347 dc_inst.x4.net5 VGND 0.37891f
C8348 dc_inst.x4.x5/a_27_47# VGND 0.2018f
C8349 dc_inst.x4.net19 VGND 0.27769f
C8350 dc_inst.x4.net18 VGND 0.34224f
C8351 dc_inst.x4.x19/a_27_47# VGND 0.20098f
C8352 dc_inst.x7.net16 VGND 0.20212f
C8353 dc_inst.x7.x16/a_27_47# VGND 0.20394f
C8354 dc_inst.x7.net5 VGND 0.12374f
C8355 dc_inst.x7.net4 VGND 0.54929f
C8356 dc_inst.x7.x4/a_27_47# VGND 0.19352f
C8357 capture_q VGND 0.34702f
C8358 _02_ VGND 1.22976f
C8359 clknet_1_1__leaf_clk VGND 0.93673f
C8360 _24_/a_1462_47# VGND 0
C8361 _24_/a_1217_47# VGND 0.00108f
C8362 _24_/a_805_47# VGND 0
C8363 _24_/a_639_47# VGND 0
C8364 _24_/a_1270_413# VGND 0
C8365 _24_/a_651_413# VGND 0.00548f
C8366 _24_/a_448_47# VGND 0.0139f
C8367 _24_/a_1108_47# VGND 0.17558f
C8368 _24_/a_1283_21# VGND 0.39249f
C8369 _24_/a_543_47# VGND 0.15967f
C8370 _24_/a_761_289# VGND 0.12916f
C8371 _24_/a_193_47# VGND 0.29749f
C8372 _24_/a_27_47# VGND 0.53625f
C8373 dc_inst.x4.net17 VGND 0.31505f
C8374 dc_inst.x4.x18/a_27_47# VGND 0.19683f
C8375 dc_inst.x1.net6 VGND 0.18527f
C8376 dc_inst.x1.net5 VGND 0.19323f
C8377 dc_inst.x1.x5/a_27_47# VGND 0.19302f
C8378 dc_inst.x4.x4/a_27_47# VGND 0.21672f
C8379 dc_inst.x7.net15 VGND 0.19671f
C8380 dc_inst.x7.x15/a_27_47# VGND 0.20386f
C8381 clk VGND 1.82173f
C8382 clkbuf_0_clk/a_110_47# VGND 1.71828f
C8383 dc_inst.x7.x3/a_27_47# VGND 0.24161f
C8384 tdo VGND 2.31003f
C8385 _00_ VGND 0.27905f
C8386 _25_/a_651_413# VGND 0.00469f
C8387 _25_/a_448_47# VGND 0.0139f
C8388 _25_/a_1108_47# VGND 0.13523f
C8389 _25_/a_1283_21# VGND 0.37845f
C8390 _25_/a_543_47# VGND 0.15789f
C8391 _25_/a_761_289# VGND 0.12073f
C8392 _25_/a_193_47# VGND 0.27412f
C8393 _25_/a_27_47# VGND 0.49504f
C8394 dc_inst.x1.net4 VGND 0.24546f
C8395 dc_inst.x1.x4/a_27_47# VGND 0.19744f
C8396 dc_inst.x4.x17/a_27_47# VGND 0.20773f
C8397 dc_inst.x4.net4 VGND 0.28673f
C8398 dc_inst.x4.x3/a_27_47# VGND 0.23866f
C8399 dc_inst.x7.net14 VGND 0.36509f
C8400 dc_inst.x7.x14/a_27_47# VGND 0.22627f
C8401 dc_inst.x7.net3 VGND 0.58813f
C8402 dc_inst.x7.x2/a_27_47# VGND 0.19276f
C8403 dc_inst.x1.net19 VGND 0.30043f
C8404 dc_inst.x1.net18 VGND 0.4907f
C8405 dc_inst.x1.x19/a_27_47# VGND 0.20585f
C8406 dc_inst.x1.x3/a_27_47# VGND 0.20423f
C8407 dc_inst.x4.net16 VGND 0.26883f
C8408 dc_inst.x4.x16/a_27_47# VGND 0.19355f
C8409 dc_inst.x4.net3 VGND 0.21365f
C8410 dc_inst.x4.net2 VGND 0.44093f
C8411 dc_inst.x4.x2/a_27_47# VGND 0.20503f
C8412 dc_inst.x7.net13 VGND 0.33414f
C8413 dc_inst.x7.net12 VGND 0.37768f
C8414 dc_inst.x7.x13/a_27_47# VGND 0.20716f
C8415 dc_inst.x7.net2 VGND 0.60666f
C8416 dc_inst.net6 VGND 0.45945f
C8417 dc_inst.x7.x1/a_27_47# VGND 0.20362f
C8418 VPWR VGND 70.59151f
C8419 dc_inst.x1.net3 VGND 0.31061f
C8420 dc_inst.x1.net2 VGND 0.54956f
C8421 dc_inst.x1.x2/a_27_47# VGND 0.20583f
C8422 dc_inst.x4.net15 VGND 0.12463f
C8423 dc_inst.x4.net14 VGND 0.42455f
C8424 dc_inst.x4.x15/a_27_47# VGND 0.20102f
C8425 dc_inst.x1.x18/a_27_47# VGND 0.23251f
C8426 dc_inst.net3 VGND 0.31503f
C8427 dc_inst.x4.x1/a_27_47# VGND 0.22074f
C8428 dc_inst.x7.net11 VGND 0.26168f
C8429 dc_inst.x7.x12/a_27_47# VGND 0.22667f
C8430 clkload0/X VGND 0.0666f
C8431 clkload0/a_27_47# VGND 0.55937f
C8432 dc_inst.x1.net17 VGND 0.36389f
C8433 dc_inst.x1.net16 VGND 0.49263f
C8434 dc_inst.x1.x17/a_27_47# VGND 0.24139f
C8435 dc_inst.in VGND 1.58291f
C8436 dc_inst.x1.x1/a_27_47# VGND 0.22927f
C8437 dc_inst.x4.x14/a_27_47# VGND 0.2424f
C8438 dc_inst.x7.x11/a_27_47# VGND 0.22826f
C8439 dc_inst.x4.net13 VGND 0.2101f
C8440 dc_inst.x4.net12 VGND 0.22214f
C8441 dc_inst.x4.x13/a_27_47# VGND 0.20382f
C8442 dc_inst.x1.net15 VGND 0.2302f
C8443 dc_inst.x1.x16/a_27_47# VGND 0.20715f
C8444 dc_inst.x7.net1 VGND 0.51083f
C8445 dc_inst.x7.x10/a_27_47# VGND 0.20159f
C8446 dc_inst.x1.x15/a_27_47# VGND 0.20214f
C8447 dc_inst.x4.x12/a_27_47# VGND 0.2068f
C8448 dc_inst.x7.x20/a_27_47# VGND 0.23968f
C8449 dc_inst.x6.net10 VGND 0.15774f
C8450 dc_inst.x6.x9/a_27_47# VGND 0.20737f
C8451 dc_inst.x4.net11 VGND 0.16236f
C8452 dc_inst.x4.x11/a_27_47# VGND 0.20686f
C8453 dc_inst.x1.net14 VGND 0.14545f
C8454 dc_inst.x1.net13 VGND 0.22871f
C8455 dc_inst.x1.x14/a_27_47# VGND 0.20668f
C8456 dc_inst.x3.x9/a_27_47# VGND 0.2114f
C8457 dc_inst.x6.net9 VGND 0.15374f
C8458 dc_inst.x6.x8/a_27_47# VGND 0.20715f
C8459 dc_inst.x1.x13/a_27_47# VGND 0.2069f
C8460 dc_inst.x4.net1 VGND 0.15396f
C8461 dc_inst.x4.x10/a_27_47# VGND 0.20385f
.ends
